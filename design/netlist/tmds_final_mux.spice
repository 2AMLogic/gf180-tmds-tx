** sch_path: /home/ubuntu/GitHub/gf180-tmds-tx/.loom/worktrees/issue-159/design/tmds_final_mux.sch
**.subckt tmds_final_mux OUTP OUTN D0P D0N D1P D1N CLKP CLKN VDD VSS
*.opin OUTP
*.opin OUTN
*.ipin D0P
*.ipin D0N
*.ipin D1P
*.ipin D1N
*.ipin CLKP
*.ipin CLKN
*.iopin VDD
*.iopin VSS
XRC TOP VDD VSS ppolyf_u r_width=20u r_length=2.65u m=1
XRLP OUTP TOP VSS ppolyf_u r_width=20u r_length=5.66u m=1
XRLN OUTN TOP VSS ppolyf_u r_width=20u r_length=5.66u m=1
XRREF IBIAS VDD VSS ppolyf_u r_width=2u r_length=24.8u m=1
XMU0P OUTP D0P SA VSS nfet_03v3 L=0.28u W=128u nf=64 ad=11.52p as=11.88p pd=139.52u ps=143.88u nrd=1.40625m nrs=1.40625m sa=0 sb=0
+ sd=0 m=1
XMU0N OUTN D0N SA VSS nfet_03v3 L=0.28u W=128u nf=64 ad=11.52p as=11.88p pd=139.52u ps=143.88u nrd=1.40625m nrs=1.40625m sa=0 sb=0
+ sd=0 m=1
XMU1P OUTP D1P SB VSS nfet_03v3 L=0.28u W=128u nf=64 ad=11.52p as=11.88p pd=139.52u ps=143.88u nrd=1.40625m nrs=1.40625m sa=0 sb=0
+ sd=0 m=1
XMU1N OUTN D1N SB VSS nfet_03v3 L=0.28u W=128u nf=64 ad=11.52p as=11.88p pd=139.52u ps=143.88u nrd=1.40625m nrs=1.40625m sa=0 sb=0
+ sd=0 m=1
XMCP SA CLKP TAIL VSS nfet_03v3 L=0.28u W=192u nf=96 ad=17.28p as=17.64p pd=209.28u ps=213.64u nrd=0.9375m nrs=0.9375m sa=0 sb=0
+ sd=0 m=1
XMCN SB CLKN TAIL VSS nfet_03v3 L=0.28u W=192u nf=96 ad=17.28p as=17.64p pd=209.28u ps=213.64u nrd=0.9375m nrs=0.9375m sa=0 sb=0
+ sd=0 m=1
XMT TAIL IBIAS VSS VSS nfet_03v3 L=0.5u W=20u nf=10 ad=1.8p as=2.16p pd=21.8u ps=26.16u nrd=9m nrs=9m sa=0 sb=0 sd=0 m=20
XMB IBIAS IBIAS VSS VSS nfet_03v3 L=0.5u W=20u nf=10 ad=1.8p as=2.16p pd=21.8u ps=26.16u nrd=9m nrs=9m sa=0 sb=0 sd=0 m=1
**.ends
.end
