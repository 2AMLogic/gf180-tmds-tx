* Frozen netlist snapshot for record 20260815-072956-34e5253
* source     : sim/cml-driver-eye/testbench/cml_driver_eye.spice
* sha256     : d198d115e83d9c9189ae73b5c27cadf607e6e1fe7fef68a3109516c742da6c51
* This is a verbatim copy taken at record time. Do not edit.
* cml-driver-eye -- one lane of the CML output driver against the DR-0002 load
*
* Netlist FRAGMENT. The harness supplies the title, the .include of the
* gf180mcu models, the corner .lib sections, .temp, the .include of the DUT
* (design/netlist/cml_driver.spice, named by tb.json's "dut" key), the
* .control block (analyses + measurements) and .end. Parameters provided by
* the harness (sim/harness/README.md): vdd_val/vdd_nom, temp_c and -- because
* this testbench's manifest declares a `rates_mbps` axis -- rate_val
* (Mbps/lane for this grid point).
*
* ---------------------------------------------------------------------------
* WHICH RAIL THE MANDATED +/-10 % SUPPLY AXIS IS APPLIED TO
* ---------------------------------------------------------------------------
* The driver is open-drain (DR-0002): it has no positive rail of its own. Two
* distinct 3.3 V rails touch this experiment and they are NOT the same rail:
*
*   vdd_val  -- the on-chip 3.3 V core rail this block owns. It powers the
*               DR-0003 custom 2:1 final multiplexer, so it sets the
*               differential input levels this cell is driven from. The
*               harness's mandated +/-10 % supply axis is applied HERE, to
*               the rail this block is responsible for: `vih`/`vil` below
*               are fixed fractions of vdd_val, so a 10 % low rail delivers
*               a 10 % smaller gate drive and the steering margin is
*               genuinely stressed at every corner.
*
*   avcc     -- the RECEIVER's termination rail, in the sink device on the
*               far side of the link, pulled up through the 50 ohm/leg
*               termination (DR-0002). It is a different power domain in a
*               different device; it is held at its nominal 3.3 V for the
*               DR-0002 swing/common-mode rows, because DR-0002's 2.8-3.3 V
*               common-mode window is an ABSOLUTE window and the output
*               common mode tracks avcc 1:1 by construction
*               (vcm = avcc - I_tail*R/2). Two extra copies below (`_vlo`,
*               `_vhi`) run the same driver at avcc -10 %/+10 % so that
*               sensitivity is measured and reported rather than assumed --
*               see the record and design/cml-driver-sizing.md. The `_vhi`
*               copy is also where worst-case device stress is measured,
*               since the highest termination rail is the worst case for
*               Vds/Vgd on the switching devices.
*
* ---------------------------------------------------------------------------
* INPUT MODEL (an assumption this cell's results are conditional on)
* ---------------------------------------------------------------------------
* The DR-0003 custom 2:1 final multiplexer is a separate cell and a follow-on
* issue. It is modelled here as an ideal differential source with:
*
*   - single-ended levels vih = 0.85*vdd_val, vil = 0.55*vdd_val
*     (2.805 V / 1.815 V at the nominal rail), i.e. a single-ended swing of
*     0.30*vdd_val ~ 1.0 V p-p and a common mode of 0.70*vdd_val ~ 2.31 V,
*     scaling with its own supply as a resistively-loaded 3.3 V-domain stage
*     does;
*   - a 80 ps linear edge (the ramp between those levels), at BOTH bit rates
*     -- the multiplexer is designed for the 742.5 Mbps target and is not
*     assumed to slow down at the 270 Mbps fallback;
*   - zero source impedance and zero jitter, so every picosecond of jitter
*     measured at the output is contributed by this stage.
*
* design/cml-driver-sizing.md states this as a requirement levied on the
* multiplexer, with the margin behind each number.
*
* ---------------------------------------------------------------------------
* STIMULUS (sim/README.md's stimulus convention)
* ---------------------------------------------------------------------------
* `mixed-run-length-16b`: a 16-bit repeating pattern, MSB first at t = 0,
*
*     1 1 1 1 1 1 1 1 1 0 1 0 1 0 1 0
*
* i.e. a nine-bit run followed by maximum-transition-density alternation.
* The alternating section is the worst-case ISI stimulus a DC-balanced
* 8b/10b-style code can present (sim/README.md's `worst-case-101010`); the
* nine-bit run in front of it adds the low-transition-density history that
* makes data-dependent jitter measurable at all -- the first edge after the
* run leaves a fully settled level, every edge in the alternating section
* does not. Pattern-dependent edge displacement between those two cases is
* exactly the deterministic jitter this stage contributes, and it is why this
* testbench does not use a plain square wave. (sim/README.md also names a
* `prbs7` option; a 127-bit PRBS needs ~127 UI of transient per rate and
* buys nothing here, because with an ideal jitter-free input the jitter this
* stage adds is deterministic -- ISI plus rise/fall asymmetry -- and both are
* excited by the pattern above. Random jitter is not a transient-simulation
* quantity at all; see the record's caveat.)
*
* Every transition ramps over `tedge` starting at an exact multiple of the
* bit period, so the input's own differential zero crossings sit on the ideal
* bit grid. The measurement references the OUTPUT crossings against the
* INPUT crossings of the same edge index, so the ideal grid never has to be
* reconstructed from a formula.

.param tbit_s   = '1e-6/rate_val'
.param avcc_nom = 3.3
.param rterm    = 50
.param iref     = 500u
.param vih      = '0.85*vdd_val'
.param vil      = '0.55*vdd_val'
.param tedge    = 80p

* Measurement windows. Both cover bits 10..15 of the first pattern period --
* the steady-state maximum-transition-density section only. Both deliberately
* exclude the nine-bit run, where the output settles all the way to its DC
* levels: a window containing that run would report the DC swing and flatter
* every bandwidth-limited corner.
*
*   win  -- the whole alternating section. Used for peak-to-peak excursion
*           (vpp_*) and for device stress, where the transition instants must
*           NOT be excluded: gate-drain feedthrough during an edge pushes the
*           drain slightly past its settled level, and that excursion is part
*           of the stress the device actually sees.
*   winc -- a comb, high only over the central 40 % of each bit (0.3..0.7 UI).
*           Used for the DR-0002 swing and common-mode rows: those are levels
*           a receiver slices, so they are measured in the sampling window,
*           not at the peak of a switching spike.
.param twin_a = '10.2*tbit_s'
.param twin_b = '15.8*tbit_s'

* Static output level forced on the conducting leg of the two `_za`/`_zb`
* copies, for the two-point output-resistance extraction below.
.param vz_a = 2.60
.param vz_b = 3.00

* ---- rails ---------------------------------------------------------------
vavcc   avcc   0 dc {avcc_nom}
vavcclo avcclo 0 dc '0.9*avcc_nom'
vavcchi avcchi 0 dc '1.1*avcc_nom'

* ---- stimulus ------------------------------------------------------------
vinp inp 0 PWL(0 '{vih}'
+ '{9*tbit_s}'  '{vih}' '{9*tbit_s+tedge}'  '{vil}'
+ '{10*tbit_s}' '{vil}' '{10*tbit_s+tedge}' '{vih}'
+ '{11*tbit_s}' '{vih}' '{11*tbit_s+tedge}' '{vil}'
+ '{12*tbit_s}' '{vil}' '{12*tbit_s+tedge}' '{vih}'
+ '{13*tbit_s}' '{vih}' '{13*tbit_s+tedge}' '{vil}'
+ '{14*tbit_s}' '{vil}' '{14*tbit_s+tedge}' '{vih}'
+ '{15*tbit_s}' '{vih}' '{15*tbit_s+tedge}' '{vil}'
+ '{16*tbit_s-tedge}' '{vil}' '{16*tbit_s}' '{vih}'
+ r=0 td=0)
vinn inn 0 PWL(0 '{vil}'
+ '{9*tbit_s}'  '{vil}' '{9*tbit_s+tedge}'  '{vih}'
+ '{10*tbit_s}' '{vih}' '{10*tbit_s+tedge}' '{vil}'
+ '{11*tbit_s}' '{vil}' '{11*tbit_s+tedge}' '{vih}'
+ '{12*tbit_s}' '{vih}' '{12*tbit_s+tedge}' '{vil}'
+ '{13*tbit_s}' '{vil}' '{13*tbit_s+tedge}' '{vih}'
+ '{14*tbit_s}' '{vih}' '{14*tbit_s+tedge}' '{vil}'
+ '{15*tbit_s}' '{vil}' '{15*tbit_s+tedge}' '{vih}'
+ '{16*tbit_s-tedge}' '{vih}' '{16*tbit_s}' '{vil}'
+ r=0 td=0)

* Static input levels for the DC copies (`_z`, `_za`, `_zb`): permanently
* steered to the INP side, so the conducting device is the one on OUTP.
vinpz inpz 0 dc '{vih}'
vinnz innz 0 dc '{vil}'

* Differential input probe. ngspice's two-terminal v(a,b) probe syntax parses
* in print/let but NOT inside a `meas` TRIG/TARG expression (confirmed
* against ngspice-46 while developing sim/smoke-cml-pair); a 1x VCVS onto a
* real node is the documented workaround, not a design element. This node is
* the ideal-bit-grid reference every jitter measurement is taken against.
einref inref 0 inp inn 1

* Measurement-window gates: 0 outside the window, 1 inside. These exist so a
* `vecmax`/`vecmin` level measurement can be windowed from inside a control
* block, which has no access to the (rate-dependent) `.param` bounds.
vwin win 0 PWL(0 0 '{twin_a}' 0 '{twin_a+1p}' 1 '{twin_b}' 1 '{twin_b+1p}' 0)
vwinc winc 0 PWL(0 0
+ '{10.3*tbit_s}' 0 '{10.3*tbit_s+1p}' 1 '{10.7*tbit_s}' 1 '{10.7*tbit_s+1p}' 0
+ '{11.3*tbit_s}' 0 '{11.3*tbit_s+1p}' 1 '{11.7*tbit_s}' 1 '{11.7*tbit_s+1p}' 0
+ '{12.3*tbit_s}' 0 '{12.3*tbit_s+1p}' 1 '{12.7*tbit_s}' 1 '{12.7*tbit_s+1p}' 0
+ '{13.3*tbit_s}' 0 '{13.3*tbit_s+1p}' 1 '{13.7*tbit_s}' 1 '{13.7*tbit_s+1p}' 0
+ '{14.3*tbit_s}' 0 '{14.3*tbit_s+1p}' 1 '{14.7*tbit_s}' 1 '{14.7*tbit_s+1p}' 0
+ '{15.3*tbit_s}' 0 '{15.3*tbit_s+1p}' 1 '{15.7*tbit_s}' 1 '{15.7*tbit_s+1p}' 0)

* ---------------------------------------------------------------------------
* Driver copies. Every copy is the SAME cml_driver cell
* (design/netlist/cml_driver.spice) with the same ideal 500 uA bias
* reference; they differ only in pad capacitance and termination rail, so a
* difference between two copies in one log is a difference caused by that
* load, measured at the identical PVT point.
*
* Pad capacitance is swept in-deck rather than as a harness axis so that all
* three loads are measured at the identical corner, temperature, supply and
* bit rate in one ngspice invocation. `_c0` carries no explicit pad
* capacitance at all (the "0 pF" point is the cell's own drain parasitics
* against the 50 ohm termination); `_c1`/`_c2` add DR-0005's 1 pF and its
* full 2 pF budget.
* ---------------------------------------------------------------------------

* ---- 0 pF pad ------------------------------------------------------------
xc0 outp_c0 outn_c0 inp inn ib_c0 0 cml_driver
ib_c0src 0 ib_c0 dc {iref}
rp_c0 avcc outp_c0 {rterm}
rn_c0 avcc outn_c0 {rterm}
ediff_c0 vd_c0 0 outn_c0 outp_c0 1

* ---- 1 pF pad ------------------------------------------------------------
xc1 outp_c1 outn_c1 inp inn ib_c1 0 cml_driver
ib_c1src 0 ib_c1 dc {iref}
rp_c1 avcc outp_c1 {rterm}
rn_c1 avcc outn_c1 {rterm}
cp_c1 outp_c1 0 1p
cn_c1 outn_c1 0 1p
ediff_c1 vd_c1 0 outn_c1 outp_c1 1

* ---- 2 pF pad (DR-0005's full budget) ------------------------------------
xc2 outp_c2 outn_c2 inp inn ib_c2 0 cml_driver
ib_c2src 0 ib_c2 dc {iref}
rp_c2 avcc outp_c2 {rterm}
rn_c2 avcc outn_c2 {rterm}
cp_c2 outp_c2 0 2p
cn_c2 outn_c2 0 2p
ediff_c2 vd_c2 0 outn_c2 outp_c2 1

* ---- leg-to-leg pad mismatch: 2 pF on OUTP, 1 pF on OUTN -----------------
* Jitter sensitivity probe, not a nominal configuration. With perfectly
* matched legs a differential pair's finite bandwidth cancels at the
* differential zero crossing -- the two legs' ISI is antisymmetric -- so a
* matched-load jitter number says nothing about how much load MISMATCH the
* pad/ESD structure may have. This copy carries a deliberate 1 pF (i.e. 50 %
* of DR-0005's whole budget) leg-to-leg imbalance so the sensitivity
* d(jitter)/d(pad mismatch) is measured rather than assumed, and so the
* pad-ring work has a matching requirement to design to.
xcmis outp_cmis outn_cmis inp inn ib_cmis 0 cml_driver
ib_cmissrc 0 ib_cmis dc {iref}
rp_cmis avcc outp_cmis {rterm}
rn_cmis avcc outn_cmis {rterm}
cp_cmis outp_cmis 0 2p
cn_cmis outn_cmis 0 1p
ediff_cmis vd_cmis 0 outn_cmis outp_cmis 1

* ---- termination-rail sensitivity: avcc -10 %, 1 pF pad ------------------
xvlo outp_vlo outn_vlo inp inn ib_vlo 0 cml_driver
ib_vlosrc 0 ib_vlo dc {iref}
rp_vlo avcclo outp_vlo {rterm}
rn_vlo avcclo outn_vlo {rterm}
cp_vlo outp_vlo 0 1p
cn_vlo outn_vlo 0 1p

* ---- termination-rail sensitivity: avcc +10 %, 1 pF pad ------------------
* Also the worst-case device-stress copy: the highest termination rail is the
* highest drain voltage the switching devices ever see.
xvhi outp_vhi outn_vhi inp inn ib_vhi 0 cml_driver
ib_vhisrc 0 ib_vhi dc {iref}
rp_vhi avcchi outp_vhi {rterm}
rn_vhi avcchi outn_vhi {rterm}
cp_vhi outp_vhi 0 1p
cn_vhi outn_vhi 0 1p

* ---- static copy: DC swing, steering completeness, supply draw -----------
* `vsens_z` is a 0 V source used as an ammeter in the cell's ground return,
* so the whole-cell (= tail) current is a real branch current.
xz outp_z outn_z inpz innz ib_z vss_z cml_driver
ib_zsrc 0 ib_z dc {iref}
vsens_z vss_z 0 dc 0
rp_z avcc outp_z {rterm}
rn_z avcc outn_z {rterm}

* ---- static copies for the output-resistance extraction ------------------
* The conducting leg's drain is forced to two voltages inside the output's
* own operating range; the single-ended output resistance looking back into
* that leg is dV/dI between the two. Extracting it from the 50 ohm-loaded
* copies instead would mean resolving a ~0.05 % change in a 50 ohm parallel
* combination, which is not a measurement.
xza outp_za outn_za inpz innz ib_za 0 cml_driver
ib_zasrc 0 ib_za dc {iref}
vforce_za outp_za 0 dc {vz_a}
rn_za avcc outn_za {rterm}

xzb outp_zb outn_zb inpz innz ib_zb 0 cml_driver
ib_zbsrc 0 ib_zb dc {iref}
vforce_zb outp_zb 0 dc {vz_b}
rn_zb avcc outn_zb {rterm}

* ---------------------------------------------------------------
* DUT netlist included by this testbench (extracted)
* source     : layout/sim/cml_driver_core_dut.spice
* sha256     : 0fe2d39d5f6ba28d1181c27d7b390e601a616ac2da9a203e732751d7183f80c3
* ---------------------------------------------------------------

* cml_driver_core_dut.spice -- post-layout DUT fragment for sim/cml-driver-eye
*
* GENERATED by layout/scripts/gen_cml_driver_core_dut.py -- do not edit.
* source        : layout/gds/cml_driver_core.spice
* source sha256 : 1a9ec9ed657ed941c308842e789586c3f80c1efbd30161990545efdd2b9783af
* devices       : 338 extracted per-finger nfet devices, bound to nfet_03v3
*
* Three mechanical translations, all documented in the generator's header:
*   1. device class 'nfet' -> PDK subcircuit 'nfet_03v3' (M-card -> X-card),
*      carrying the extracted AS/AD/PS/PD junction geometry through unchanged;
*   2. the deck-synthesized body net 'vsubs' tied to VSS in the wrapper below
*      (NMOS-only cell in the common p-substrate -- the sized schematic's own
*      B=VSS; see design/cml-driver-sizing.md section 0);
*   3. a wrapper presenting the schematic cell boundary (cml_driver OUTP OUTN INP INN IBIAS VSS),
*      so sim/cml-driver-eye's testbench runs unchanged against either netlist.
*
* NOT modelled here (state this in any record taken against this netlist):
*   - no parasitic RC: the source extraction is schematic-equivalent
*     (devices + connectivity); klt extract --parasitics was not used;
*   - no NRD/NRS: the extraction carries no diffusion sheet counts, so
*     nfet_03v3's defaults (0) apply, unlike the schematic DUT.

.subckt cml_driver OUTP OUTN INP INN IBIAS VSS
* cml_driver_core pin order is the extraction's own (alphabetical, plus the
* promoted internal node TAIL and the body net vsubs).
xcore IBIAS INN INP OUTN OUTP TAIL VSS VSS cml_driver_core
.ends

* extracted by klt extract --deck gf180mcu
* cell cml_driver_core
* pin IBIAS
* pin INN
* pin INP
* pin OUTN
* pin OUTP
* pin TAIL
* pin VSS
* pin vsubs
.SUBCKT cml_driver_core IBIAS INN INP OUTN OUTP TAIL VSS vsubs
* device instance $1 r0 *1 92.67,1.82 nfet
XM$1 TAIL IBIAS VSS vsubs nfet_03v3 L=0.5U W=2U AS=0.42P AD=0.42P PS=2.42U PD=2.42U
* device instance $2 r0 *1 93.59,1.82 nfet
XM$2 VSS IBIAS TAIL vsubs nfet_03v3 L=0.5U W=2U AS=0.42P AD=0.42P PS=2.42U PD=2.42U
* device instance $3 r0 *1 94.51,1.82 nfet
XM$3 TAIL IBIAS VSS vsubs nfet_03v3 L=0.5U W=2U AS=0.42P AD=0.42P PS=2.42U PD=2.42U
* device instance $4 r0 *1 95.43,1.82 nfet
XM$4 VSS IBIAS TAIL vsubs nfet_03v3 L=0.5U W=2U AS=0.42P AD=0.42P PS=2.42U PD=2.42U
* device instance $5 r0 *1 96.35,1.82 nfet
XM$5 TAIL IBIAS VSS vsubs nfet_03v3 L=0.5U W=2U AS=0.42P AD=0.42P PS=2.42U PD=2.42U
* device instance $6 r0 *1 97.27,1.82 nfet
XM$6 VSS IBIAS TAIL vsubs nfet_03v3 L=0.5U W=2U AS=0.42P AD=0.42P PS=2.42U PD=2.42U
* device instance $7 r0 *1 98.19,1.82 nfet
XM$7 TAIL IBIAS VSS vsubs nfet_03v3 L=0.5U W=2U AS=0.42P AD=0.42P PS=2.42U PD=2.42U
* device instance $8 r0 *1 99.11,1.82 nfet
XM$8 VSS IBIAS TAIL vsubs nfet_03v3 L=0.5U W=2U AS=0.42P AD=0.42P PS=2.42U PD=2.42U
* device instance $9 r0 *1 100.03,1.82 nfet
XM$9 TAIL IBIAS VSS vsubs nfet_03v3 L=0.5U W=2U AS=0.42P AD=0.42P PS=2.42U PD=2.42U
* device instance $10 r0 *1 100.95,1.82 nfet
XM$10 VSS IBIAS TAIL vsubs nfet_03v3 L=0.5U W=2U AS=0.42P AD=0.42P PS=2.42U PD=2.42U
* device instance $11 r0 *1 101.87,1.82 nfet
XM$11 TAIL IBIAS VSS vsubs nfet_03v3 L=0.5U W=2U AS=0.42P AD=0.42P PS=2.42U PD=2.42U
* device instance $12 r0 *1 102.79,1.82 nfet
XM$12 VSS IBIAS TAIL vsubs nfet_03v3 L=0.5U W=2U AS=0.42P AD=0.42P PS=2.42U PD=2.42U
* device instance $13 r0 *1 103.71,1.82 nfet
XM$13 TAIL IBIAS VSS vsubs nfet_03v3 L=0.5U W=2U AS=0.42P AD=0.42P PS=2.42U PD=2.42U
* device instance $14 r0 *1 104.63,1.82 nfet
XM$14 VSS IBIAS TAIL vsubs nfet_03v3 L=0.5U W=2U AS=0.42P AD=0.42P PS=2.42U PD=2.42U
* device instance $15 r0 *1 105.55,1.82 nfet
XM$15 TAIL IBIAS VSS vsubs nfet_03v3 L=0.5U W=2U AS=0.42P AD=0.42P PS=2.42U PD=2.42U
* device instance $16 r0 *1 106.47,1.82 nfet
XM$16 VSS IBIAS TAIL vsubs nfet_03v3 L=0.5U W=2U AS=0.42P AD=0.42P PS=2.42U PD=2.42U
* device instance $17 r0 *1 107.39,1.82 nfet
XM$17 TAIL IBIAS VSS vsubs nfet_03v3 L=0.5U W=2U AS=0.42P AD=0.42P PS=2.42U PD=2.42U
* device instance $18 r0 *1 108.31,1.82 nfet
XM$18 VSS IBIAS TAIL vsubs nfet_03v3 L=0.5U W=2U AS=0.42P AD=0.42P PS=2.42U PD=2.42U
* device instance $19 r0 *1 109.23,1.82 nfet
XM$19 TAIL IBIAS VSS vsubs nfet_03v3 L=0.5U W=2U AS=0.42P AD=0.42P PS=2.42U PD=2.42U
* device instance $20 r0 *1 110.15,1.82 nfet
XM$20 VSS IBIAS TAIL vsubs nfet_03v3 L=0.5U W=2U AS=0.42P AD=0.42P PS=2.42U PD=2.42U
* device instance $21 r0 *1 111.07,1.82 nfet
XM$21 TAIL IBIAS VSS vsubs nfet_03v3 L=0.5U W=2U AS=0.42P AD=0.42P PS=2.42U PD=2.42U
* device instance $22 r0 *1 111.99,1.82 nfet
XM$22 VSS IBIAS TAIL vsubs nfet_03v3 L=0.5U W=2U AS=0.42P AD=0.42P PS=2.42U PD=2.42U
* device instance $23 r0 *1 112.91,1.82 nfet
XM$23 TAIL IBIAS VSS vsubs nfet_03v3 L=0.5U W=2U AS=0.42P AD=0.42P PS=2.42U PD=2.42U
* device instance $24 r0 *1 113.83,1.82 nfet
XM$24 VSS IBIAS TAIL vsubs nfet_03v3 L=0.5U W=2U AS=0.42P AD=0.42P PS=2.42U PD=2.42U
* device instance $25 r0 *1 114.75,1.82 nfet
XM$25 TAIL IBIAS VSS vsubs nfet_03v3 L=0.5U W=2U AS=0.42P AD=0.42P PS=2.42U PD=2.42U
* device instance $26 r0 *1 115.67,1.82 nfet
XM$26 VSS IBIAS TAIL vsubs nfet_03v3 L=0.5U W=2U AS=0.42P AD=0.42P PS=2.42U PD=2.42U
* device instance $27 r0 *1 116.59,1.82 nfet
XM$27 TAIL IBIAS VSS vsubs nfet_03v3 L=0.5U W=2U AS=0.42P AD=0.42P PS=2.42U PD=2.42U
* device instance $28 r0 *1 117.51,1.82 nfet
XM$28 VSS IBIAS TAIL vsubs nfet_03v3 L=0.5U W=2U AS=0.42P AD=0.42P PS=2.42U PD=2.42U
* device instance $29 r0 *1 118.43,1.82 nfet
XM$29 TAIL IBIAS VSS vsubs nfet_03v3 L=0.5U W=2U AS=0.42P AD=0.42P PS=2.42U PD=2.42U
* device instance $30 r0 *1 119.35,1.82 nfet
XM$30 VSS IBIAS TAIL vsubs nfet_03v3 L=0.5U W=2U AS=0.42P AD=0.42P PS=2.42U PD=2.42U
* device instance $31 r0 *1 120.27,1.82 nfet
XM$31 TAIL IBIAS VSS vsubs nfet_03v3 L=0.5U W=2U AS=0.42P AD=0.42P PS=2.42U PD=2.42U
* device instance $32 r0 *1 121.19,1.82 nfet
XM$32 VSS IBIAS TAIL vsubs nfet_03v3 L=0.5U W=2U AS=0.42P AD=0.42P PS=2.42U PD=2.42U
* device instance $33 r0 *1 122.11,1.82 nfet
XM$33 TAIL IBIAS VSS vsubs nfet_03v3 L=0.5U W=2U AS=0.42P AD=0.42P PS=2.42U PD=2.42U
* device instance $34 r0 *1 123.03,1.82 nfet
XM$34 VSS IBIAS TAIL vsubs nfet_03v3 L=0.5U W=2U AS=0.42P AD=0.42P PS=2.42U PD=2.42U
* device instance $35 r0 *1 123.95,1.82 nfet
XM$35 TAIL IBIAS VSS vsubs nfet_03v3 L=0.5U W=2U AS=0.42P AD=0.42P PS=2.42U PD=2.42U
* device instance $36 r0 *1 124.87,1.82 nfet
XM$36 VSS IBIAS TAIL vsubs nfet_03v3 L=0.5U W=2U AS=0.42P AD=0.42P PS=2.42U PD=2.42U
* device instance $37 r0 *1 125.79,1.82 nfet
XM$37 TAIL IBIAS VSS vsubs nfet_03v3 L=0.5U W=2U AS=0.42P AD=0.42P PS=2.42U PD=2.42U
* device instance $38 r0 *1 126.71,1.82 nfet
XM$38 VSS IBIAS TAIL vsubs nfet_03v3 L=0.5U W=2U AS=0.42P AD=0.42P PS=2.42U PD=2.42U
* device instance $39 r0 *1 127.63,1.82 nfet
XM$39 TAIL IBIAS VSS vsubs nfet_03v3 L=0.5U W=2U AS=0.42P AD=0.42P PS=2.42U PD=2.42U
* device instance $40 r0 *1 128.55,1.82 nfet
XM$40 VSS IBIAS TAIL vsubs nfet_03v3 L=0.5U W=2U AS=0.42P AD=0.42P PS=2.42U PD=2.42U
* device instance $41 r0 *1 129.47,1.82 nfet
XM$41 TAIL IBIAS VSS vsubs nfet_03v3 L=0.5U W=2U AS=0.42P AD=0.42P PS=2.42U PD=2.42U
* device instance $42 r0 *1 130.39,1.82 nfet
XM$42 VSS IBIAS TAIL vsubs nfet_03v3 L=0.5U W=2U AS=0.42P AD=0.42P PS=2.42U PD=2.42U
* device instance $43 r0 *1 131.31,1.82 nfet
XM$43 TAIL IBIAS VSS vsubs nfet_03v3 L=0.5U W=2U AS=0.42P AD=0.42P PS=2.42U PD=2.42U
* device instance $44 r0 *1 132.23,1.82 nfet
XM$44 VSS IBIAS TAIL vsubs nfet_03v3 L=0.5U W=2U AS=0.42P AD=0.42P PS=2.42U PD=2.42U
* device instance $45 r0 *1 133.15,1.82 nfet
XM$45 TAIL IBIAS VSS vsubs nfet_03v3 L=0.5U W=2U AS=0.42P AD=0.42P PS=2.42U PD=2.42U
* device instance $46 r0 *1 134.07,1.82 nfet
XM$46 VSS IBIAS TAIL vsubs nfet_03v3 L=0.5U W=2U AS=0.42P AD=0.42P PS=2.42U PD=2.42U
* device instance $47 r0 *1 134.99,1.82 nfet
XM$47 TAIL IBIAS VSS vsubs nfet_03v3 L=0.5U W=2U AS=0.42P AD=0.42P PS=2.42U PD=2.42U
* device instance $48 r0 *1 135.91,1.82 nfet
XM$48 VSS IBIAS TAIL vsubs nfet_03v3 L=0.5U W=2U AS=0.42P AD=0.42P PS=2.42U PD=2.42U
* device instance $49 r0 *1 136.83,1.82 nfet
XM$49 TAIL IBIAS VSS vsubs nfet_03v3 L=0.5U W=2U AS=0.42P AD=0.42P PS=2.42U PD=2.42U
* device instance $50 r0 *1 137.75,1.82 nfet
XM$50 VSS IBIAS TAIL vsubs nfet_03v3 L=0.5U W=2U AS=0.42P AD=0.42P PS=2.42U PD=2.42U
* device instance $51 r0 *1 138.67,1.82 nfet
XM$51 TAIL IBIAS VSS vsubs nfet_03v3 L=0.5U W=2U AS=0.42P AD=0.42P PS=2.42U PD=2.42U
* device instance $52 r0 *1 139.59,1.82 nfet
XM$52 VSS IBIAS TAIL vsubs nfet_03v3 L=0.5U W=2U AS=0.42P AD=0.42P PS=2.42U PD=2.42U
* device instance $53 r0 *1 140.51,1.82 nfet
XM$53 TAIL IBIAS VSS vsubs nfet_03v3 L=0.5U W=2U AS=0.42P AD=0.42P PS=2.42U PD=2.42U
* device instance $54 r0 *1 141.43,1.82 nfet
XM$54 VSS IBIAS TAIL vsubs nfet_03v3 L=0.5U W=2U AS=0.42P AD=0.42P PS=2.42U PD=2.42U
* device instance $55 r0 *1 142.35,1.82 nfet
XM$55 TAIL IBIAS VSS vsubs nfet_03v3 L=0.5U W=2U AS=0.42P AD=0.42P PS=2.42U PD=2.42U
* device instance $56 r0 *1 143.27,1.82 nfet
XM$56 VSS IBIAS TAIL vsubs nfet_03v3 L=0.5U W=2U AS=0.42P AD=0.42P PS=2.42U PD=2.42U
* device instance $57 r0 *1 144.19,1.82 nfet
XM$57 TAIL IBIAS VSS vsubs nfet_03v3 L=0.5U W=2U AS=0.42P AD=0.42P PS=2.42U PD=2.42U
* device instance $58 r0 *1 145.11,1.82 nfet
XM$58 VSS IBIAS TAIL vsubs nfet_03v3 L=0.5U W=2U AS=0.42P AD=0.42P PS=2.42U PD=2.42U
* device instance $59 r0 *1 146.03,1.82 nfet
XM$59 TAIL IBIAS VSS vsubs nfet_03v3 L=0.5U W=2U AS=0.42P AD=0.42P PS=2.42U PD=2.42U
* device instance $60 r0 *1 146.95,1.82 nfet
XM$60 VSS IBIAS TAIL vsubs nfet_03v3 L=0.5U W=2U AS=0.42P AD=0.42P PS=2.42U PD=2.42U
* device instance $61 r0 *1 147.87,1.82 nfet
XM$61 TAIL IBIAS VSS vsubs nfet_03v3 L=0.5U W=2U AS=0.42P AD=0.42P PS=2.42U PD=2.42U
* device instance $62 r0 *1 148.79,1.82 nfet
XM$62 VSS IBIAS TAIL vsubs nfet_03v3 L=0.5U W=2U AS=0.42P AD=0.42P PS=2.42U PD=2.42U
* device instance $63 r0 *1 149.71,1.82 nfet
XM$63 TAIL IBIAS VSS vsubs nfet_03v3 L=0.5U W=2U AS=0.42P AD=0.42P PS=2.42U PD=2.42U
* device instance $64 r0 *1 150.63,1.82 nfet
XM$64 VSS IBIAS TAIL vsubs nfet_03v3 L=0.5U W=2U AS=0.42P AD=0.42P PS=2.42U PD=2.42U
* device instance $65 r0 *1 151.55,1.82 nfet
XM$65 TAIL IBIAS VSS vsubs nfet_03v3 L=0.5U W=2U AS=0.42P AD=0.42P PS=2.42U PD=2.42U
* device instance $66 r0 *1 152.47,1.82 nfet
XM$66 VSS IBIAS TAIL vsubs nfet_03v3 L=0.5U W=2U AS=0.42P AD=0.42P PS=2.42U PD=2.42U
* device instance $67 r0 *1 153.39,1.82 nfet
XM$67 TAIL IBIAS VSS vsubs nfet_03v3 L=0.5U W=2U AS=0.42P AD=0.42P PS=2.42U PD=2.42U
* device instance $68 r0 *1 154.31,1.82 nfet
XM$68 VSS IBIAS TAIL vsubs nfet_03v3 L=0.5U W=2U AS=0.42P AD=0.42P PS=2.42U PD=2.42U
* device instance $69 r0 *1 155.23,1.82 nfet
XM$69 TAIL IBIAS VSS vsubs nfet_03v3 L=0.5U W=2U AS=0.42P AD=0.42P PS=2.42U PD=2.42U
* device instance $70 r0 *1 156.15,1.82 nfet
XM$70 VSS IBIAS TAIL vsubs nfet_03v3 L=0.5U W=2U AS=0.42P AD=0.42P PS=2.42U PD=2.42U
* device instance $71 r0 *1 157.07,1.82 nfet
XM$71 TAIL IBIAS VSS vsubs nfet_03v3 L=0.5U W=2U AS=0.42P AD=0.42P PS=2.42U PD=2.42U
* device instance $72 r0 *1 157.99,1.82 nfet
XM$72 VSS IBIAS TAIL vsubs nfet_03v3 L=0.5U W=2U AS=0.42P AD=0.42P PS=2.42U PD=2.42U
* device instance $73 r0 *1 158.91,1.82 nfet
XM$73 TAIL IBIAS VSS vsubs nfet_03v3 L=0.5U W=2U AS=0.42P AD=0.42P PS=2.42U PD=2.42U
* device instance $74 r0 *1 159.83,1.82 nfet
XM$74 VSS IBIAS TAIL vsubs nfet_03v3 L=0.5U W=2U AS=0.42P AD=0.42P PS=2.42U PD=2.42U
* device instance $75 r0 *1 160.75,1.82 nfet
XM$75 TAIL IBIAS VSS vsubs nfet_03v3 L=0.5U W=2U AS=0.42P AD=0.42P PS=2.42U PD=2.42U
* device instance $76 r0 *1 161.67,1.82 nfet
XM$76 VSS IBIAS TAIL vsubs nfet_03v3 L=0.5U W=2U AS=0.42P AD=0.42P PS=2.42U PD=2.42U
* device instance $77 r0 *1 162.59,1.82 nfet
XM$77 TAIL IBIAS VSS vsubs nfet_03v3 L=0.5U W=2U AS=0.42P AD=0.42P PS=2.42U PD=2.42U
* device instance $78 r0 *1 163.51,1.82 nfet
XM$78 VSS IBIAS TAIL vsubs nfet_03v3 L=0.5U W=2U AS=0.42P AD=0.42P PS=2.42U PD=2.42U
* device instance $79 r0 *1 164.43,1.82 nfet
XM$79 TAIL IBIAS VSS vsubs nfet_03v3 L=0.5U W=2U AS=0.42P AD=0.42P PS=2.42U PD=2.42U
* device instance $80 r0 *1 165.35,1.82 nfet
XM$80 VSS IBIAS TAIL vsubs nfet_03v3 L=0.5U W=2U AS=0.42P AD=0.42P PS=2.42U PD=2.42U
* device instance $81 r0 *1 166.27,1.82 nfet
XM$81 TAIL IBIAS VSS vsubs nfet_03v3 L=0.5U W=2U AS=0.42P AD=0.42P PS=2.42U PD=2.42U
* device instance $82 r0 *1 167.19,1.82 nfet
XM$82 VSS IBIAS TAIL vsubs nfet_03v3 L=0.5U W=2U AS=0.42P AD=0.42P PS=2.42U PD=2.42U
* device instance $83 r0 *1 168.11,1.82 nfet
XM$83 TAIL IBIAS VSS vsubs nfet_03v3 L=0.5U W=2U AS=0.42P AD=0.42P PS=2.42U PD=2.42U
* device instance $84 r0 *1 169.03,1.82 nfet
XM$84 VSS IBIAS TAIL vsubs nfet_03v3 L=0.5U W=2U AS=0.42P AD=0.42P PS=2.42U PD=2.42U
* device instance $85 r0 *1 169.95,1.82 nfet
XM$85 TAIL IBIAS VSS vsubs nfet_03v3 L=0.5U W=2U AS=0.42P AD=0.42P PS=2.42U PD=2.42U
* device instance $86 r0 *1 170.87,1.82 nfet
XM$86 VSS IBIAS TAIL vsubs nfet_03v3 L=0.5U W=2U AS=0.42P AD=0.42P PS=2.42U PD=2.42U
* device instance $87 r0 *1 171.79,1.82 nfet
XM$87 TAIL IBIAS VSS vsubs nfet_03v3 L=0.5U W=2U AS=0.42P AD=0.42P PS=2.42U PD=2.42U
* device instance $88 r0 *1 172.71,1.82 nfet
XM$88 VSS IBIAS TAIL vsubs nfet_03v3 L=0.5U W=2U AS=0.42P AD=0.42P PS=2.42U PD=2.42U
* device instance $89 r0 *1 173.63,1.82 nfet
XM$89 TAIL IBIAS VSS vsubs nfet_03v3 L=0.5U W=2U AS=0.42P AD=0.42P PS=2.42U PD=2.42U
* device instance $90 r0 *1 174.55,1.82 nfet
XM$90 VSS IBIAS TAIL vsubs nfet_03v3 L=0.5U W=2U AS=0.42P AD=0.42P PS=2.42U PD=2.42U
* device instance $91 r0 *1 175.47,1.82 nfet
XM$91 TAIL IBIAS VSS vsubs nfet_03v3 L=0.5U W=2U AS=0.42P AD=0.42P PS=2.42U PD=2.42U
* device instance $92 r0 *1 176.39,1.82 nfet
XM$92 VSS IBIAS TAIL vsubs nfet_03v3 L=0.5U W=2U AS=0.42P AD=0.42P PS=2.42U PD=2.42U
* device instance $93 r0 *1 177.31,1.82 nfet
XM$93 TAIL IBIAS VSS vsubs nfet_03v3 L=0.5U W=2U AS=0.42P AD=0.42P PS=2.42U PD=2.42U
* device instance $94 r0 *1 178.23,1.82 nfet
XM$94 VSS IBIAS TAIL vsubs nfet_03v3 L=0.5U W=2U AS=0.42P AD=0.42P PS=2.42U PD=2.42U
* device instance $95 r0 *1 179.15,1.82 nfet
XM$95 TAIL IBIAS VSS vsubs nfet_03v3 L=0.5U W=2U AS=0.42P AD=0.42P PS=2.42U PD=2.42U
* device instance $96 r0 *1 180.07,1.82 nfet
XM$96 VSS IBIAS TAIL vsubs nfet_03v3 L=0.5U W=2U AS=0.42P AD=0.42P PS=2.42U PD=2.42U
* device instance $97 r0 *1 180.99,1.82 nfet
XM$97 TAIL IBIAS VSS vsubs nfet_03v3 L=0.5U W=2U AS=0.42P AD=0.42P PS=2.42U PD=2.42U
* device instance $98 r0 *1 181.91,1.82 nfet
XM$98 VSS IBIAS TAIL vsubs nfet_03v3 L=0.5U W=2U AS=0.42P AD=0.42P PS=2.42U PD=2.42U
* device instance $99 r0 *1 182.83,1.82 nfet
XM$99 TAIL IBIAS VSS vsubs nfet_03v3 L=0.5U W=2U AS=0.42P AD=0.42P PS=2.42U PD=2.42U
* device instance $100 r0 *1 183.75,1.82 nfet
XM$100 VSS IBIAS TAIL vsubs nfet_03v3 L=0.5U W=2U AS=0.42P AD=0.84P PS=2.42U PD=4.84U
* device instance $101 r0 *1 0.67,1.82 nfet
XM$101 TAIL IBIAS VSS vsubs nfet_03v3 L=0.5U W=2U AS=0.84P AD=0.42P PS=4.84U PD=2.42U
* device instance $102 r0 *1 1.59,1.82 nfet
XM$102 VSS IBIAS TAIL vsubs nfet_03v3 L=0.5U W=2U AS=0.42P AD=0.42P PS=2.42U PD=2.42U
* device instance $103 r0 *1 2.51,1.82 nfet
XM$103 TAIL IBIAS VSS vsubs nfet_03v3 L=0.5U W=2U AS=0.42P AD=0.42P PS=2.42U PD=2.42U
* device instance $104 r0 *1 3.43,1.82 nfet
XM$104 VSS IBIAS TAIL vsubs nfet_03v3 L=0.5U W=2U AS=0.42P AD=0.42P PS=2.42U PD=2.42U
* device instance $105 r0 *1 4.35,1.82 nfet
XM$105 TAIL IBIAS VSS vsubs nfet_03v3 L=0.5U W=2U AS=0.42P AD=0.42P PS=2.42U PD=2.42U
* device instance $106 r0 *1 5.27,1.82 nfet
XM$106 VSS IBIAS TAIL vsubs nfet_03v3 L=0.5U W=2U AS=0.42P AD=0.42P PS=2.42U PD=2.42U
* device instance $107 r0 *1 6.19,1.82 nfet
XM$107 TAIL IBIAS VSS vsubs nfet_03v3 L=0.5U W=2U AS=0.42P AD=0.42P PS=2.42U PD=2.42U
* device instance $108 r0 *1 7.11,1.82 nfet
XM$108 VSS IBIAS TAIL vsubs nfet_03v3 L=0.5U W=2U AS=0.42P AD=0.42P PS=2.42U PD=2.42U
* device instance $109 r0 *1 8.03,1.82 nfet
XM$109 TAIL IBIAS VSS vsubs nfet_03v3 L=0.5U W=2U AS=0.42P AD=0.42P PS=2.42U PD=2.42U
* device instance $110 r0 *1 8.95,1.82 nfet
XM$110 VSS IBIAS TAIL vsubs nfet_03v3 L=0.5U W=2U AS=0.42P AD=0.42P PS=2.42U PD=2.42U
* device instance $111 r0 *1 9.87,1.82 nfet
XM$111 TAIL IBIAS VSS vsubs nfet_03v3 L=0.5U W=2U AS=0.42P AD=0.42P PS=2.42U PD=2.42U
* device instance $112 r0 *1 10.79,1.82 nfet
XM$112 VSS IBIAS TAIL vsubs nfet_03v3 L=0.5U W=2U AS=0.42P AD=0.42P PS=2.42U PD=2.42U
* device instance $113 r0 *1 11.71,1.82 nfet
XM$113 TAIL IBIAS VSS vsubs nfet_03v3 L=0.5U W=2U AS=0.42P AD=0.42P PS=2.42U PD=2.42U
* device instance $114 r0 *1 12.63,1.82 nfet
XM$114 VSS IBIAS TAIL vsubs nfet_03v3 L=0.5U W=2U AS=0.42P AD=0.42P PS=2.42U PD=2.42U
* device instance $115 r0 *1 13.55,1.82 nfet
XM$115 TAIL IBIAS VSS vsubs nfet_03v3 L=0.5U W=2U AS=0.42P AD=0.42P PS=2.42U PD=2.42U
* device instance $116 r0 *1 14.47,1.82 nfet
XM$116 VSS IBIAS TAIL vsubs nfet_03v3 L=0.5U W=2U AS=0.42P AD=0.42P PS=2.42U PD=2.42U
* device instance $117 r0 *1 15.39,1.82 nfet
XM$117 TAIL IBIAS VSS vsubs nfet_03v3 L=0.5U W=2U AS=0.42P AD=0.42P PS=2.42U PD=2.42U
* device instance $118 r0 *1 16.31,1.82 nfet
XM$118 VSS IBIAS TAIL vsubs nfet_03v3 L=0.5U W=2U AS=0.42P AD=0.42P PS=2.42U PD=2.42U
* device instance $119 r0 *1 17.23,1.82 nfet
XM$119 TAIL IBIAS VSS vsubs nfet_03v3 L=0.5U W=2U AS=0.42P AD=0.42P PS=2.42U PD=2.42U
* device instance $120 r0 *1 18.15,1.82 nfet
XM$120 VSS IBIAS TAIL vsubs nfet_03v3 L=0.5U W=2U AS=0.42P AD=0.42P PS=2.42U PD=2.42U
* device instance $121 r0 *1 19.07,1.82 nfet
XM$121 TAIL IBIAS VSS vsubs nfet_03v3 L=0.5U W=2U AS=0.42P AD=0.42P PS=2.42U PD=2.42U
* device instance $122 r0 *1 19.99,1.82 nfet
XM$122 VSS IBIAS TAIL vsubs nfet_03v3 L=0.5U W=2U AS=0.42P AD=0.42P PS=2.42U PD=2.42U
* device instance $123 r0 *1 20.91,1.82 nfet
XM$123 TAIL IBIAS VSS vsubs nfet_03v3 L=0.5U W=2U AS=0.42P AD=0.42P PS=2.42U PD=2.42U
* device instance $124 r0 *1 21.83,1.82 nfet
XM$124 VSS IBIAS TAIL vsubs nfet_03v3 L=0.5U W=2U AS=0.42P AD=0.42P PS=2.42U PD=2.42U
* device instance $125 r0 *1 22.75,1.82 nfet
XM$125 TAIL IBIAS VSS vsubs nfet_03v3 L=0.5U W=2U AS=0.42P AD=0.42P PS=2.42U PD=2.42U
* device instance $126 r0 *1 23.67,1.82 nfet
XM$126 VSS IBIAS TAIL vsubs nfet_03v3 L=0.5U W=2U AS=0.42P AD=0.42P PS=2.42U PD=2.42U
* device instance $127 r0 *1 24.59,1.82 nfet
XM$127 TAIL IBIAS VSS vsubs nfet_03v3 L=0.5U W=2U AS=0.42P AD=0.42P PS=2.42U PD=2.42U
* device instance $128 r0 *1 25.51,1.82 nfet
XM$128 VSS IBIAS TAIL vsubs nfet_03v3 L=0.5U W=2U AS=0.42P AD=0.42P PS=2.42U PD=2.42U
* device instance $129 r0 *1 26.43,1.82 nfet
XM$129 TAIL IBIAS VSS vsubs nfet_03v3 L=0.5U W=2U AS=0.42P AD=0.42P PS=2.42U PD=2.42U
* device instance $130 r0 *1 27.35,1.82 nfet
XM$130 VSS IBIAS TAIL vsubs nfet_03v3 L=0.5U W=2U AS=0.42P AD=0.42P PS=2.42U PD=2.42U
* device instance $131 r0 *1 28.27,1.82 nfet
XM$131 TAIL IBIAS VSS vsubs nfet_03v3 L=0.5U W=2U AS=0.42P AD=0.42P PS=2.42U PD=2.42U
* device instance $132 r0 *1 29.19,1.82 nfet
XM$132 VSS IBIAS TAIL vsubs nfet_03v3 L=0.5U W=2U AS=0.42P AD=0.42P PS=2.42U PD=2.42U
* device instance $133 r0 *1 30.11,1.82 nfet
XM$133 TAIL IBIAS VSS vsubs nfet_03v3 L=0.5U W=2U AS=0.42P AD=0.42P PS=2.42U PD=2.42U
* device instance $134 r0 *1 31.03,1.82 nfet
XM$134 VSS IBIAS TAIL vsubs nfet_03v3 L=0.5U W=2U AS=0.42P AD=0.42P PS=2.42U PD=2.42U
* device instance $135 r0 *1 31.95,1.82 nfet
XM$135 TAIL IBIAS VSS vsubs nfet_03v3 L=0.5U W=2U AS=0.42P AD=0.42P PS=2.42U PD=2.42U
* device instance $136 r0 *1 32.87,1.82 nfet
XM$136 VSS IBIAS TAIL vsubs nfet_03v3 L=0.5U W=2U AS=0.42P AD=0.42P PS=2.42U PD=2.42U
* device instance $137 r0 *1 33.79,1.82 nfet
XM$137 TAIL IBIAS VSS vsubs nfet_03v3 L=0.5U W=2U AS=0.42P AD=0.42P PS=2.42U PD=2.42U
* device instance $138 r0 *1 34.71,1.82 nfet
XM$138 VSS IBIAS TAIL vsubs nfet_03v3 L=0.5U W=2U AS=0.42P AD=0.42P PS=2.42U PD=2.42U
* device instance $139 r0 *1 35.63,1.82 nfet
XM$139 TAIL IBIAS VSS vsubs nfet_03v3 L=0.5U W=2U AS=0.42P AD=0.42P PS=2.42U PD=2.42U
* device instance $140 r0 *1 36.55,1.82 nfet
XM$140 VSS IBIAS TAIL vsubs nfet_03v3 L=0.5U W=2U AS=0.42P AD=0.42P PS=2.42U PD=2.42U
* device instance $141 r0 *1 37.47,1.82 nfet
XM$141 TAIL IBIAS VSS vsubs nfet_03v3 L=0.5U W=2U AS=0.42P AD=0.42P PS=2.42U PD=2.42U
* device instance $142 r0 *1 38.39,1.82 nfet
XM$142 VSS IBIAS TAIL vsubs nfet_03v3 L=0.5U W=2U AS=0.42P AD=0.42P PS=2.42U PD=2.42U
* device instance $143 r0 *1 39.31,1.82 nfet
XM$143 TAIL IBIAS VSS vsubs nfet_03v3 L=0.5U W=2U AS=0.42P AD=0.42P PS=2.42U PD=2.42U
* device instance $144 r0 *1 40.23,1.82 nfet
XM$144 VSS IBIAS TAIL vsubs nfet_03v3 L=0.5U W=2U AS=0.42P AD=0.42P PS=2.42U PD=2.42U
* device instance $145 r0 *1 41.15,1.82 nfet
XM$145 TAIL IBIAS VSS vsubs nfet_03v3 L=0.5U W=2U AS=0.42P AD=0.42P PS=2.42U PD=2.42U
* device instance $146 r0 *1 42.07,1.82 nfet
XM$146 VSS IBIAS TAIL vsubs nfet_03v3 L=0.5U W=2U AS=0.42P AD=0.42P PS=2.42U PD=2.42U
* device instance $147 r0 *1 42.99,1.82 nfet
XM$147 TAIL IBIAS VSS vsubs nfet_03v3 L=0.5U W=2U AS=0.42P AD=0.42P PS=2.42U PD=2.42U
* device instance $148 r0 *1 43.91,1.82 nfet
XM$148 VSS IBIAS TAIL vsubs nfet_03v3 L=0.5U W=2U AS=0.42P AD=0.42P PS=2.42U PD=2.42U
* device instance $149 r0 *1 44.83,1.82 nfet
XM$149 TAIL IBIAS VSS vsubs nfet_03v3 L=0.5U W=2U AS=0.42P AD=0.42P PS=2.42U PD=2.42U
* device instance $150 r0 *1 45.75,1.82 nfet
XM$150 VSS IBIAS TAIL vsubs nfet_03v3 L=0.5U W=2U AS=0.42P AD=0.42P PS=2.42U PD=2.42U
* device instance $151 r0 *1 46.67,1.82 nfet
XM$151 TAIL IBIAS VSS vsubs nfet_03v3 L=0.5U W=2U AS=0.42P AD=0.42P PS=2.42U PD=2.42U
* device instance $152 r0 *1 47.59,1.82 nfet
XM$152 VSS IBIAS TAIL vsubs nfet_03v3 L=0.5U W=2U AS=0.42P AD=0.42P PS=2.42U PD=2.42U
* device instance $153 r0 *1 48.51,1.82 nfet
XM$153 TAIL IBIAS VSS vsubs nfet_03v3 L=0.5U W=2U AS=0.42P AD=0.42P PS=2.42U PD=2.42U
* device instance $154 r0 *1 49.43,1.82 nfet
XM$154 VSS IBIAS TAIL vsubs nfet_03v3 L=0.5U W=2U AS=0.42P AD=0.42P PS=2.42U PD=2.42U
* device instance $155 r0 *1 50.35,1.82 nfet
XM$155 TAIL IBIAS VSS vsubs nfet_03v3 L=0.5U W=2U AS=0.42P AD=0.42P PS=2.42U PD=2.42U
* device instance $156 r0 *1 51.27,1.82 nfet
XM$156 VSS IBIAS TAIL vsubs nfet_03v3 L=0.5U W=2U AS=0.42P AD=0.42P PS=2.42U PD=2.42U
* device instance $157 r0 *1 52.19,1.82 nfet
XM$157 TAIL IBIAS VSS vsubs nfet_03v3 L=0.5U W=2U AS=0.42P AD=0.42P PS=2.42U PD=2.42U
* device instance $158 r0 *1 53.11,1.82 nfet
XM$158 VSS IBIAS TAIL vsubs nfet_03v3 L=0.5U W=2U AS=0.42P AD=0.42P PS=2.42U PD=2.42U
* device instance $159 r0 *1 54.03,1.82 nfet
XM$159 TAIL IBIAS VSS vsubs nfet_03v3 L=0.5U W=2U AS=0.42P AD=0.42P PS=2.42U PD=2.42U
* device instance $160 r0 *1 54.95,1.82 nfet
XM$160 VSS IBIAS TAIL vsubs nfet_03v3 L=0.5U W=2U AS=0.42P AD=0.42P PS=2.42U PD=2.42U
* device instance $161 r0 *1 55.87,1.82 nfet
XM$161 TAIL IBIAS VSS vsubs nfet_03v3 L=0.5U W=2U AS=0.42P AD=0.42P PS=2.42U PD=2.42U
* device instance $162 r0 *1 56.79,1.82 nfet
XM$162 VSS IBIAS TAIL vsubs nfet_03v3 L=0.5U W=2U AS=0.42P AD=0.42P PS=2.42U PD=2.42U
* device instance $163 r0 *1 57.71,1.82 nfet
XM$163 TAIL IBIAS VSS vsubs nfet_03v3 L=0.5U W=2U AS=0.42P AD=0.42P PS=2.42U PD=2.42U
* device instance $164 r0 *1 58.63,1.82 nfet
XM$164 VSS IBIAS TAIL vsubs nfet_03v3 L=0.5U W=2U AS=0.42P AD=0.42P PS=2.42U PD=2.42U
* device instance $165 r0 *1 59.55,1.82 nfet
XM$165 TAIL IBIAS VSS vsubs nfet_03v3 L=0.5U W=2U AS=0.42P AD=0.42P PS=2.42U PD=2.42U
* device instance $166 r0 *1 60.47,1.82 nfet
XM$166 VSS IBIAS TAIL vsubs nfet_03v3 L=0.5U W=2U AS=0.42P AD=0.42P PS=2.42U PD=2.42U
* device instance $167 r0 *1 61.39,1.82 nfet
XM$167 TAIL IBIAS VSS vsubs nfet_03v3 L=0.5U W=2U AS=0.42P AD=0.42P PS=2.42U PD=2.42U
* device instance $168 r0 *1 62.31,1.82 nfet
XM$168 VSS IBIAS TAIL vsubs nfet_03v3 L=0.5U W=2U AS=0.42P AD=0.42P PS=2.42U PD=2.42U
* device instance $169 r0 *1 63.23,1.82 nfet
XM$169 TAIL IBIAS VSS vsubs nfet_03v3 L=0.5U W=2U AS=0.42P AD=0.42P PS=2.42U PD=2.42U
* device instance $170 r0 *1 64.15,1.82 nfet
XM$170 VSS IBIAS TAIL vsubs nfet_03v3 L=0.5U W=2U AS=0.42P AD=0.42P PS=2.42U PD=2.42U
* device instance $171 r0 *1 65.07,1.82 nfet
XM$171 TAIL IBIAS VSS vsubs nfet_03v3 L=0.5U W=2U AS=0.42P AD=0.42P PS=2.42U PD=2.42U
* device instance $172 r0 *1 65.99,1.82 nfet
XM$172 VSS IBIAS TAIL vsubs nfet_03v3 L=0.5U W=2U AS=0.42P AD=0.42P PS=2.42U PD=2.42U
* device instance $173 r0 *1 66.91,1.82 nfet
XM$173 TAIL IBIAS VSS vsubs nfet_03v3 L=0.5U W=2U AS=0.42P AD=0.42P PS=2.42U PD=2.42U
* device instance $174 r0 *1 67.83,1.82 nfet
XM$174 VSS IBIAS TAIL vsubs nfet_03v3 L=0.5U W=2U AS=0.42P AD=0.42P PS=2.42U PD=2.42U
* device instance $175 r0 *1 68.75,1.82 nfet
XM$175 TAIL IBIAS VSS vsubs nfet_03v3 L=0.5U W=2U AS=0.42P AD=0.42P PS=2.42U PD=2.42U
* device instance $176 r0 *1 69.67,1.82 nfet
XM$176 VSS IBIAS TAIL vsubs nfet_03v3 L=0.5U W=2U AS=0.42P AD=0.42P PS=2.42U PD=2.42U
* device instance $177 r0 *1 70.59,1.82 nfet
XM$177 TAIL IBIAS VSS vsubs nfet_03v3 L=0.5U W=2U AS=0.42P AD=0.42P PS=2.42U PD=2.42U
* device instance $178 r0 *1 71.51,1.82 nfet
XM$178 VSS IBIAS TAIL vsubs nfet_03v3 L=0.5U W=2U AS=0.42P AD=0.42P PS=2.42U PD=2.42U
* device instance $179 r0 *1 72.43,1.82 nfet
XM$179 TAIL IBIAS VSS vsubs nfet_03v3 L=0.5U W=2U AS=0.42P AD=0.42P PS=2.42U PD=2.42U
* device instance $180 r0 *1 73.35,1.82 nfet
XM$180 VSS IBIAS TAIL vsubs nfet_03v3 L=0.5U W=2U AS=0.42P AD=0.42P PS=2.42U PD=2.42U
* device instance $181 r0 *1 74.27,1.82 nfet
XM$181 TAIL IBIAS VSS vsubs nfet_03v3 L=0.5U W=2U AS=0.42P AD=0.42P PS=2.42U PD=2.42U
* device instance $182 r0 *1 75.19,1.82 nfet
XM$182 VSS IBIAS TAIL vsubs nfet_03v3 L=0.5U W=2U AS=0.42P AD=0.42P PS=2.42U PD=2.42U
* device instance $183 r0 *1 76.11,1.82 nfet
XM$183 TAIL IBIAS VSS vsubs nfet_03v3 L=0.5U W=2U AS=0.42P AD=0.42P PS=2.42U PD=2.42U
* device instance $184 r0 *1 77.03,1.82 nfet
XM$184 VSS IBIAS TAIL vsubs nfet_03v3 L=0.5U W=2U AS=0.42P AD=0.42P PS=2.42U PD=2.42U
* device instance $185 r0 *1 77.95,1.82 nfet
XM$185 TAIL IBIAS VSS vsubs nfet_03v3 L=0.5U W=2U AS=0.42P AD=0.42P PS=2.42U PD=2.42U
* device instance $186 r0 *1 78.87,1.82 nfet
XM$186 VSS IBIAS TAIL vsubs nfet_03v3 L=0.5U W=2U AS=0.42P AD=0.42P PS=2.42U PD=2.42U
* device instance $187 r0 *1 79.79,1.82 nfet
XM$187 TAIL IBIAS VSS vsubs nfet_03v3 L=0.5U W=2U AS=0.42P AD=0.42P PS=2.42U PD=2.42U
* device instance $188 r0 *1 80.71,1.82 nfet
XM$188 VSS IBIAS TAIL vsubs nfet_03v3 L=0.5U W=2U AS=0.42P AD=0.42P PS=2.42U PD=2.42U
* device instance $189 r0 *1 81.63,1.82 nfet
XM$189 TAIL IBIAS VSS vsubs nfet_03v3 L=0.5U W=2U AS=0.42P AD=0.42P PS=2.42U PD=2.42U
* device instance $190 r0 *1 82.55,1.82 nfet
XM$190 VSS IBIAS TAIL vsubs nfet_03v3 L=0.5U W=2U AS=0.42P AD=0.42P PS=2.42U PD=2.42U
* device instance $191 r0 *1 83.47,1.82 nfet
XM$191 TAIL IBIAS VSS vsubs nfet_03v3 L=0.5U W=2U AS=0.42P AD=0.42P PS=2.42U PD=2.42U
* device instance $192 r0 *1 84.39,1.82 nfet
XM$192 VSS IBIAS TAIL vsubs nfet_03v3 L=0.5U W=2U AS=0.42P AD=0.42P PS=2.42U PD=2.42U
* device instance $193 r0 *1 85.31,1.82 nfet
XM$193 TAIL IBIAS VSS vsubs nfet_03v3 L=0.5U W=2U AS=0.42P AD=0.42P PS=2.42U PD=2.42U
* device instance $194 r0 *1 86.23,1.82 nfet
XM$194 VSS IBIAS TAIL vsubs nfet_03v3 L=0.5U W=2U AS=0.42P AD=0.42P PS=2.42U PD=2.42U
* device instance $195 r0 *1 87.15,1.82 nfet
XM$195 TAIL IBIAS VSS vsubs nfet_03v3 L=0.5U W=2U AS=0.42P AD=0.42P PS=2.42U PD=2.42U
* device instance $196 r0 *1 88.07,1.82 nfet
XM$196 VSS IBIAS TAIL vsubs nfet_03v3 L=0.5U W=2U AS=0.42P AD=0.42P PS=2.42U PD=2.42U
* device instance $197 r0 *1 88.99,1.82 nfet
XM$197 TAIL IBIAS VSS vsubs nfet_03v3 L=0.5U W=2U AS=0.42P AD=0.42P PS=2.42U PD=2.42U
* device instance $198 r0 *1 89.91,1.82 nfet
XM$198 VSS IBIAS TAIL vsubs nfet_03v3 L=0.5U W=2U AS=0.42P AD=0.42P PS=2.42U PD=2.42U
* device instance $199 r0 *1 90.83,1.82 nfet
XM$199 TAIL IBIAS VSS vsubs nfet_03v3 L=0.5U W=2U AS=0.42P AD=0.42P PS=2.42U PD=2.42U
* device instance $200 r0 *1 91.75,1.82 nfet
XM$200 VSS IBIAS TAIL vsubs nfet_03v3 L=0.5U W=2U AS=0.42P AD=0.42P PS=2.42U PD=2.42U
* device instance $201 r0 *1 189.98,1.82 nfet
XM$201 OUTP INP TAIL vsubs nfet_03v3 L=0.28U W=2U AS=0.84P AD=0.42P PS=4.84U PD=2.42U
* device instance $202 r0 *1 190.68,1.82 nfet
XM$202 TAIL INP OUTP vsubs nfet_03v3 L=0.28U W=2U AS=0.42P AD=0.42P PS=2.42U PD=2.42U
* device instance $203 r0 *1 191.38,1.82 nfet
XM$203 OUTP INP TAIL vsubs nfet_03v3 L=0.28U W=2U AS=0.42P AD=0.42P PS=2.42U PD=2.42U
* device instance $204 r0 *1 192.08,1.82 nfet
XM$204 TAIL INP OUTP vsubs nfet_03v3 L=0.28U W=2U AS=0.42P AD=0.42P PS=2.42U PD=2.42U
* device instance $205 r0 *1 192.78,1.82 nfet
XM$205 OUTP INP TAIL vsubs nfet_03v3 L=0.28U W=2U AS=0.42P AD=0.42P PS=2.42U PD=2.42U
* device instance $206 r0 *1 193.48,1.82 nfet
XM$206 TAIL INP OUTP vsubs nfet_03v3 L=0.28U W=2U AS=0.42P AD=0.42P PS=2.42U PD=2.42U
* device instance $207 r0 *1 194.18,1.82 nfet
XM$207 OUTP INP TAIL vsubs nfet_03v3 L=0.28U W=2U AS=0.42P AD=0.42P PS=2.42U PD=2.42U
* device instance $208 r0 *1 194.88,1.82 nfet
XM$208 TAIL INP OUTP vsubs nfet_03v3 L=0.28U W=2U AS=0.42P AD=0.42P PS=2.42U PD=2.42U
* device instance $209 r0 *1 195.58,1.82 nfet
XM$209 OUTP INP TAIL vsubs nfet_03v3 L=0.28U W=2U AS=0.42P AD=0.42P PS=2.42U PD=2.42U
* device instance $210 r0 *1 196.28,1.82 nfet
XM$210 TAIL INP OUTP vsubs nfet_03v3 L=0.28U W=2U AS=0.42P AD=0.42P PS=2.42U PD=2.42U
* device instance $211 r0 *1 196.98,1.82 nfet
XM$211 OUTP INP TAIL vsubs nfet_03v3 L=0.28U W=2U AS=0.42P AD=0.42P PS=2.42U PD=2.42U
* device instance $212 r0 *1 197.68,1.82 nfet
XM$212 TAIL INP OUTP vsubs nfet_03v3 L=0.28U W=2U AS=0.42P AD=0.42P PS=2.42U PD=2.42U
* device instance $213 r0 *1 198.38,1.82 nfet
XM$213 OUTP INP TAIL vsubs nfet_03v3 L=0.28U W=2U AS=0.42P AD=0.42P PS=2.42U PD=2.42U
* device instance $214 r0 *1 199.08,1.82 nfet
XM$214 TAIL INP OUTP vsubs nfet_03v3 L=0.28U W=2U AS=0.42P AD=0.42P PS=2.42U PD=2.42U
* device instance $215 r0 *1 199.78,1.82 nfet
XM$215 OUTP INP TAIL vsubs nfet_03v3 L=0.28U W=2U AS=0.42P AD=0.42P PS=2.42U PD=2.42U
* device instance $216 r0 *1 200.48,1.82 nfet
XM$216 TAIL INP OUTP vsubs nfet_03v3 L=0.28U W=2U AS=0.42P AD=0.42P PS=2.42U PD=2.42U
* device instance $217 r0 *1 201.18,1.82 nfet
XM$217 OUTP INP TAIL vsubs nfet_03v3 L=0.28U W=2U AS=0.42P AD=0.42P PS=2.42U PD=2.42U
* device instance $218 r0 *1 201.88,1.82 nfet
XM$218 TAIL INP OUTP vsubs nfet_03v3 L=0.28U W=2U AS=0.42P AD=0.42P PS=2.42U PD=2.42U
* device instance $219 r0 *1 202.58,1.82 nfet
XM$219 OUTP INP TAIL vsubs nfet_03v3 L=0.28U W=2U AS=0.42P AD=0.42P PS=2.42U PD=2.42U
* device instance $220 r0 *1 203.28,1.82 nfet
XM$220 TAIL INP OUTP vsubs nfet_03v3 L=0.28U W=2U AS=0.42P AD=0.42P PS=2.42U PD=2.42U
* device instance $221 r0 *1 203.98,1.82 nfet
XM$221 OUTP INP TAIL vsubs nfet_03v3 L=0.28U W=2U AS=0.42P AD=0.42P PS=2.42U PD=2.42U
* device instance $222 r0 *1 204.68,1.82 nfet
XM$222 TAIL INP OUTP vsubs nfet_03v3 L=0.28U W=2U AS=0.42P AD=0.42P PS=2.42U PD=2.42U
* device instance $223 r0 *1 205.38,1.82 nfet
XM$223 OUTP INP TAIL vsubs nfet_03v3 L=0.28U W=2U AS=0.42P AD=0.42P PS=2.42U PD=2.42U
* device instance $224 r0 *1 206.08,1.82 nfet
XM$224 TAIL INP OUTP vsubs nfet_03v3 L=0.28U W=2U AS=0.42P AD=0.42P PS=2.42U PD=2.42U
* device instance $225 r0 *1 206.78,1.82 nfet
XM$225 OUTP INP TAIL vsubs nfet_03v3 L=0.28U W=2U AS=0.42P AD=0.42P PS=2.42U PD=2.42U
* device instance $226 r0 *1 207.48,1.82 nfet
XM$226 TAIL INP OUTP vsubs nfet_03v3 L=0.28U W=2U AS=0.42P AD=0.42P PS=2.42U PD=2.42U
* device instance $227 r0 *1 208.18,1.82 nfet
XM$227 OUTP INP TAIL vsubs nfet_03v3 L=0.28U W=2U AS=0.42P AD=0.42P PS=2.42U PD=2.42U
* device instance $228 r0 *1 208.88,1.82 nfet
XM$228 TAIL INP OUTP vsubs nfet_03v3 L=0.28U W=2U AS=0.42P AD=0.42P PS=2.42U PD=2.42U
* device instance $229 r0 *1 209.58,1.82 nfet
XM$229 OUTP INP TAIL vsubs nfet_03v3 L=0.28U W=2U AS=0.42P AD=0.42P PS=2.42U PD=2.42U
* device instance $230 r0 *1 210.28,1.82 nfet
XM$230 TAIL INP OUTP vsubs nfet_03v3 L=0.28U W=2U AS=0.42P AD=0.42P PS=2.42U PD=2.42U
* device instance $231 r0 *1 210.98,1.82 nfet
XM$231 OUTP INP TAIL vsubs nfet_03v3 L=0.28U W=2U AS=0.42P AD=0.42P PS=2.42U PD=2.42U
* device instance $232 r0 *1 211.68,1.82 nfet
XM$232 TAIL INP OUTP vsubs nfet_03v3 L=0.28U W=2U AS=0.42P AD=0.42P PS=2.42U PD=2.42U
* device instance $233 r0 *1 212.38,1.82 nfet
XM$233 OUTP INP TAIL vsubs nfet_03v3 L=0.28U W=2U AS=0.42P AD=0.42P PS=2.42U PD=2.42U
* device instance $234 r0 *1 213.08,1.82 nfet
XM$234 TAIL INP OUTP vsubs nfet_03v3 L=0.28U W=2U AS=0.42P AD=0.42P PS=2.42U PD=2.42U
* device instance $235 r0 *1 213.78,1.82 nfet
XM$235 OUTP INP TAIL vsubs nfet_03v3 L=0.28U W=2U AS=0.42P AD=0.42P PS=2.42U PD=2.42U
* device instance $236 r0 *1 214.48,1.82 nfet
XM$236 TAIL INP OUTP vsubs nfet_03v3 L=0.28U W=2U AS=0.42P AD=0.42P PS=2.42U PD=2.42U
* device instance $237 r0 *1 215.18,1.82 nfet
XM$237 OUTP INP TAIL vsubs nfet_03v3 L=0.28U W=2U AS=0.42P AD=0.42P PS=2.42U PD=2.42U
* device instance $238 r0 *1 215.88,1.82 nfet
XM$238 TAIL INP OUTP vsubs nfet_03v3 L=0.28U W=2U AS=0.42P AD=0.42P PS=2.42U PD=2.42U
* device instance $239 r0 *1 216.58,1.82 nfet
XM$239 OUTP INP TAIL vsubs nfet_03v3 L=0.28U W=2U AS=0.42P AD=0.42P PS=2.42U PD=2.42U
* device instance $240 r0 *1 217.28,1.82 nfet
XM$240 TAIL INP OUTP vsubs nfet_03v3 L=0.28U W=2U AS=0.42P AD=0.42P PS=2.42U PD=2.42U
* device instance $241 r0 *1 217.98,1.82 nfet
XM$241 OUTP INP TAIL vsubs nfet_03v3 L=0.28U W=2U AS=0.42P AD=0.42P PS=2.42U PD=2.42U
* device instance $242 r0 *1 218.68,1.82 nfet
XM$242 TAIL INP OUTP vsubs nfet_03v3 L=0.28U W=2U AS=0.42P AD=0.42P PS=2.42U PD=2.42U
* device instance $243 r0 *1 219.38,1.82 nfet
XM$243 OUTP INP TAIL vsubs nfet_03v3 L=0.28U W=2U AS=0.42P AD=0.42P PS=2.42U PD=2.42U
* device instance $244 r0 *1 220.08,1.82 nfet
XM$244 TAIL INP OUTP vsubs nfet_03v3 L=0.28U W=2U AS=0.42P AD=0.42P PS=2.42U PD=2.42U
* device instance $245 r0 *1 220.78,1.82 nfet
XM$245 OUTP INP TAIL vsubs nfet_03v3 L=0.28U W=2U AS=0.42P AD=0.42P PS=2.42U PD=2.42U
* device instance $246 r0 *1 221.48,1.82 nfet
XM$246 TAIL INP OUTP vsubs nfet_03v3 L=0.28U W=2U AS=0.42P AD=0.42P PS=2.42U PD=2.42U
* device instance $247 r0 *1 222.18,1.82 nfet
XM$247 OUTP INP TAIL vsubs nfet_03v3 L=0.28U W=2U AS=0.42P AD=0.42P PS=2.42U PD=2.42U
* device instance $248 r0 *1 222.88,1.82 nfet
XM$248 TAIL INP OUTP vsubs nfet_03v3 L=0.28U W=2U AS=0.42P AD=0.42P PS=2.42U PD=2.42U
* device instance $249 r0 *1 223.58,1.82 nfet
XM$249 OUTP INP TAIL vsubs nfet_03v3 L=0.28U W=2U AS=0.42P AD=0.42P PS=2.42U PD=2.42U
* device instance $250 r0 *1 224.28,1.82 nfet
XM$250 TAIL INP OUTP vsubs nfet_03v3 L=0.28U W=2U AS=0.42P AD=0.42P PS=2.42U PD=2.42U
* device instance $251 r0 *1 224.98,1.82 nfet
XM$251 OUTP INP TAIL vsubs nfet_03v3 L=0.28U W=2U AS=0.42P AD=0.42P PS=2.42U PD=2.42U
* device instance $252 r0 *1 225.68,1.82 nfet
XM$252 TAIL INP OUTP vsubs nfet_03v3 L=0.28U W=2U AS=0.42P AD=0.42P PS=2.42U PD=2.42U
* device instance $253 r0 *1 226.38,1.82 nfet
XM$253 OUTP INP TAIL vsubs nfet_03v3 L=0.28U W=2U AS=0.42P AD=0.42P PS=2.42U PD=2.42U
* device instance $254 r0 *1 227.08,1.82 nfet
XM$254 TAIL INP OUTP vsubs nfet_03v3 L=0.28U W=2U AS=0.42P AD=0.42P PS=2.42U PD=2.42U
* device instance $255 r0 *1 227.78,1.82 nfet
XM$255 OUTP INP TAIL vsubs nfet_03v3 L=0.28U W=2U AS=0.42P AD=0.42P PS=2.42U PD=2.42U
* device instance $256 r0 *1 228.48,1.82 nfet
XM$256 TAIL INP OUTP vsubs nfet_03v3 L=0.28U W=2U AS=0.42P AD=0.42P PS=2.42U PD=2.42U
* device instance $257 r0 *1 229.18,1.82 nfet
XM$257 OUTP INP TAIL vsubs nfet_03v3 L=0.28U W=2U AS=0.42P AD=0.42P PS=2.42U PD=2.42U
* device instance $258 r0 *1 229.88,1.82 nfet
XM$258 TAIL INP OUTP vsubs nfet_03v3 L=0.28U W=2U AS=0.42P AD=0.42P PS=2.42U PD=2.42U
* device instance $259 r0 *1 230.58,1.82 nfet
XM$259 OUTP INP TAIL vsubs nfet_03v3 L=0.28U W=2U AS=0.42P AD=0.42P PS=2.42U PD=2.42U
* device instance $260 r0 *1 231.28,1.82 nfet
XM$260 TAIL INP OUTP vsubs nfet_03v3 L=0.28U W=2U AS=0.42P AD=0.42P PS=2.42U PD=2.42U
* device instance $261 r0 *1 231.98,1.82 nfet
XM$261 OUTP INP TAIL vsubs nfet_03v3 L=0.28U W=2U AS=0.42P AD=0.42P PS=2.42U PD=2.42U
* device instance $262 r0 *1 232.68,1.82 nfet
XM$262 TAIL INP OUTP vsubs nfet_03v3 L=0.28U W=2U AS=0.42P AD=0.42P PS=2.42U PD=2.42U
* device instance $263 r0 *1 233.38,1.82 nfet
XM$263 OUTP INP TAIL vsubs nfet_03v3 L=0.28U W=2U AS=0.42P AD=0.42P PS=2.42U PD=2.42U
* device instance $264 r0 *1 234.08,1.82 nfet
XM$264 TAIL INP OUTP vsubs nfet_03v3 L=0.28U W=2U AS=0.42P AD=0.84P PS=2.42U PD=4.84U
* device instance $265 r0 *1 0.67,11.28 nfet
XM$265 IBIAS IBIAS VSS vsubs nfet_03v3 L=0.5U W=2U AS=0.84P AD=0.42P PS=4.84U PD=2.42U
* device instance $266 r0 *1 1.59,11.28 nfet
XM$266 VSS IBIAS IBIAS vsubs nfet_03v3 L=0.5U W=2U AS=0.42P AD=0.42P PS=2.42U PD=2.42U
* device instance $267 r0 *1 2.51,11.28 nfet
XM$267 IBIAS IBIAS VSS vsubs nfet_03v3 L=0.5U W=2U AS=0.42P AD=0.42P PS=2.42U PD=2.42U
* device instance $268 r0 *1 3.43,11.28 nfet
XM$268 VSS IBIAS IBIAS vsubs nfet_03v3 L=0.5U W=2U AS=0.42P AD=0.42P PS=2.42U PD=2.42U
* device instance $269 r0 *1 4.35,11.28 nfet
XM$269 IBIAS IBIAS VSS vsubs nfet_03v3 L=0.5U W=2U AS=0.42P AD=0.42P PS=2.42U PD=2.42U
* device instance $270 r0 *1 5.27,11.28 nfet
XM$270 VSS IBIAS IBIAS vsubs nfet_03v3 L=0.5U W=2U AS=0.42P AD=0.42P PS=2.42U PD=2.42U
* device instance $271 r0 *1 6.19,11.28 nfet
XM$271 IBIAS IBIAS VSS vsubs nfet_03v3 L=0.5U W=2U AS=0.42P AD=0.42P PS=2.42U PD=2.42U
* device instance $272 r0 *1 7.11,11.28 nfet
XM$272 VSS IBIAS IBIAS vsubs nfet_03v3 L=0.5U W=2U AS=0.42P AD=0.42P PS=2.42U PD=2.42U
* device instance $273 r0 *1 8.03,11.28 nfet
XM$273 IBIAS IBIAS VSS vsubs nfet_03v3 L=0.5U W=2U AS=0.42P AD=0.42P PS=2.42U PD=2.42U
* device instance $274 r0 *1 8.95,11.28 nfet
XM$274 VSS IBIAS IBIAS vsubs nfet_03v3 L=0.5U W=2U AS=0.42P AD=0.84P PS=2.42U PD=4.84U
* device instance $275 r0 *1 189.98,11.28 nfet
XM$275 OUTN INN TAIL vsubs nfet_03v3 L=0.28U W=2U AS=0.84P AD=0.42P PS=4.84U PD=2.42U
* device instance $276 r0 *1 190.68,11.28 nfet
XM$276 TAIL INN OUTN vsubs nfet_03v3 L=0.28U W=2U AS=0.42P AD=0.42P PS=2.42U PD=2.42U
* device instance $277 r0 *1 191.38,11.28 nfet
XM$277 OUTN INN TAIL vsubs nfet_03v3 L=0.28U W=2U AS=0.42P AD=0.42P PS=2.42U PD=2.42U
* device instance $278 r0 *1 192.08,11.28 nfet
XM$278 TAIL INN OUTN vsubs nfet_03v3 L=0.28U W=2U AS=0.42P AD=0.42P PS=2.42U PD=2.42U
* device instance $279 r0 *1 192.78,11.28 nfet
XM$279 OUTN INN TAIL vsubs nfet_03v3 L=0.28U W=2U AS=0.42P AD=0.42P PS=2.42U PD=2.42U
* device instance $280 r0 *1 193.48,11.28 nfet
XM$280 TAIL INN OUTN vsubs nfet_03v3 L=0.28U W=2U AS=0.42P AD=0.42P PS=2.42U PD=2.42U
* device instance $281 r0 *1 194.18,11.28 nfet
XM$281 OUTN INN TAIL vsubs nfet_03v3 L=0.28U W=2U AS=0.42P AD=0.42P PS=2.42U PD=2.42U
* device instance $282 r0 *1 194.88,11.28 nfet
XM$282 TAIL INN OUTN vsubs nfet_03v3 L=0.28U W=2U AS=0.42P AD=0.42P PS=2.42U PD=2.42U
* device instance $283 r0 *1 195.58,11.28 nfet
XM$283 OUTN INN TAIL vsubs nfet_03v3 L=0.28U W=2U AS=0.42P AD=0.42P PS=2.42U PD=2.42U
* device instance $284 r0 *1 196.28,11.28 nfet
XM$284 TAIL INN OUTN vsubs nfet_03v3 L=0.28U W=2U AS=0.42P AD=0.42P PS=2.42U PD=2.42U
* device instance $285 r0 *1 196.98,11.28 nfet
XM$285 OUTN INN TAIL vsubs nfet_03v3 L=0.28U W=2U AS=0.42P AD=0.42P PS=2.42U PD=2.42U
* device instance $286 r0 *1 197.68,11.28 nfet
XM$286 TAIL INN OUTN vsubs nfet_03v3 L=0.28U W=2U AS=0.42P AD=0.42P PS=2.42U PD=2.42U
* device instance $287 r0 *1 198.38,11.28 nfet
XM$287 OUTN INN TAIL vsubs nfet_03v3 L=0.28U W=2U AS=0.42P AD=0.42P PS=2.42U PD=2.42U
* device instance $288 r0 *1 199.08,11.28 nfet
XM$288 TAIL INN OUTN vsubs nfet_03v3 L=0.28U W=2U AS=0.42P AD=0.42P PS=2.42U PD=2.42U
* device instance $289 r0 *1 199.78,11.28 nfet
XM$289 OUTN INN TAIL vsubs nfet_03v3 L=0.28U W=2U AS=0.42P AD=0.42P PS=2.42U PD=2.42U
* device instance $290 r0 *1 200.48,11.28 nfet
XM$290 TAIL INN OUTN vsubs nfet_03v3 L=0.28U W=2U AS=0.42P AD=0.42P PS=2.42U PD=2.42U
* device instance $291 r0 *1 201.18,11.28 nfet
XM$291 OUTN INN TAIL vsubs nfet_03v3 L=0.28U W=2U AS=0.42P AD=0.42P PS=2.42U PD=2.42U
* device instance $292 r0 *1 201.88,11.28 nfet
XM$292 TAIL INN OUTN vsubs nfet_03v3 L=0.28U W=2U AS=0.42P AD=0.42P PS=2.42U PD=2.42U
* device instance $293 r0 *1 202.58,11.28 nfet
XM$293 OUTN INN TAIL vsubs nfet_03v3 L=0.28U W=2U AS=0.42P AD=0.42P PS=2.42U PD=2.42U
* device instance $294 r0 *1 203.28,11.28 nfet
XM$294 TAIL INN OUTN vsubs nfet_03v3 L=0.28U W=2U AS=0.42P AD=0.42P PS=2.42U PD=2.42U
* device instance $295 r0 *1 203.98,11.28 nfet
XM$295 OUTN INN TAIL vsubs nfet_03v3 L=0.28U W=2U AS=0.42P AD=0.42P PS=2.42U PD=2.42U
* device instance $296 r0 *1 204.68,11.28 nfet
XM$296 TAIL INN OUTN vsubs nfet_03v3 L=0.28U W=2U AS=0.42P AD=0.42P PS=2.42U PD=2.42U
* device instance $297 r0 *1 205.38,11.28 nfet
XM$297 OUTN INN TAIL vsubs nfet_03v3 L=0.28U W=2U AS=0.42P AD=0.42P PS=2.42U PD=2.42U
* device instance $298 r0 *1 206.08,11.28 nfet
XM$298 TAIL INN OUTN vsubs nfet_03v3 L=0.28U W=2U AS=0.42P AD=0.42P PS=2.42U PD=2.42U
* device instance $299 r0 *1 206.78,11.28 nfet
XM$299 OUTN INN TAIL vsubs nfet_03v3 L=0.28U W=2U AS=0.42P AD=0.42P PS=2.42U PD=2.42U
* device instance $300 r0 *1 207.48,11.28 nfet
XM$300 TAIL INN OUTN vsubs nfet_03v3 L=0.28U W=2U AS=0.42P AD=0.42P PS=2.42U PD=2.42U
* device instance $301 r0 *1 208.18,11.28 nfet
XM$301 OUTN INN TAIL vsubs nfet_03v3 L=0.28U W=2U AS=0.42P AD=0.42P PS=2.42U PD=2.42U
* device instance $302 r0 *1 208.88,11.28 nfet
XM$302 TAIL INN OUTN vsubs nfet_03v3 L=0.28U W=2U AS=0.42P AD=0.42P PS=2.42U PD=2.42U
* device instance $303 r0 *1 209.58,11.28 nfet
XM$303 OUTN INN TAIL vsubs nfet_03v3 L=0.28U W=2U AS=0.42P AD=0.42P PS=2.42U PD=2.42U
* device instance $304 r0 *1 210.28,11.28 nfet
XM$304 TAIL INN OUTN vsubs nfet_03v3 L=0.28U W=2U AS=0.42P AD=0.42P PS=2.42U PD=2.42U
* device instance $305 r0 *1 210.98,11.28 nfet
XM$305 OUTN INN TAIL vsubs nfet_03v3 L=0.28U W=2U AS=0.42P AD=0.42P PS=2.42U PD=2.42U
* device instance $306 r0 *1 211.68,11.28 nfet
XM$306 TAIL INN OUTN vsubs nfet_03v3 L=0.28U W=2U AS=0.42P AD=0.42P PS=2.42U PD=2.42U
* device instance $307 r0 *1 212.38,11.28 nfet
XM$307 OUTN INN TAIL vsubs nfet_03v3 L=0.28U W=2U AS=0.42P AD=0.42P PS=2.42U PD=2.42U
* device instance $308 r0 *1 213.08,11.28 nfet
XM$308 TAIL INN OUTN vsubs nfet_03v3 L=0.28U W=2U AS=0.42P AD=0.42P PS=2.42U PD=2.42U
* device instance $309 r0 *1 213.78,11.28 nfet
XM$309 OUTN INN TAIL vsubs nfet_03v3 L=0.28U W=2U AS=0.42P AD=0.42P PS=2.42U PD=2.42U
* device instance $310 r0 *1 214.48,11.28 nfet
XM$310 TAIL INN OUTN vsubs nfet_03v3 L=0.28U W=2U AS=0.42P AD=0.42P PS=2.42U PD=2.42U
* device instance $311 r0 *1 215.18,11.28 nfet
XM$311 OUTN INN TAIL vsubs nfet_03v3 L=0.28U W=2U AS=0.42P AD=0.42P PS=2.42U PD=2.42U
* device instance $312 r0 *1 215.88,11.28 nfet
XM$312 TAIL INN OUTN vsubs nfet_03v3 L=0.28U W=2U AS=0.42P AD=0.42P PS=2.42U PD=2.42U
* device instance $313 r0 *1 216.58,11.28 nfet
XM$313 OUTN INN TAIL vsubs nfet_03v3 L=0.28U W=2U AS=0.42P AD=0.42P PS=2.42U PD=2.42U
* device instance $314 r0 *1 217.28,11.28 nfet
XM$314 TAIL INN OUTN vsubs nfet_03v3 L=0.28U W=2U AS=0.42P AD=0.42P PS=2.42U PD=2.42U
* device instance $315 r0 *1 217.98,11.28 nfet
XM$315 OUTN INN TAIL vsubs nfet_03v3 L=0.28U W=2U AS=0.42P AD=0.42P PS=2.42U PD=2.42U
* device instance $316 r0 *1 218.68,11.28 nfet
XM$316 TAIL INN OUTN vsubs nfet_03v3 L=0.28U W=2U AS=0.42P AD=0.42P PS=2.42U PD=2.42U
* device instance $317 r0 *1 219.38,11.28 nfet
XM$317 OUTN INN TAIL vsubs nfet_03v3 L=0.28U W=2U AS=0.42P AD=0.42P PS=2.42U PD=2.42U
* device instance $318 r0 *1 220.08,11.28 nfet
XM$318 TAIL INN OUTN vsubs nfet_03v3 L=0.28U W=2U AS=0.42P AD=0.42P PS=2.42U PD=2.42U
* device instance $319 r0 *1 220.78,11.28 nfet
XM$319 OUTN INN TAIL vsubs nfet_03v3 L=0.28U W=2U AS=0.42P AD=0.42P PS=2.42U PD=2.42U
* device instance $320 r0 *1 221.48,11.28 nfet
XM$320 TAIL INN OUTN vsubs nfet_03v3 L=0.28U W=2U AS=0.42P AD=0.42P PS=2.42U PD=2.42U
* device instance $321 r0 *1 222.18,11.28 nfet
XM$321 OUTN INN TAIL vsubs nfet_03v3 L=0.28U W=2U AS=0.42P AD=0.42P PS=2.42U PD=2.42U
* device instance $322 r0 *1 222.88,11.28 nfet
XM$322 TAIL INN OUTN vsubs nfet_03v3 L=0.28U W=2U AS=0.42P AD=0.42P PS=2.42U PD=2.42U
* device instance $323 r0 *1 223.58,11.28 nfet
XM$323 OUTN INN TAIL vsubs nfet_03v3 L=0.28U W=2U AS=0.42P AD=0.42P PS=2.42U PD=2.42U
* device instance $324 r0 *1 224.28,11.28 nfet
XM$324 TAIL INN OUTN vsubs nfet_03v3 L=0.28U W=2U AS=0.42P AD=0.42P PS=2.42U PD=2.42U
* device instance $325 r0 *1 224.98,11.28 nfet
XM$325 OUTN INN TAIL vsubs nfet_03v3 L=0.28U W=2U AS=0.42P AD=0.42P PS=2.42U PD=2.42U
* device instance $326 r0 *1 225.68,11.28 nfet
XM$326 TAIL INN OUTN vsubs nfet_03v3 L=0.28U W=2U AS=0.42P AD=0.42P PS=2.42U PD=2.42U
* device instance $327 r0 *1 226.38,11.28 nfet
XM$327 OUTN INN TAIL vsubs nfet_03v3 L=0.28U W=2U AS=0.42P AD=0.42P PS=2.42U PD=2.42U
* device instance $328 r0 *1 227.08,11.28 nfet
XM$328 TAIL INN OUTN vsubs nfet_03v3 L=0.28U W=2U AS=0.42P AD=0.42P PS=2.42U PD=2.42U
* device instance $329 r0 *1 227.78,11.28 nfet
XM$329 OUTN INN TAIL vsubs nfet_03v3 L=0.28U W=2U AS=0.42P AD=0.42P PS=2.42U PD=2.42U
* device instance $330 r0 *1 228.48,11.28 nfet
XM$330 TAIL INN OUTN vsubs nfet_03v3 L=0.28U W=2U AS=0.42P AD=0.42P PS=2.42U PD=2.42U
* device instance $331 r0 *1 229.18,11.28 nfet
XM$331 OUTN INN TAIL vsubs nfet_03v3 L=0.28U W=2U AS=0.42P AD=0.42P PS=2.42U PD=2.42U
* device instance $332 r0 *1 229.88,11.28 nfet
XM$332 TAIL INN OUTN vsubs nfet_03v3 L=0.28U W=2U AS=0.42P AD=0.42P PS=2.42U PD=2.42U
* device instance $333 r0 *1 230.58,11.28 nfet
XM$333 OUTN INN TAIL vsubs nfet_03v3 L=0.28U W=2U AS=0.42P AD=0.42P PS=2.42U PD=2.42U
* device instance $334 r0 *1 231.28,11.28 nfet
XM$334 TAIL INN OUTN vsubs nfet_03v3 L=0.28U W=2U AS=0.42P AD=0.42P PS=2.42U PD=2.42U
* device instance $335 r0 *1 231.98,11.28 nfet
XM$335 OUTN INN TAIL vsubs nfet_03v3 L=0.28U W=2U AS=0.42P AD=0.42P PS=2.42U PD=2.42U
* device instance $336 r0 *1 232.68,11.28 nfet
XM$336 TAIL INN OUTN vsubs nfet_03v3 L=0.28U W=2U AS=0.42P AD=0.42P PS=2.42U PD=2.42U
* device instance $337 r0 *1 233.38,11.28 nfet
XM$337 OUTN INN TAIL vsubs nfet_03v3 L=0.28U W=2U AS=0.42P AD=0.42P PS=2.42U PD=2.42U
* device instance $338 r0 *1 234.08,11.28 nfet
XM$338 TAIL INN OUTN vsubs nfet_03v3 L=0.28U W=2U AS=0.42P AD=0.84P PS=2.42U PD=4.84U
.ENDS cml_driver_core
