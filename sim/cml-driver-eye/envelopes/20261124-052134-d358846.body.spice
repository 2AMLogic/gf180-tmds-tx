* cml-driver-eye -- whole-grid klt sim body (T1 item 5 envelope)
* GENERATED by sim/run_envelope.py from cml-driver-eye/testbench/tb.json, do not edit
* grid: 5 process corners x 3 temperatures x 3 supplies x 2 rates = 90 corners,
* swept in the request JSON (corners.process / temperature_c / params) over this one
* body; the .param lines below are the defaults each corner overrides with
* alterparam (nominal supply, the first declared rate, first declared temperature).
* analysis  : tran 10e-12 61e-9 0 20e-12
* DUT       : ../testbench/cml_driver_dut.spice (schematic, sha256 31f70faa38776fffc7635b6a78770cbc51f93dc29a78674161a1faaf2f4ffacb)
* testbench : ../testbench/cml_driver_eye.spice (sha256 d198d115e83d9c9189ae73b5c27cadf607e6e1fe7fef68a3109516c742da6c51)
.param vdd_nom=3.3
.param vdd_val=3.3
.param temp_c=-40.0
.param rate_val=742.5
.options reltol=1e-06
.options abstol=1e-09
.options vntol=1e-06
.options noinit
.include "../testbench/cml_driver_dut.spice"
.include "../testbench/cml_driver_eye.spice"
