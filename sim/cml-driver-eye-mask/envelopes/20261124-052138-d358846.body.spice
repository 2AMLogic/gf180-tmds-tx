* cml-driver-eye-mask -- whole-grid klt sim body (T1 item 5 envelope)
* GENERATED by sim/run_envelope.py from cml-driver-eye-mask/testbench/tb.json, do not edit
* grid: 5 process corners x 3 temperatures x 3 supplies = 45 corners at 742.5 Mbps/lane (one rate slice),
* swept in the request JSON (corners.process / temperature_c / params) over this one
* body; the .param lines below are the defaults each corner overrides with
* alterparam (nominal supply, the rate above, first declared temperature).
* analysis  : tran 20e-12 300e-9 0 40e-12 (TRANSIENT_WINDOWS override of the manifest's window)
* DUT       : ../../cml-driver-eye/testbench/cml_driver_dut.spice (schematic, sha256 31f70faa38776fffc7635b6a78770cbc51f93dc29a78674161a1faaf2f4ffacb)
* testbench : ../testbench/cml_driver_eye_mask.spice (sha256 f644d9082072e930cbf223ccebd0275b412657f5f051416d29f0ede98297dff8)
.param vdd_nom=3.3
.param vdd_val=3.3
.param temp_c=-40.0
.param rate_val=742.5
.options reltol=1e-06
.options abstol=1e-09
.options vntol=1e-06
.options noinit
.include "../../cml-driver-eye/testbench/cml_driver_dut.spice"
.include "../testbench/cml_driver_eye_mask.spice"
