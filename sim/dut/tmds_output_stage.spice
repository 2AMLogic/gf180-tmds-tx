* tmds_output_stage.spice -- shared DUT fragment: the DR-0003 custom final
* 2:1 multiplexer AND the CML output driver it feeds, as two callable
* .subckt cells.
*
* Two experiments share this one file, so that the mux and the driver they
* both instantiate are byte-identically the same cells:
*   sim/tmds-final-mux-eye/       -- the mux's own output, into the real
*                                    driver gate load
*   sim/cml-driver-eye-realmux/   -- sim/cml-driver-eye's driver rows,
*                                    re-measured with the real mux
*                                    substituted for its ideal source
*
* Derived MECHANICALLY from the two xschem-generated netlists, by the same
* recipe sim/cml-driver-eye/testbench/cml_driver_dut.spice documents:
*   1. strip the machine-local `sch_path` comment and the trailing `.end`
*      (the harness's DUT fragment rule, sim/harness/README.md: a DUT file
*      may not carry .control/.endc/.end/.lib/.temp);
*   2. un-comment the `**.subckt ... **.ends` markers xschem writes as
*      documentation-only comments when it netlists a top-level sheet.
*
* Regenerate with:
*   for c in tmds_final_mux cml_driver; do
*     tail -n +2 design/netlist/$c.spice | grep -v '^\.end$' \
*       | sed -E 's/^\*\*\.(subckt|ends)/.\1/'
*   done > sim/dut/tmds_output_stage.spice
* (then re-add this header).
*
.subckt tmds_final_mux OUTP OUTN D0P D0N D1P D1N CLKP CLKN VDD VSS
*.opin OUTP
*.opin OUTN
*.ipin D0P
*.ipin D0N
*.ipin D1P
*.ipin D1N
*.ipin CLKP
*.ipin CLKN
*.iopin VDD
*.iopin VSS
XRC TOP VDD VSS ppolyf_u r_width=20u r_length=2.65u m=1
XRLP OUTP TOP VSS ppolyf_u r_width=20u r_length=5.90u m=1
XRLN OUTN TOP VSS ppolyf_u r_width=20u r_length=5.90u m=1
XRREF IBIAS VDD VSS ppolyf_u r_width=2u r_length=24.8u m=1
XMU0P OUTP D0P SA VSS nfet_03v3 L=0.28u W=128u nf=64 ad=11.52p as=11.88p pd=139.52u ps=143.88u nrd=1.40625m nrs=1.40625m sa=0 sb=0
+ sd=0 m=1
XMU0N OUTN D0N SA VSS nfet_03v3 L=0.28u W=128u nf=64 ad=11.52p as=11.88p pd=139.52u ps=143.88u nrd=1.40625m nrs=1.40625m sa=0 sb=0
+ sd=0 m=1
XMU1P OUTP D1P SB VSS nfet_03v3 L=0.28u W=128u nf=64 ad=11.52p as=11.88p pd=139.52u ps=143.88u nrd=1.40625m nrs=1.40625m sa=0 sb=0
+ sd=0 m=1
XMU1N OUTN D1N SB VSS nfet_03v3 L=0.28u W=128u nf=64 ad=11.52p as=11.88p pd=139.52u ps=143.88u nrd=1.40625m nrs=1.40625m sa=0 sb=0
+ sd=0 m=1
XMCP SA CLKP TAIL VSS nfet_03v3 L=0.28u W=192u nf=96 ad=17.28p as=17.64p pd=209.28u ps=213.64u nrd=0.9375m nrs=0.9375m sa=0 sb=0
+ sd=0 m=1
XMCN SB CLKN TAIL VSS nfet_03v3 L=0.28u W=192u nf=96 ad=17.28p as=17.64p pd=209.28u ps=213.64u nrd=0.9375m nrs=0.9375m sa=0 sb=0
+ sd=0 m=1
XMT TAIL IBIAS VSS VSS nfet_03v3 L=0.5u W=20u nf=10 ad=1.8p as=2.16p pd=21.8u ps=26.16u nrd=9m nrs=9m sa=0 sb=0 sd=0 m=20
XMB IBIAS IBIAS VSS VSS nfet_03v3 L=0.5u W=20u nf=10 ad=1.8p as=2.16p pd=21.8u ps=26.16u nrd=9m nrs=9m sa=0 sb=0 sd=0 m=1
.ends
.subckt cml_driver OUTP OUTN INP INN IBIAS VSS
*.ipin INP
*.ipin INN
*.opin OUTP
*.opin OUTN
*.iopin IBIAS
*.iopin VSS
XM1 OUTP INP TAIL VSS nfet_03v3 L=0.28u W=128u nf=64 ad=11.52p as=11.88p pd=139.52u ps=143.88u nrd=1.40625m nrs=1.40625m sa=0 sb=0
+ sd=0 m=1
XM2 OUTN INN TAIL VSS nfet_03v3 L=0.28u W=128u nf=64 ad=11.52p as=11.88p pd=139.52u ps=143.88u nrd=1.40625m nrs=1.40625m sa=0 sb=0
+ sd=0 m=1
XMT TAIL IBIAS VSS VSS nfet_03v3 L=0.5u W=20u nf=10 ad=1.8p as=2.16p pd=21.8u ps=26.16u nrd=9m nrs=9m sa=0 sb=0 sd=0 m=20
XMB IBIAS IBIAS VSS VSS nfet_03v3 L=0.5u W=20u nf=10 ad=1.8p as=2.16p pd=21.8u ps=26.16u nrd=9m nrs=9m sa=0 sb=0 sd=0 m=1
.ends
