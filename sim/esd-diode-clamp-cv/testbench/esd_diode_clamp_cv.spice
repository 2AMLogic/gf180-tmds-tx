* ESD-clamp small-signal capacitance at the PAD node -- diode_nd2ps_06v0
* (issue #87, the VSS-side leg) and diode_pd2nw_06v0 (issue #312, the
* VDD-side leg). Diode counterpart of
* sim/esd-clamp-cv/testbench/esd_clamp_cv.spice (issue #12's GGNMOS study)
* -- same structure, same corner/bias axes, same AC-probe method, swapped
* onto the DR-0011-ratified diode clamp devices (nd2ps:
* layout/gds/gf180_tmds_pad_v2.gds, layout/scripts/gen_pad_v2.py; pd2nw:
* layout/gds/gf180_tmds_pad_ring_assembly.gds,
* layout/scripts/gen_pad_ring_assembly.py) instead of the GGNMOS
* gf180_tmds_pad_min.gds used.
*
* Eight independent branches: the nd2ps leg's three device sizes x two DC
* bias states (issue #87), plus the pd2nw leg at its one drawn size x two
* DC bias states (issue #312). Each branch is its own AC voltage source
* driving its own D-device instance, so all eight are electrically
* independent within one ngspice invocation -- no crosstalk, one PVT grid
* point measures the whole curve. The nd2ps branches put the anode at
* VSS=0 and probe the cathode; the pd2nw branches probe the anode and tie
* the cathode to the shared `vdd` rail, which is an AC ground (see
* "VDD-side pd2nw leg" below).
*
* Device / sizing convention (see design/esd-capacitance-budget.md Sec.1-3
* for the full derivation this reuses):
* -- "base": the aggregate device gf180_tmds_pad_v2.gds actually draws --
*    20 fingers in parallel, A=40um^2 P=120um total (verbatim from
*    layout/lvs/gf180_tmds_pad_v2.ref.spice's combined D-card).
* -- "w222"/"w444": the same HBM-sizing-window total widths
*    sim/esd-clamp-cv's GGNMOS study already swept (222/444 um, the
*    6/3 mA/um density readings from design/esd-capacitance-budget.md
*    Sec.2b), applied with that same document's own per-um-width-to-A/P
*    convention (A=W*1um, P=2*(W+1um)) so the two clamp families' numbers
*    are read on the same total-periphery x-axis. 667um (2 mA/um) is
*    reported by linear extrapolation, not simulated -- same choice
*    sim/esd-clamp-cv made, and justified the same way (Sec.3c: the curve
*    is linear in width since junction area/perimeter both scale linearly
*    with a fixed per-finger geometry).
*
* Bias (nd2ps branches): DC=0 is the "easy to quote" reference point.
* DC='vdd_val' reuses the harness's own supply-tolerance axis
* (2.97/3.30/3.63 V) as the TMDS operating-bias proxy, same justification
* sim/esd-clamp-cv's own testbench documents (DR-0002/DR-0006's
* DC-coupled, pad-tracks-rail topology) -- the cathode (PAD) sits at the
* positive operating bias, the anode (VSS) at 0, so this diode is
* reverse-biased at the operating point, matching its role as a
* diode-to-ground ESD clamp under normal (non-ESD) operation.
*
* VDD-side pd2nw leg (issue #312 -- the testbench half of issue #222):
* -- Device: diode_pd2nw_06v0, the VDD-side clamp issue #210 added to each
*    output pad of layout/gds/gf180_tmds_pad_ring_assembly.gds.
* -- Geometry: area=40p pj=120u -- 20 fingers at A=2um^2 P=6um each.
*    Source of the figure: the `_draw_vdd_clamp` docstring in
*    layout/scripts/gen_pad_ring_assembly.py, which states the design
*    intent ("the same area/periphery (A=40P P=120U at 20 fingers)" as the
*    VSS-side array). Independently corroborated by the extracted netlist
*    layout/gds/gf180_tmds_pad_ring_assembly_shorted.spice: 20
*    `diode_pd2nw_06v0 A=2P P=6U` cards per output pad net. That is the
*    same total area/periphery as the nd2ps "base" branches above, so the
*    two legs of one pad are read on the same geometry.
* -- Terminal orientation, and why the bias axis is INVERTED relative to
*    the nd2ps branches: in the layout the pd2nw anode is the pad net and
*    its cathode is the Nwell, tapped out to VDD (`D$379 OUTP|VSS VDD
*    diode_pd2nw_06v0` in the extracted netlist above). The nd2ps cards
*    are the other way round (anode=VSS, cathode=pad). Junction reverse
*    bias is therefore V(VDD)-V(pad) for pd2nw but V(pad)-0 for nd2ps, so
*    the two legs reach maximum capacitance at OPPOSITE ends of the
*    pad-voltage axis:
*
*      pad DC      nd2ps junction   nd2ps C   pd2nw junction   pd2nw C
*      0           0 V              max       vdd_val reverse  min
*      'vdd_val'   vdd_val reverse  min       0 V              max
*
*    The swept axis stays the PAD voltage for both legs, because the pad
*    total design/esd-capacitance-budget.md Sec.10.5a needs is
*    C_nd2ps(Vpad) + C_pd2nw(Vpad) at a common pad voltage. But the nd2ps
*    `_0v`/`_opv` suffixes name the JUNCTION state, and reusing them here
*    would silently mean the opposite column, so the pd2nw measures are
*    named after the PAD voltage explicitly:
*
*      cap_pd2nw_base_pad0v   pad at 0 V;       junction at vdd_val reverse
*      cap_pd2nw_base_padopv  pad at 'vdd_val'; junction at 0 V
*
*    `cap_pd2nw_base_padopv` is thus both the operating-bias grading point
*    (Sec.9.4's convention, per DR-0005's "preserve eye margin while
*    driving data") and this leg's own worst case -- unlike the nd2ps leg,
*    where those two are different points.
* -- NO RECORD YET. These two branches have never been run: no
*    diode_pd2nw_06v0 PVT record exists under ../records/, and Sec.10.5a's
*    pd2nw junction figure is still a bound rather than a measurement.
*    Running the grid and committing that record is issue #222; this file
*    only adds the probes it will measure.
*

* -- "base" (20 x 2.0/1.0um fingers, A=40um^2 P=120um total) --
Vpad_base_0v pad_base_0v 0 DC=0 AC=1
Dclamp_base_0v 0 pad_base_0v diode_nd2ps_06v0 area=40p pj=120u
Vpad_base_opv pad_base_opv 0 DC='vdd_val' AC=1
Dclamp_base_opv 0 pad_base_opv diode_nd2ps_06v0 area=40p pj=120u

* -- w222 (222um total periphery-equivalent width, 6 mA/um HBM density) --
Vpad_w222_0v pad_w222_0v 0 DC=0 AC=1
Dclamp_w222_0v 0 pad_w222_0v diode_nd2ps_06v0 area=222p pj=446u
Vpad_w222_opv pad_w222_opv 0 DC='vdd_val' AC=1
Dclamp_w222_opv 0 pad_w222_opv diode_nd2ps_06v0 area=222p pj=446u

* -- w444 (444um total periphery-equivalent width, 3 mA/um HBM density) --
Vpad_w444_0v pad_w444_0v 0 DC=0 AC=1
Dclamp_w444_0v 0 pad_w444_0v diode_nd2ps_06v0 area=444p pj=890u
Vpad_w444_opv pad_w444_opv 0 DC='vdd_val' AC=1
Dclamp_w444_opv 0 pad_w444_opv diode_nd2ps_06v0 area=444p pj=890u

* -- VDD rail for the pd2nw cathodes (issue #312) --
* DC only: AC defaults to 0, so `vdd` is an AC ground and each pd2nw
* branch's probe still reads only its own source's current. One shared
* node is correct and sufficient; a per-branch supply would add nothing.
Vsup vdd 0 DC='vdd_val'

* -- pd2nw "base" (20 x 2.0/1.0um fingers, A=40um^2 P=120um total -- the
*    issue #210 VDD-side clamp exactly as drawn). Suffixes name the PAD
*    voltage, not the junction bias; see the header. --
Vpad_pd2nw_base_pad0v pad_pd2nw_base_pad0v 0 DC=0 AC=1
Dclamp_pd2nw_base_pad0v pad_pd2nw_base_pad0v vdd diode_pd2nw_06v0 area=40p pj=120u
Vpad_pd2nw_base_padopv pad_pd2nw_base_padopv 0 DC='vdd_val' AC=1
Dclamp_pd2nw_base_padopv pad_pd2nw_base_padopv vdd diode_pd2nw_06v0 area=40p pj=120u
