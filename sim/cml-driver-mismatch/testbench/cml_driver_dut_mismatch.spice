* cml_driver_dut_mismatch.spice -- mismatch-capable DUT fragment for
* sim/cml-driver-mismatch/ (issue #23)
*
* Derived from sim/cml-driver-eye/testbench/cml_driver_dut.spice (itself
* generated from design/netlist/cml_driver.spice -- see that file's header
* for the xschem-export recipe) by ONE mechanical substitution, applied to
* all four transistors: the plain `nfet_03v3` model instantiation is
* replaced by `nfet_03v3_dss` -- gf180mcu's own statistical/mismatch
* subcircuit wrapper (sm141064.ngspice, e.g. line 745 of the gf180mcuD
* open_pdks c6d73a35f524070e85faff4a6a9eef49553ebc2b drop). `nfet_03v3_dss`
* wraps the identical `nfet_03v3` BSIM4 instance (same electrical device --
* same w/l/nf/ad/as/pd/ps/nrd/nrs/sa/sb/sd/m, passed straight through) with
* two small source/drain routing resistors (negligible for these device
* sizes) and gf180mcu's per-instance local-mismatch injection:
*
*     delvto = mis_vth * sw_stat_mismatch
*     mulu0  = 1 - mis_k * sw_stat_mismatch
*     mis_vth = agauss(0, var_vth, 1),  var_vth = 0.7071*par_vth*1e-6/sqrt(leff*weff)
*     mis_k   = agauss(0, var_k,   1),  var_k   = 0.7071*par_k  *1e-6/sqrt(leff*weff)
*     leff = l - par_l,  weff = par*(w - par_w)          (Pelgrom's law)
*
* `sw_stat_mismatch` is a global switch (design.ngspice default: 0 = off,
* matching every OTHER experiment in this repo, which never sets it and so
* never carries mismatch). The testbench (cml_driver_mismatch.spice) sets it
* to 1 for the samples this experiment's claim is about.
*
* `par` is NOT threaded into the underlying BSIM4 instance at all -- it only
* scales the Pelgrom area term above, so it can be varied to reflect the
* number of independently-mismatched unit elements *a given instance
* represents* without perturbing the instance's own real electrical w/l/nf/m
* (which set drive strength/current, unchanged from the original DUT).
* Exposed here as this subckt's own par_pair/par_tail/par_mirror parameters,
* defaulted to nf*m for each device -- the standard multi-finger/multi-copy
* mismatch-averaging convention (N parallel, uncorrelated unit elements
* average mismatch down by sqrt(N)) -- so a caller can override one (e.g.
* driving par_tail far below its default) to inject an artificially large,
* deterministic, seed-reproducible mismatch for a negative control, using
* gf180mcu's own unmodified mismatch machinery rather than a hand-rolled
* fault-injection mechanism. See sim/cml-driver-mismatch/run_mc.py.
*
* Every other device parameter, and the subckt's own I/O pinout, is
* byte-identical to sim/cml-driver-eye/testbench/cml_driver_dut.spice.
* NOT hand-edited beyond the substitution described above and the
* par_pair/par_tail/par_mirror parameterization -- regenerate by re-applying
* both to a fresh export of design/netlist/cml_driver.spice if the schematic
* changes.
*
.subckt cml_driver_mc OUTP OUTN INP INN IBIAS VSS par_pair=64 par_tail=200 par_mirror=10
*.ipin INP
*.ipin INN
*.opin OUTP
*.opin OUTN
*.iopin IBIAS
*.iopin VSS
XM1 OUTP INP TAIL VSS nfet_03v3_dss w=128u l=0.28u par='par_pair' nf=64 ad=11.52p as=11.88p pd=139.52u ps=143.88u nrd=1.40625m nrs=1.40625m sa=0 sb=0
+ sd=0 m=1
XM2 OUTN INN TAIL VSS nfet_03v3_dss w=128u l=0.28u par='par_pair' nf=64 ad=11.52p as=11.88p pd=139.52u ps=143.88u nrd=1.40625m nrs=1.40625m sa=0 sb=0
+ sd=0 m=1
XMT TAIL IBIAS VSS VSS nfet_03v3_dss w=20u l=0.5u par='par_tail' nf=10 ad=1.8p as=2.16p pd=21.8u ps=26.16u nrd=9m nrs=9m sa=0 sb=0 sd=0 m=20
XMB IBIAS IBIAS VSS VSS nfet_03v3_dss w=20u l=0.5u par='par_mirror' nf=10 ad=1.8p as=2.16p pd=21.8u ps=26.16u nrd=9m nrs=9m sa=0 sb=0 sd=0 m=1
.ends
