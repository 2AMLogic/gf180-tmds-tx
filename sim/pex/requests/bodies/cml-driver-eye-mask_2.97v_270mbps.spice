* cml-driver-eye-mask_2.97v_270mbps -- GENERATED by sim/pex/gen_requests.py, do not edit
* source bench : sim/cml-driver-eye-mask/testbench (manifest + netlist fragment)
* baked point  : vdd_val=2.97 V  rate_val=270 Mbps/lane
* corner grid  : 5 process corners x 3 temperatures in the request JSON (supply and rate are baked here: the bench's PWL stimuli expand parameter expressions at deck-parse time, so they cannot be alterparam-swept)
* DUT          : ../../gf180_tmds_pad_ring_assembly.spice (schematic leg; klt pex swaps this one include for the extracted netlist on the extracted leg)
.param vdd_nom=3.3
.param vdd_val=2.97
.param rate_val=270.0
.options abstol=1e-09
.options vntol=1e-06
.options noinit
* reltol: ngspice's default 1e-3, not this bench's 1e-6. With 1e-6 every
* tested Linux ngspice build collapses the transient at the FIRST stimulus
* edge (t = 9*tbit_s) once the DUT is this assembly (wrapper hierarchy);
* 1e-4 and 1e-5 collapse too, 1e-3 completes (ngspice 42 and 47, local and
* batch). Both pex legs share this body, so the schematic-vs-extracted
* delta is unaffected; the harness's own 1e-6 records stay authoritative.
.options reltol=1e-3
.include "../../gf180_tmds_pad_ring_assembly.spice"
* ---- shared DUT adapter (identical on both pex legs) ---------------
* The assembly's seven-pin boundary adapted to the six-pin `cml_driver`
* interface the eye benches instantiate. The X line below wires the
* assembly POSITIONALLY in the DUT's declared pin order (IBIAS INN INP OUTN OUTP VDD VSS)
* -- sim/pex/gen_requests.py --check asserts that order against the
* DUT header, so a same-count permutation fails the lint, and klt pex
* itself refuses a pin-order mismatch against the extraction.
* The assembly's VDD ring net (VDD-side clamp cathodes + Nwell tap) is
* held at the testbench core rail vdd_val by an ideal source inside the
* wrapper, since the six-pin boundary has no VDD pin -- the same adapter
* layout/sim/gf180_tmds_pad_ring_assembly_dut.spice documents.
.subckt cml_driver OUTP OUTN INP INN IBIAS VSS
vvdd_rail VDD 0 dc {vdd_val}
xcore IBIAS INN INP OUTN OUTP VDD VSS gf180_tmds_pad_ring_assembly
.ends

* ---- cml-driver-eye-mask netlist fragment, inlined verbatim --------------
* cml-driver-eye-mask -- GENERATED by sim/cml-driver-eye-mask/gen_testbench.py
* DO NOT HAND-EDIT. Re-run the generator and re-commit instead.
*
* Netlist FRAGMENT (sim/harness/README.md convention): the harness supplies
* the title, gf180mcu model .include/.lib, .temp, the DUT .include
* (cml_driver_dut.spice, shared with sim/cml-driver-eye/), .control/.endc/.end,
* and vdd_val/vdd_nom/temp_c/rate_val. See tb.json's "dut" key.
*
* METHODOLOGY: see this directory's gen_testbench.py module docstring for the
* full derivation. Summary: a PRBS7 (period 127, ITU-T O.150 x^7+x^6+1, all-ones
* seed) stimulus, preceded by a 20-bit rolling-history prefix (the
* sequence's own tail) so the measured 127-bit period starts fully settled, in
* turn preceded by a fixed 3-bit 1-0-1 calibration lead-in (ui_ref's
* reference, independent of the PRBS's own leading bits -- see gen_testbench.py).
* 150 bits driven in total, only the last 127 measured.
* Each UI is tiled into 8 equal phase bins (no fixed sampling instant
* assumed); per bin, the worst-case vertical eye opening is the gap between the
* minimum sampled level over every measured "1" bit and the maximum sampled
* level over every measured "0" bit, at that phase. DR-0013 row 6's combined
* height/width criterion is graded as a sliding 6-bin (0.75 UI) window
* eye-mask test in tb.json's measure section (eyemask_margin_c0/c1/c2).
*
* WHICH RAIL THE MANDATED +/-10 % SUPPLY AXIS IS APPLIED TO / INPUT MODEL:
* identical to sim/cml-driver-eye/testbench/cml_driver_eye.spice -- see that
* file's header for the full rationale (vdd_val is the on-chip 3.3 V core rail
* driving the DR-0003 final multiplexer's ideal-source model; avcc is the
* receiver's separate termination rail, held at nominal here since this
* bench's claim is row 6 only -- avcc sensitivity is sim/cml-driver-eye's job).

.param tbit_s   = '1e-6/rate_val'
.param avcc_nom = 3.3
.param rterm    = 50
.param iref     = 500u
.param vih      = '0.85*vdd_val'
.param vil      = '0.55*vdd_val'
.param tedge    = 80p

* ---- rails ---------------------------------------------------------------
vavcc   avcc   0 dc {avcc_nom}

* ---- stimulus: PRBS7 (see header) -----------------------------------------
vinp inp 0 PWL(0 '{vih}'
+ '{1*tbit_s}' '{vih}'
+ '{1*tbit_s+tedge}' '{vil}'
+ '{2*tbit_s}' '{vil}'
+ '{2*tbit_s+tedge}' '{vih}'
+ '{3*tbit_s}' '{vih}'
+ '{3*tbit_s+tedge}' '{vil}'
+ '{4*tbit_s}' '{vil}'
+ '{4*tbit_s+tedge}' '{vih}'
+ '{5*tbit_s}' '{vih}'
+ '{5*tbit_s+tedge}' '{vih}'
+ '{6*tbit_s}' '{vih}'
+ '{6*tbit_s+tedge}' '{vih}'
+ '{7*tbit_s}' '{vih}'
+ '{7*tbit_s+tedge}' '{vil}'
+ '{8*tbit_s}' '{vil}'
+ '{8*tbit_s+tedge}' '{vih}'
+ '{9*tbit_s}' '{vih}'
+ '{9*tbit_s+tedge}' '{vih}'
+ '{10*tbit_s}' '{vih}'
+ '{10*tbit_s+tedge}' '{vih}'
+ '{11*tbit_s}' '{vih}'
+ '{11*tbit_s+tedge}' '{vil}'
+ '{12*tbit_s}' '{vil}'
+ '{12*tbit_s+tedge}' '{vil}'
+ '{13*tbit_s}' '{vil}'
+ '{13*tbit_s+tedge}' '{vih}'
+ '{14*tbit_s}' '{vih}'
+ '{14*tbit_s+tedge}' '{vih}'
+ '{15*tbit_s}' '{vih}'
+ '{15*tbit_s+tedge}' '{vil}'
+ '{16*tbit_s}' '{vil}'
+ '{16*tbit_s+tedge}' '{vil}'
+ '{17*tbit_s}' '{vil}'
+ '{17*tbit_s+tedge}' '{vih}'
+ '{18*tbit_s}' '{vih}'
+ '{18*tbit_s+tedge}' '{vil}'
+ '{19*tbit_s}' '{vil}'
+ '{19*tbit_s+tedge}' '{vih}'
+ '{20*tbit_s}' '{vih}'
+ '{20*tbit_s+tedge}' '{vil}'
+ '{21*tbit_s}' '{vil}'
+ '{21*tbit_s+tedge}' '{vih}'
+ '{22*tbit_s}' '{vih}'
+ '{22*tbit_s+tedge}' '{vil}'
+ '{23*tbit_s}' '{vil}'
+ '{23*tbit_s+tedge}' '{vih}'
+ '{24*tbit_s}' '{vih}'
+ '{24*tbit_s+tedge}' '{vih}'
+ '{25*tbit_s}' '{vih}'
+ '{25*tbit_s+tedge}' '{vih}'
+ '{26*tbit_s}' '{vih}'
+ '{26*tbit_s+tedge}' '{vih}'
+ '{27*tbit_s}' '{vih}'
+ '{27*tbit_s+tedge}' '{vih}'
+ '{28*tbit_s}' '{vih}'
+ '{28*tbit_s+tedge}' '{vih}'
+ '{29*tbit_s}' '{vih}'
+ '{29*tbit_s+tedge}' '{vih}'
+ '{30*tbit_s}' '{vih}'
+ '{30*tbit_s+tedge}' '{vil}'
+ '{31*tbit_s}' '{vil}'
+ '{31*tbit_s+tedge}' '{vil}'
+ '{32*tbit_s}' '{vil}'
+ '{32*tbit_s+tedge}' '{vil}'
+ '{33*tbit_s}' '{vil}'
+ '{33*tbit_s+tedge}' '{vil}'
+ '{34*tbit_s}' '{vil}'
+ '{34*tbit_s+tedge}' '{vil}'
+ '{35*tbit_s}' '{vil}'
+ '{35*tbit_s+tedge}' '{vil}'
+ '{36*tbit_s}' '{vil}'
+ '{36*tbit_s+tedge}' '{vih}'
+ '{37*tbit_s}' '{vih}'
+ '{37*tbit_s+tedge}' '{vil}'
+ '{38*tbit_s}' '{vil}'
+ '{38*tbit_s+tedge}' '{vil}'
+ '{39*tbit_s}' '{vil}'
+ '{39*tbit_s+tedge}' '{vil}'
+ '{40*tbit_s}' '{vil}'
+ '{40*tbit_s+tedge}' '{vil}'
+ '{41*tbit_s}' '{vil}'
+ '{41*tbit_s+tedge}' '{vil}'
+ '{42*tbit_s}' '{vil}'
+ '{42*tbit_s+tedge}' '{vih}'
+ '{43*tbit_s}' '{vih}'
+ '{43*tbit_s+tedge}' '{vih}'
+ '{44*tbit_s}' '{vih}'
+ '{44*tbit_s+tedge}' '{vil}'
+ '{45*tbit_s}' '{vil}'
+ '{45*tbit_s+tedge}' '{vil}'
+ '{46*tbit_s}' '{vil}'
+ '{46*tbit_s+tedge}' '{vil}'
+ '{47*tbit_s}' '{vil}'
+ '{47*tbit_s+tedge}' '{vil}'
+ '{48*tbit_s}' '{vil}'
+ '{48*tbit_s+tedge}' '{vih}'
+ '{49*tbit_s}' '{vih}'
+ '{49*tbit_s+tedge}' '{vil}'
+ '{50*tbit_s}' '{vil}'
+ '{50*tbit_s+tedge}' '{vih}'
+ '{51*tbit_s}' '{vih}'
+ '{51*tbit_s+tedge}' '{vil}'
+ '{52*tbit_s}' '{vil}'
+ '{52*tbit_s+tedge}' '{vil}'
+ '{53*tbit_s}' '{vil}'
+ '{53*tbit_s+tedge}' '{vil}'
+ '{54*tbit_s}' '{vil}'
+ '{54*tbit_s+tedge}' '{vih}'
+ '{55*tbit_s}' '{vih}'
+ '{55*tbit_s+tedge}' '{vih}'
+ '{56*tbit_s}' '{vih}'
+ '{56*tbit_s+tedge}' '{vih}'
+ '{57*tbit_s}' '{vih}'
+ '{57*tbit_s+tedge}' '{vih}'
+ '{58*tbit_s}' '{vih}'
+ '{58*tbit_s+tedge}' '{vil}'
+ '{59*tbit_s}' '{vil}'
+ '{59*tbit_s+tedge}' '{vil}'
+ '{60*tbit_s}' '{vil}'
+ '{60*tbit_s+tedge}' '{vih}'
+ '{61*tbit_s}' '{vih}'
+ '{61*tbit_s+tedge}' '{vil}'
+ '{62*tbit_s}' '{vil}'
+ '{62*tbit_s+tedge}' '{vil}'
+ '{63*tbit_s}' '{vil}'
+ '{63*tbit_s+tedge}' '{vil}'
+ '{64*tbit_s}' '{vil}'
+ '{64*tbit_s+tedge}' '{vih}'
+ '{65*tbit_s}' '{vih}'
+ '{65*tbit_s+tedge}' '{vil}'
+ '{66*tbit_s}' '{vil}'
+ '{66*tbit_s+tedge}' '{vih}'
+ '{67*tbit_s}' '{vih}'
+ '{67*tbit_s+tedge}' '{vih}'
+ '{68*tbit_s}' '{vih}'
+ '{68*tbit_s+tedge}' '{vil}'
+ '{69*tbit_s}' '{vil}'
+ '{69*tbit_s+tedge}' '{vil}'
+ '{70*tbit_s}' '{vil}'
+ '{70*tbit_s+tedge}' '{vih}'
+ '{71*tbit_s}' '{vih}'
+ '{71*tbit_s+tedge}' '{vih}'
+ '{72*tbit_s}' '{vih}'
+ '{72*tbit_s+tedge}' '{vih}'
+ '{73*tbit_s}' '{vih}'
+ '{73*tbit_s+tedge}' '{vil}'
+ '{74*tbit_s}' '{vil}'
+ '{74*tbit_s+tedge}' '{vih}'
+ '{75*tbit_s}' '{vih}'
+ '{75*tbit_s+tedge}' '{vil}'
+ '{76*tbit_s}' '{vil}'
+ '{76*tbit_s+tedge}' '{vih}'
+ '{77*tbit_s}' '{vih}'
+ '{77*tbit_s+tedge}' '{vil}'
+ '{78*tbit_s}' '{vil}'
+ '{78*tbit_s+tedge}' '{vil}'
+ '{79*tbit_s}' '{vil}'
+ '{79*tbit_s+tedge}' '{vih}'
+ '{80*tbit_s}' '{vih}'
+ '{80*tbit_s+tedge}' '{vih}'
+ '{81*tbit_s}' '{vih}'
+ '{81*tbit_s+tedge}' '{vih}'
+ '{82*tbit_s}' '{vih}'
+ '{82*tbit_s+tedge}' '{vih}'
+ '{83*tbit_s}' '{vih}'
+ '{83*tbit_s+tedge}' '{vih}'
+ '{84*tbit_s}' '{vih}'
+ '{84*tbit_s+tedge}' '{vil}'
+ '{85*tbit_s}' '{vil}'
+ '{85*tbit_s+tedge}' '{vih}'
+ '{86*tbit_s}' '{vih}'
+ '{86*tbit_s+tedge}' '{vil}'
+ '{87*tbit_s}' '{vil}'
+ '{87*tbit_s+tedge}' '{vil}'
+ '{88*tbit_s}' '{vil}'
+ '{88*tbit_s+tedge}' '{vil}'
+ '{89*tbit_s}' '{vil}'
+ '{89*tbit_s+tedge}' '{vil}'
+ '{90*tbit_s}' '{vil}'
+ '{90*tbit_s+tedge}' '{vih}'
+ '{91*tbit_s}' '{vih}'
+ '{91*tbit_s+tedge}' '{vih}'
+ '{92*tbit_s}' '{vih}'
+ '{92*tbit_s+tedge}' '{vih}'
+ '{93*tbit_s}' '{vih}'
+ '{93*tbit_s+tedge}' '{vil}'
+ '{94*tbit_s}' '{vil}'
+ '{94*tbit_s+tedge}' '{vil}'
+ '{95*tbit_s}' '{vil}'
+ '{95*tbit_s+tedge}' '{vil}'
+ '{96*tbit_s}' '{vil}'
+ '{96*tbit_s+tedge}' '{vih}'
+ '{97*tbit_s}' '{vih}'
+ '{97*tbit_s+tedge}' '{vil}'
+ '{98*tbit_s}' '{vil}'
+ '{98*tbit_s+tedge}' '{vil}'
+ '{99*tbit_s}' '{vil}'
+ '{99*tbit_s+tedge}' '{vih}'
+ '{100*tbit_s}' '{vih}'
+ '{100*tbit_s+tedge}' '{vil}'
+ '{101*tbit_s}' '{vil}'
+ '{101*tbit_s+tedge}' '{vil}'
+ '{102*tbit_s}' '{vil}'
+ '{102*tbit_s+tedge}' '{vih}'
+ '{103*tbit_s}' '{vih}'
+ '{103*tbit_s+tedge}' '{vih}'
+ '{104*tbit_s}' '{vih}'
+ '{104*tbit_s+tedge}' '{vil}'
+ '{105*tbit_s}' '{vil}'
+ '{105*tbit_s+tedge}' '{vih}'
+ '{106*tbit_s}' '{vih}'
+ '{106*tbit_s+tedge}' '{vih}'
+ '{107*tbit_s}' '{vih}'
+ '{107*tbit_s+tedge}' '{vil}'
+ '{108*tbit_s}' '{vil}'
+ '{108*tbit_s+tedge}' '{vih}'
+ '{109*tbit_s}' '{vih}'
+ '{109*tbit_s+tedge}' '{vil}'
+ '{110*tbit_s}' '{vil}'
+ '{110*tbit_s+tedge}' '{vih}'
+ '{111*tbit_s}' '{vih}'
+ '{111*tbit_s+tedge}' '{vih}'
+ '{112*tbit_s}' '{vih}'
+ '{112*tbit_s+tedge}' '{vil}'
+ '{113*tbit_s}' '{vil}'
+ '{113*tbit_s+tedge}' '{vih}'
+ '{114*tbit_s}' '{vih}'
+ '{114*tbit_s+tedge}' '{vih}'
+ '{115*tbit_s}' '{vih}'
+ '{115*tbit_s+tedge}' '{vih}'
+ '{116*tbit_s}' '{vih}'
+ '{116*tbit_s+tedge}' '{vih}'
+ '{117*tbit_s}' '{vih}'
+ '{117*tbit_s+tedge}' '{vil}'
+ '{118*tbit_s}' '{vil}'
+ '{118*tbit_s+tedge}' '{vih}'
+ '{119*tbit_s}' '{vih}'
+ '{119*tbit_s+tedge}' '{vih}'
+ '{120*tbit_s}' '{vih}'
+ '{120*tbit_s+tedge}' '{vil}'
+ '{121*tbit_s}' '{vil}'
+ '{121*tbit_s+tedge}' '{vil}'
+ '{122*tbit_s}' '{vil}'
+ '{122*tbit_s+tedge}' '{vil}'
+ '{123*tbit_s}' '{vil}'
+ '{123*tbit_s+tedge}' '{vih}'
+ '{124*tbit_s}' '{vih}'
+ '{124*tbit_s+tedge}' '{vih}'
+ '{125*tbit_s}' '{vih}'
+ '{125*tbit_s+tedge}' '{vil}'
+ '{126*tbit_s}' '{vil}'
+ '{126*tbit_s+tedge}' '{vih}'
+ '{127*tbit_s}' '{vih}'
+ '{127*tbit_s+tedge}' '{vil}'
+ '{128*tbit_s}' '{vil}'
+ '{128*tbit_s+tedge}' '{vil}'
+ '{129*tbit_s}' '{vil}'
+ '{129*tbit_s+tedge}' '{vih}'
+ '{130*tbit_s}' '{vih}'
+ '{130*tbit_s+tedge}' '{vil}'
+ '{131*tbit_s}' '{vil}'
+ '{131*tbit_s+tedge}' '{vih}'
+ '{132*tbit_s}' '{vih}'
+ '{132*tbit_s+tedge}' '{vih}'
+ '{133*tbit_s}' '{vih}'
+ '{133*tbit_s+tedge}' '{vih}'
+ '{134*tbit_s}' '{vih}'
+ '{134*tbit_s+tedge}' '{vil}'
+ '{135*tbit_s}' '{vil}'
+ '{135*tbit_s+tedge}' '{vih}'
+ '{136*tbit_s}' '{vih}'
+ '{136*tbit_s+tedge}' '{vih}'
+ '{137*tbit_s}' '{vih}'
+ '{137*tbit_s+tedge}' '{vih}'
+ '{138*tbit_s}' '{vih}'
+ '{138*tbit_s+tedge}' '{vil}'
+ '{139*tbit_s}' '{vil}'
+ '{139*tbit_s+tedge}' '{vil}'
+ '{140*tbit_s}' '{vil}'
+ '{140*tbit_s+tedge}' '{vih}'
+ '{141*tbit_s}' '{vih}'
+ '{141*tbit_s+tedge}' '{vih}'
+ '{142*tbit_s}' '{vih}'
+ '{142*tbit_s+tedge}' '{vil}'
+ '{143*tbit_s}' '{vil}'
+ '{143*tbit_s+tedge}' '{vil}'
+ '{144*tbit_s}' '{vil}'
+ '{144*tbit_s+tedge}' '{vih}'
+ '{145*tbit_s}' '{vih}'
+ '{145*tbit_s+tedge}' '{vil}'
+ '{146*tbit_s}' '{vil}'
+ '{146*tbit_s+tedge}' '{vih}'
+ '{147*tbit_s}' '{vih}'
+ '{147*tbit_s+tedge}' '{vil}'
+ '{148*tbit_s}' '{vil}'
+ '{148*tbit_s+tedge}' '{vih}'
+ '{149*tbit_s}' '{vih}'
+ '{149*tbit_s+tedge}' '{vil}'
+ '{150*tbit_s}' '{vil}'
+ r=0 td=0)
vinn inn 0 PWL(0 '{vil}'
+ '{1*tbit_s}' '{vil}'
+ '{1*tbit_s+tedge}' '{vih}'
+ '{2*tbit_s}' '{vih}'
+ '{2*tbit_s+tedge}' '{vil}'
+ '{3*tbit_s}' '{vil}'
+ '{3*tbit_s+tedge}' '{vih}'
+ '{4*tbit_s}' '{vih}'
+ '{4*tbit_s+tedge}' '{vil}'
+ '{5*tbit_s}' '{vil}'
+ '{5*tbit_s+tedge}' '{vil}'
+ '{6*tbit_s}' '{vil}'
+ '{6*tbit_s+tedge}' '{vil}'
+ '{7*tbit_s}' '{vil}'
+ '{7*tbit_s+tedge}' '{vih}'
+ '{8*tbit_s}' '{vih}'
+ '{8*tbit_s+tedge}' '{vil}'
+ '{9*tbit_s}' '{vil}'
+ '{9*tbit_s+tedge}' '{vil}'
+ '{10*tbit_s}' '{vil}'
+ '{10*tbit_s+tedge}' '{vil}'
+ '{11*tbit_s}' '{vil}'
+ '{11*tbit_s+tedge}' '{vih}'
+ '{12*tbit_s}' '{vih}'
+ '{12*tbit_s+tedge}' '{vih}'
+ '{13*tbit_s}' '{vih}'
+ '{13*tbit_s+tedge}' '{vil}'
+ '{14*tbit_s}' '{vil}'
+ '{14*tbit_s+tedge}' '{vil}'
+ '{15*tbit_s}' '{vil}'
+ '{15*tbit_s+tedge}' '{vih}'
+ '{16*tbit_s}' '{vih}'
+ '{16*tbit_s+tedge}' '{vih}'
+ '{17*tbit_s}' '{vih}'
+ '{17*tbit_s+tedge}' '{vil}'
+ '{18*tbit_s}' '{vil}'
+ '{18*tbit_s+tedge}' '{vih}'
+ '{19*tbit_s}' '{vih}'
+ '{19*tbit_s+tedge}' '{vil}'
+ '{20*tbit_s}' '{vil}'
+ '{20*tbit_s+tedge}' '{vih}'
+ '{21*tbit_s}' '{vih}'
+ '{21*tbit_s+tedge}' '{vil}'
+ '{22*tbit_s}' '{vil}'
+ '{22*tbit_s+tedge}' '{vih}'
+ '{23*tbit_s}' '{vih}'
+ '{23*tbit_s+tedge}' '{vil}'
+ '{24*tbit_s}' '{vil}'
+ '{24*tbit_s+tedge}' '{vil}'
+ '{25*tbit_s}' '{vil}'
+ '{25*tbit_s+tedge}' '{vil}'
+ '{26*tbit_s}' '{vil}'
+ '{26*tbit_s+tedge}' '{vil}'
+ '{27*tbit_s}' '{vil}'
+ '{27*tbit_s+tedge}' '{vil}'
+ '{28*tbit_s}' '{vil}'
+ '{28*tbit_s+tedge}' '{vil}'
+ '{29*tbit_s}' '{vil}'
+ '{29*tbit_s+tedge}' '{vil}'
+ '{30*tbit_s}' '{vil}'
+ '{30*tbit_s+tedge}' '{vih}'
+ '{31*tbit_s}' '{vih}'
+ '{31*tbit_s+tedge}' '{vih}'
+ '{32*tbit_s}' '{vih}'
+ '{32*tbit_s+tedge}' '{vih}'
+ '{33*tbit_s}' '{vih}'
+ '{33*tbit_s+tedge}' '{vih}'
+ '{34*tbit_s}' '{vih}'
+ '{34*tbit_s+tedge}' '{vih}'
+ '{35*tbit_s}' '{vih}'
+ '{35*tbit_s+tedge}' '{vih}'
+ '{36*tbit_s}' '{vih}'
+ '{36*tbit_s+tedge}' '{vil}'
+ '{37*tbit_s}' '{vil}'
+ '{37*tbit_s+tedge}' '{vih}'
+ '{38*tbit_s}' '{vih}'
+ '{38*tbit_s+tedge}' '{vih}'
+ '{39*tbit_s}' '{vih}'
+ '{39*tbit_s+tedge}' '{vih}'
+ '{40*tbit_s}' '{vih}'
+ '{40*tbit_s+tedge}' '{vih}'
+ '{41*tbit_s}' '{vih}'
+ '{41*tbit_s+tedge}' '{vih}'
+ '{42*tbit_s}' '{vih}'
+ '{42*tbit_s+tedge}' '{vil}'
+ '{43*tbit_s}' '{vil}'
+ '{43*tbit_s+tedge}' '{vil}'
+ '{44*tbit_s}' '{vil}'
+ '{44*tbit_s+tedge}' '{vih}'
+ '{45*tbit_s}' '{vih}'
+ '{45*tbit_s+tedge}' '{vih}'
+ '{46*tbit_s}' '{vih}'
+ '{46*tbit_s+tedge}' '{vih}'
+ '{47*tbit_s}' '{vih}'
+ '{47*tbit_s+tedge}' '{vih}'
+ '{48*tbit_s}' '{vih}'
+ '{48*tbit_s+tedge}' '{vil}'
+ '{49*tbit_s}' '{vil}'
+ '{49*tbit_s+tedge}' '{vih}'
+ '{50*tbit_s}' '{vih}'
+ '{50*tbit_s+tedge}' '{vil}'
+ '{51*tbit_s}' '{vil}'
+ '{51*tbit_s+tedge}' '{vih}'
+ '{52*tbit_s}' '{vih}'
+ '{52*tbit_s+tedge}' '{vih}'
+ '{53*tbit_s}' '{vih}'
+ '{53*tbit_s+tedge}' '{vih}'
+ '{54*tbit_s}' '{vih}'
+ '{54*tbit_s+tedge}' '{vil}'
+ '{55*tbit_s}' '{vil}'
+ '{55*tbit_s+tedge}' '{vil}'
+ '{56*tbit_s}' '{vil}'
+ '{56*tbit_s+tedge}' '{vil}'
+ '{57*tbit_s}' '{vil}'
+ '{57*tbit_s+tedge}' '{vil}'
+ '{58*tbit_s}' '{vil}'
+ '{58*tbit_s+tedge}' '{vih}'
+ '{59*tbit_s}' '{vih}'
+ '{59*tbit_s+tedge}' '{vih}'
+ '{60*tbit_s}' '{vih}'
+ '{60*tbit_s+tedge}' '{vil}'
+ '{61*tbit_s}' '{vil}'
+ '{61*tbit_s+tedge}' '{vih}'
+ '{62*tbit_s}' '{vih}'
+ '{62*tbit_s+tedge}' '{vih}'
+ '{63*tbit_s}' '{vih}'
+ '{63*tbit_s+tedge}' '{vih}'
+ '{64*tbit_s}' '{vih}'
+ '{64*tbit_s+tedge}' '{vil}'
+ '{65*tbit_s}' '{vil}'
+ '{65*tbit_s+tedge}' '{vih}'
+ '{66*tbit_s}' '{vih}'
+ '{66*tbit_s+tedge}' '{vil}'
+ '{67*tbit_s}' '{vil}'
+ '{67*tbit_s+tedge}' '{vil}'
+ '{68*tbit_s}' '{vil}'
+ '{68*tbit_s+tedge}' '{vih}'
+ '{69*tbit_s}' '{vih}'
+ '{69*tbit_s+tedge}' '{vih}'
+ '{70*tbit_s}' '{vih}'
+ '{70*tbit_s+tedge}' '{vil}'
+ '{71*tbit_s}' '{vil}'
+ '{71*tbit_s+tedge}' '{vil}'
+ '{72*tbit_s}' '{vil}'
+ '{72*tbit_s+tedge}' '{vil}'
+ '{73*tbit_s}' '{vil}'
+ '{73*tbit_s+tedge}' '{vih}'
+ '{74*tbit_s}' '{vih}'
+ '{74*tbit_s+tedge}' '{vil}'
+ '{75*tbit_s}' '{vil}'
+ '{75*tbit_s+tedge}' '{vih}'
+ '{76*tbit_s}' '{vih}'
+ '{76*tbit_s+tedge}' '{vil}'
+ '{77*tbit_s}' '{vil}'
+ '{77*tbit_s+tedge}' '{vih}'
+ '{78*tbit_s}' '{vih}'
+ '{78*tbit_s+tedge}' '{vih}'
+ '{79*tbit_s}' '{vih}'
+ '{79*tbit_s+tedge}' '{vil}'
+ '{80*tbit_s}' '{vil}'
+ '{80*tbit_s+tedge}' '{vil}'
+ '{81*tbit_s}' '{vil}'
+ '{81*tbit_s+tedge}' '{vil}'
+ '{82*tbit_s}' '{vil}'
+ '{82*tbit_s+tedge}' '{vil}'
+ '{83*tbit_s}' '{vil}'
+ '{83*tbit_s+tedge}' '{vil}'
+ '{84*tbit_s}' '{vil}'
+ '{84*tbit_s+tedge}' '{vih}'
+ '{85*tbit_s}' '{vih}'
+ '{85*tbit_s+tedge}' '{vil}'
+ '{86*tbit_s}' '{vil}'
+ '{86*tbit_s+tedge}' '{vih}'
+ '{87*tbit_s}' '{vih}'
+ '{87*tbit_s+tedge}' '{vih}'
+ '{88*tbit_s}' '{vih}'
+ '{88*tbit_s+tedge}' '{vih}'
+ '{89*tbit_s}' '{vih}'
+ '{89*tbit_s+tedge}' '{vih}'
+ '{90*tbit_s}' '{vih}'
+ '{90*tbit_s+tedge}' '{vil}'
+ '{91*tbit_s}' '{vil}'
+ '{91*tbit_s+tedge}' '{vil}'
+ '{92*tbit_s}' '{vil}'
+ '{92*tbit_s+tedge}' '{vil}'
+ '{93*tbit_s}' '{vil}'
+ '{93*tbit_s+tedge}' '{vih}'
+ '{94*tbit_s}' '{vih}'
+ '{94*tbit_s+tedge}' '{vih}'
+ '{95*tbit_s}' '{vih}'
+ '{95*tbit_s+tedge}' '{vih}'
+ '{96*tbit_s}' '{vih}'
+ '{96*tbit_s+tedge}' '{vil}'
+ '{97*tbit_s}' '{vil}'
+ '{97*tbit_s+tedge}' '{vih}'
+ '{98*tbit_s}' '{vih}'
+ '{98*tbit_s+tedge}' '{vih}'
+ '{99*tbit_s}' '{vih}'
+ '{99*tbit_s+tedge}' '{vil}'
+ '{100*tbit_s}' '{vil}'
+ '{100*tbit_s+tedge}' '{vih}'
+ '{101*tbit_s}' '{vih}'
+ '{101*tbit_s+tedge}' '{vih}'
+ '{102*tbit_s}' '{vih}'
+ '{102*tbit_s+tedge}' '{vil}'
+ '{103*tbit_s}' '{vil}'
+ '{103*tbit_s+tedge}' '{vil}'
+ '{104*tbit_s}' '{vil}'
+ '{104*tbit_s+tedge}' '{vih}'
+ '{105*tbit_s}' '{vih}'
+ '{105*tbit_s+tedge}' '{vil}'
+ '{106*tbit_s}' '{vil}'
+ '{106*tbit_s+tedge}' '{vil}'
+ '{107*tbit_s}' '{vil}'
+ '{107*tbit_s+tedge}' '{vih}'
+ '{108*tbit_s}' '{vih}'
+ '{108*tbit_s+tedge}' '{vil}'
+ '{109*tbit_s}' '{vil}'
+ '{109*tbit_s+tedge}' '{vih}'
+ '{110*tbit_s}' '{vih}'
+ '{110*tbit_s+tedge}' '{vil}'
+ '{111*tbit_s}' '{vil}'
+ '{111*tbit_s+tedge}' '{vil}'
+ '{112*tbit_s}' '{vil}'
+ '{112*tbit_s+tedge}' '{vih}'
+ '{113*tbit_s}' '{vih}'
+ '{113*tbit_s+tedge}' '{vil}'
+ '{114*tbit_s}' '{vil}'
+ '{114*tbit_s+tedge}' '{vil}'
+ '{115*tbit_s}' '{vil}'
+ '{115*tbit_s+tedge}' '{vil}'
+ '{116*tbit_s}' '{vil}'
+ '{116*tbit_s+tedge}' '{vil}'
+ '{117*tbit_s}' '{vil}'
+ '{117*tbit_s+tedge}' '{vih}'
+ '{118*tbit_s}' '{vih}'
+ '{118*tbit_s+tedge}' '{vil}'
+ '{119*tbit_s}' '{vil}'
+ '{119*tbit_s+tedge}' '{vil}'
+ '{120*tbit_s}' '{vil}'
+ '{120*tbit_s+tedge}' '{vih}'
+ '{121*tbit_s}' '{vih}'
+ '{121*tbit_s+tedge}' '{vih}'
+ '{122*tbit_s}' '{vih}'
+ '{122*tbit_s+tedge}' '{vih}'
+ '{123*tbit_s}' '{vih}'
+ '{123*tbit_s+tedge}' '{vil}'
+ '{124*tbit_s}' '{vil}'
+ '{124*tbit_s+tedge}' '{vil}'
+ '{125*tbit_s}' '{vil}'
+ '{125*tbit_s+tedge}' '{vih}'
+ '{126*tbit_s}' '{vih}'
+ '{126*tbit_s+tedge}' '{vil}'
+ '{127*tbit_s}' '{vil}'
+ '{127*tbit_s+tedge}' '{vih}'
+ '{128*tbit_s}' '{vih}'
+ '{128*tbit_s+tedge}' '{vih}'
+ '{129*tbit_s}' '{vih}'
+ '{129*tbit_s+tedge}' '{vil}'
+ '{130*tbit_s}' '{vil}'
+ '{130*tbit_s+tedge}' '{vih}'
+ '{131*tbit_s}' '{vih}'
+ '{131*tbit_s+tedge}' '{vil}'
+ '{132*tbit_s}' '{vil}'
+ '{132*tbit_s+tedge}' '{vil}'
+ '{133*tbit_s}' '{vil}'
+ '{133*tbit_s+tedge}' '{vil}'
+ '{134*tbit_s}' '{vil}'
+ '{134*tbit_s+tedge}' '{vih}'
+ '{135*tbit_s}' '{vih}'
+ '{135*tbit_s+tedge}' '{vil}'
+ '{136*tbit_s}' '{vil}'
+ '{136*tbit_s+tedge}' '{vil}'
+ '{137*tbit_s}' '{vil}'
+ '{137*tbit_s+tedge}' '{vil}'
+ '{138*tbit_s}' '{vil}'
+ '{138*tbit_s+tedge}' '{vih}'
+ '{139*tbit_s}' '{vih}'
+ '{139*tbit_s+tedge}' '{vih}'
+ '{140*tbit_s}' '{vih}'
+ '{140*tbit_s+tedge}' '{vil}'
+ '{141*tbit_s}' '{vil}'
+ '{141*tbit_s+tedge}' '{vil}'
+ '{142*tbit_s}' '{vil}'
+ '{142*tbit_s+tedge}' '{vih}'
+ '{143*tbit_s}' '{vih}'
+ '{143*tbit_s+tedge}' '{vih}'
+ '{144*tbit_s}' '{vih}'
+ '{144*tbit_s+tedge}' '{vil}'
+ '{145*tbit_s}' '{vil}'
+ '{145*tbit_s+tedge}' '{vih}'
+ '{146*tbit_s}' '{vih}'
+ '{146*tbit_s+tedge}' '{vil}'
+ '{147*tbit_s}' '{vil}'
+ '{147*tbit_s+tedge}' '{vih}'
+ '{148*tbit_s}' '{vih}'
+ '{148*tbit_s+tedge}' '{vil}'
+ '{149*tbit_s}' '{vil}'
+ '{149*tbit_s+tedge}' '{vih}'
+ '{150*tbit_s}' '{vih}'
+ r=0 td=0)

* Differential input probe (VCVS workaround -- v(a,b) does not parse inside a
* meas TRIG/TARG expression; confirmed while developing sim/smoke-cml-pair).
einref inref 0 inp inn 1

* ---- 8 phase-tiled comb windows, split by measured bit value --------
* comb1_<i> is high (1) during phase bin i of every MEASURED bit equal to 1;
* comb0_<i> likewise for measured bits equal to 0. Only the measured
* 127-bit period (global bit index 23..149) is
* windowed -- the first 23 bits (3-bit calibration lead-in
* + 20-bit rolling-history prefix) are not measured.
vcomb1_0 comb1_0 0 PWL(0 0
+ '{(23+0.0)*tbit_s}' 0
+ '{(23+0.0)*tbit_s+2e-11}' 1
+ '{(23+0.125)*tbit_s-2e-11}' 1
+ '{(23+0.125)*tbit_s}' 0
+ '{(24+0.0)*tbit_s}' 0
+ '{(24+0.0)*tbit_s+2e-11}' 1
+ '{(24+0.125)*tbit_s-2e-11}' 1
+ '{(24+0.125)*tbit_s}' 0
+ '{(25+0.0)*tbit_s}' 0
+ '{(25+0.0)*tbit_s+2e-11}' 1
+ '{(25+0.125)*tbit_s-2e-11}' 1
+ '{(25+0.125)*tbit_s}' 0
+ '{(26+0.0)*tbit_s}' 0
+ '{(26+0.0)*tbit_s+2e-11}' 1
+ '{(26+0.125)*tbit_s-2e-11}' 1
+ '{(26+0.125)*tbit_s}' 0
+ '{(27+0.0)*tbit_s}' 0
+ '{(27+0.0)*tbit_s+2e-11}' 1
+ '{(27+0.125)*tbit_s-2e-11}' 1
+ '{(27+0.125)*tbit_s}' 0
+ '{(28+0.0)*tbit_s}' 0
+ '{(28+0.0)*tbit_s+2e-11}' 1
+ '{(28+0.125)*tbit_s-2e-11}' 1
+ '{(28+0.125)*tbit_s}' 0
+ '{(29+0.0)*tbit_s}' 0
+ '{(29+0.0)*tbit_s+2e-11}' 1
+ '{(29+0.125)*tbit_s-2e-11}' 1
+ '{(29+0.125)*tbit_s}' 0
+ '{(36+0.0)*tbit_s}' 0
+ '{(36+0.0)*tbit_s+2e-11}' 1
+ '{(36+0.125)*tbit_s-2e-11}' 1
+ '{(36+0.125)*tbit_s}' 0
+ '{(42+0.0)*tbit_s}' 0
+ '{(42+0.0)*tbit_s+2e-11}' 1
+ '{(42+0.125)*tbit_s-2e-11}' 1
+ '{(42+0.125)*tbit_s}' 0
+ '{(43+0.0)*tbit_s}' 0
+ '{(43+0.0)*tbit_s+2e-11}' 1
+ '{(43+0.125)*tbit_s-2e-11}' 1
+ '{(43+0.125)*tbit_s}' 0
+ '{(48+0.0)*tbit_s}' 0
+ '{(48+0.0)*tbit_s+2e-11}' 1
+ '{(48+0.125)*tbit_s-2e-11}' 1
+ '{(48+0.125)*tbit_s}' 0
+ '{(50+0.0)*tbit_s}' 0
+ '{(50+0.0)*tbit_s+2e-11}' 1
+ '{(50+0.125)*tbit_s-2e-11}' 1
+ '{(50+0.125)*tbit_s}' 0
+ '{(54+0.0)*tbit_s}' 0
+ '{(54+0.0)*tbit_s+2e-11}' 1
+ '{(54+0.125)*tbit_s-2e-11}' 1
+ '{(54+0.125)*tbit_s}' 0
+ '{(55+0.0)*tbit_s}' 0
+ '{(55+0.0)*tbit_s+2e-11}' 1
+ '{(55+0.125)*tbit_s-2e-11}' 1
+ '{(55+0.125)*tbit_s}' 0
+ '{(56+0.0)*tbit_s}' 0
+ '{(56+0.0)*tbit_s+2e-11}' 1
+ '{(56+0.125)*tbit_s-2e-11}' 1
+ '{(56+0.125)*tbit_s}' 0
+ '{(57+0.0)*tbit_s}' 0
+ '{(57+0.0)*tbit_s+2e-11}' 1
+ '{(57+0.125)*tbit_s-2e-11}' 1
+ '{(57+0.125)*tbit_s}' 0
+ '{(60+0.0)*tbit_s}' 0
+ '{(60+0.0)*tbit_s+2e-11}' 1
+ '{(60+0.125)*tbit_s-2e-11}' 1
+ '{(60+0.125)*tbit_s}' 0
+ '{(64+0.0)*tbit_s}' 0
+ '{(64+0.0)*tbit_s+2e-11}' 1
+ '{(64+0.125)*tbit_s-2e-11}' 1
+ '{(64+0.125)*tbit_s}' 0
+ '{(66+0.0)*tbit_s}' 0
+ '{(66+0.0)*tbit_s+2e-11}' 1
+ '{(66+0.125)*tbit_s-2e-11}' 1
+ '{(66+0.125)*tbit_s}' 0
+ '{(67+0.0)*tbit_s}' 0
+ '{(67+0.0)*tbit_s+2e-11}' 1
+ '{(67+0.125)*tbit_s-2e-11}' 1
+ '{(67+0.125)*tbit_s}' 0
+ '{(70+0.0)*tbit_s}' 0
+ '{(70+0.0)*tbit_s+2e-11}' 1
+ '{(70+0.125)*tbit_s-2e-11}' 1
+ '{(70+0.125)*tbit_s}' 0
+ '{(71+0.0)*tbit_s}' 0
+ '{(71+0.0)*tbit_s+2e-11}' 1
+ '{(71+0.125)*tbit_s-2e-11}' 1
+ '{(71+0.125)*tbit_s}' 0
+ '{(72+0.0)*tbit_s}' 0
+ '{(72+0.0)*tbit_s+2e-11}' 1
+ '{(72+0.125)*tbit_s-2e-11}' 1
+ '{(72+0.125)*tbit_s}' 0
+ '{(74+0.0)*tbit_s}' 0
+ '{(74+0.0)*tbit_s+2e-11}' 1
+ '{(74+0.125)*tbit_s-2e-11}' 1
+ '{(74+0.125)*tbit_s}' 0
+ '{(76+0.0)*tbit_s}' 0
+ '{(76+0.0)*tbit_s+2e-11}' 1
+ '{(76+0.125)*tbit_s-2e-11}' 1
+ '{(76+0.125)*tbit_s}' 0
+ '{(79+0.0)*tbit_s}' 0
+ '{(79+0.0)*tbit_s+2e-11}' 1
+ '{(79+0.125)*tbit_s-2e-11}' 1
+ '{(79+0.125)*tbit_s}' 0
+ '{(80+0.0)*tbit_s}' 0
+ '{(80+0.0)*tbit_s+2e-11}' 1
+ '{(80+0.125)*tbit_s-2e-11}' 1
+ '{(80+0.125)*tbit_s}' 0
+ '{(81+0.0)*tbit_s}' 0
+ '{(81+0.0)*tbit_s+2e-11}' 1
+ '{(81+0.125)*tbit_s-2e-11}' 1
+ '{(81+0.125)*tbit_s}' 0
+ '{(82+0.0)*tbit_s}' 0
+ '{(82+0.0)*tbit_s+2e-11}' 1
+ '{(82+0.125)*tbit_s-2e-11}' 1
+ '{(82+0.125)*tbit_s}' 0
+ '{(83+0.0)*tbit_s}' 0
+ '{(83+0.0)*tbit_s+2e-11}' 1
+ '{(83+0.125)*tbit_s-2e-11}' 1
+ '{(83+0.125)*tbit_s}' 0
+ '{(85+0.0)*tbit_s}' 0
+ '{(85+0.0)*tbit_s+2e-11}' 1
+ '{(85+0.125)*tbit_s-2e-11}' 1
+ '{(85+0.125)*tbit_s}' 0
+ '{(90+0.0)*tbit_s}' 0
+ '{(90+0.0)*tbit_s+2e-11}' 1
+ '{(90+0.125)*tbit_s-2e-11}' 1
+ '{(90+0.125)*tbit_s}' 0
+ '{(91+0.0)*tbit_s}' 0
+ '{(91+0.0)*tbit_s+2e-11}' 1
+ '{(91+0.125)*tbit_s-2e-11}' 1
+ '{(91+0.125)*tbit_s}' 0
+ '{(92+0.0)*tbit_s}' 0
+ '{(92+0.0)*tbit_s+2e-11}' 1
+ '{(92+0.125)*tbit_s-2e-11}' 1
+ '{(92+0.125)*tbit_s}' 0
+ '{(96+0.0)*tbit_s}' 0
+ '{(96+0.0)*tbit_s+2e-11}' 1
+ '{(96+0.125)*tbit_s-2e-11}' 1
+ '{(96+0.125)*tbit_s}' 0
+ '{(99+0.0)*tbit_s}' 0
+ '{(99+0.0)*tbit_s+2e-11}' 1
+ '{(99+0.125)*tbit_s-2e-11}' 1
+ '{(99+0.125)*tbit_s}' 0
+ '{(102+0.0)*tbit_s}' 0
+ '{(102+0.0)*tbit_s+2e-11}' 1
+ '{(102+0.125)*tbit_s-2e-11}' 1
+ '{(102+0.125)*tbit_s}' 0
+ '{(103+0.0)*tbit_s}' 0
+ '{(103+0.0)*tbit_s+2e-11}' 1
+ '{(103+0.125)*tbit_s-2e-11}' 1
+ '{(103+0.125)*tbit_s}' 0
+ '{(105+0.0)*tbit_s}' 0
+ '{(105+0.0)*tbit_s+2e-11}' 1
+ '{(105+0.125)*tbit_s-2e-11}' 1
+ '{(105+0.125)*tbit_s}' 0
+ '{(106+0.0)*tbit_s}' 0
+ '{(106+0.0)*tbit_s+2e-11}' 1
+ '{(106+0.125)*tbit_s-2e-11}' 1
+ '{(106+0.125)*tbit_s}' 0
+ '{(108+0.0)*tbit_s}' 0
+ '{(108+0.0)*tbit_s+2e-11}' 1
+ '{(108+0.125)*tbit_s-2e-11}' 1
+ '{(108+0.125)*tbit_s}' 0
+ '{(110+0.0)*tbit_s}' 0
+ '{(110+0.0)*tbit_s+2e-11}' 1
+ '{(110+0.125)*tbit_s-2e-11}' 1
+ '{(110+0.125)*tbit_s}' 0
+ '{(111+0.0)*tbit_s}' 0
+ '{(111+0.0)*tbit_s+2e-11}' 1
+ '{(111+0.125)*tbit_s-2e-11}' 1
+ '{(111+0.125)*tbit_s}' 0
+ '{(113+0.0)*tbit_s}' 0
+ '{(113+0.0)*tbit_s+2e-11}' 1
+ '{(113+0.125)*tbit_s-2e-11}' 1
+ '{(113+0.125)*tbit_s}' 0
+ '{(114+0.0)*tbit_s}' 0
+ '{(114+0.0)*tbit_s+2e-11}' 1
+ '{(114+0.125)*tbit_s-2e-11}' 1
+ '{(114+0.125)*tbit_s}' 0
+ '{(115+0.0)*tbit_s}' 0
+ '{(115+0.0)*tbit_s+2e-11}' 1
+ '{(115+0.125)*tbit_s-2e-11}' 1
+ '{(115+0.125)*tbit_s}' 0
+ '{(116+0.0)*tbit_s}' 0
+ '{(116+0.0)*tbit_s+2e-11}' 1
+ '{(116+0.125)*tbit_s-2e-11}' 1
+ '{(116+0.125)*tbit_s}' 0
+ '{(118+0.0)*tbit_s}' 0
+ '{(118+0.0)*tbit_s+2e-11}' 1
+ '{(118+0.125)*tbit_s-2e-11}' 1
+ '{(118+0.125)*tbit_s}' 0
+ '{(119+0.0)*tbit_s}' 0
+ '{(119+0.0)*tbit_s+2e-11}' 1
+ '{(119+0.125)*tbit_s-2e-11}' 1
+ '{(119+0.125)*tbit_s}' 0
+ '{(123+0.0)*tbit_s}' 0
+ '{(123+0.0)*tbit_s+2e-11}' 1
+ '{(123+0.125)*tbit_s-2e-11}' 1
+ '{(123+0.125)*tbit_s}' 0
+ '{(124+0.0)*tbit_s}' 0
+ '{(124+0.0)*tbit_s+2e-11}' 1
+ '{(124+0.125)*tbit_s-2e-11}' 1
+ '{(124+0.125)*tbit_s}' 0
+ '{(126+0.0)*tbit_s}' 0
+ '{(126+0.0)*tbit_s+2e-11}' 1
+ '{(126+0.125)*tbit_s-2e-11}' 1
+ '{(126+0.125)*tbit_s}' 0
+ '{(129+0.0)*tbit_s}' 0
+ '{(129+0.0)*tbit_s+2e-11}' 1
+ '{(129+0.125)*tbit_s-2e-11}' 1
+ '{(129+0.125)*tbit_s}' 0
+ '{(131+0.0)*tbit_s}' 0
+ '{(131+0.0)*tbit_s+2e-11}' 1
+ '{(131+0.125)*tbit_s-2e-11}' 1
+ '{(131+0.125)*tbit_s}' 0
+ '{(132+0.0)*tbit_s}' 0
+ '{(132+0.0)*tbit_s+2e-11}' 1
+ '{(132+0.125)*tbit_s-2e-11}' 1
+ '{(132+0.125)*tbit_s}' 0
+ '{(133+0.0)*tbit_s}' 0
+ '{(133+0.0)*tbit_s+2e-11}' 1
+ '{(133+0.125)*tbit_s-2e-11}' 1
+ '{(133+0.125)*tbit_s}' 0
+ '{(135+0.0)*tbit_s}' 0
+ '{(135+0.0)*tbit_s+2e-11}' 1
+ '{(135+0.125)*tbit_s-2e-11}' 1
+ '{(135+0.125)*tbit_s}' 0
+ '{(136+0.0)*tbit_s}' 0
+ '{(136+0.0)*tbit_s+2e-11}' 1
+ '{(136+0.125)*tbit_s-2e-11}' 1
+ '{(136+0.125)*tbit_s}' 0
+ '{(137+0.0)*tbit_s}' 0
+ '{(137+0.0)*tbit_s+2e-11}' 1
+ '{(137+0.125)*tbit_s-2e-11}' 1
+ '{(137+0.125)*tbit_s}' 0
+ '{(140+0.0)*tbit_s}' 0
+ '{(140+0.0)*tbit_s+2e-11}' 1
+ '{(140+0.125)*tbit_s-2e-11}' 1
+ '{(140+0.125)*tbit_s}' 0
+ '{(141+0.0)*tbit_s}' 0
+ '{(141+0.0)*tbit_s+2e-11}' 1
+ '{(141+0.125)*tbit_s-2e-11}' 1
+ '{(141+0.125)*tbit_s}' 0
+ '{(144+0.0)*tbit_s}' 0
+ '{(144+0.0)*tbit_s+2e-11}' 1
+ '{(144+0.125)*tbit_s-2e-11}' 1
+ '{(144+0.125)*tbit_s}' 0
+ '{(146+0.0)*tbit_s}' 0
+ '{(146+0.0)*tbit_s+2e-11}' 1
+ '{(146+0.125)*tbit_s-2e-11}' 1
+ '{(146+0.125)*tbit_s}' 0
+ '{(148+0.0)*tbit_s}' 0
+ '{(148+0.0)*tbit_s+2e-11}' 1
+ '{(148+0.125)*tbit_s-2e-11}' 1
+ '{(148+0.125)*tbit_s}' 0
+ )
vcomb0_0 comb0_0 0 PWL(0 0
+ '{(30+0.0)*tbit_s}' 0
+ '{(30+0.0)*tbit_s+2e-11}' 1
+ '{(30+0.125)*tbit_s-2e-11}' 1
+ '{(30+0.125)*tbit_s}' 0
+ '{(31+0.0)*tbit_s}' 0
+ '{(31+0.0)*tbit_s+2e-11}' 1
+ '{(31+0.125)*tbit_s-2e-11}' 1
+ '{(31+0.125)*tbit_s}' 0
+ '{(32+0.0)*tbit_s}' 0
+ '{(32+0.0)*tbit_s+2e-11}' 1
+ '{(32+0.125)*tbit_s-2e-11}' 1
+ '{(32+0.125)*tbit_s}' 0
+ '{(33+0.0)*tbit_s}' 0
+ '{(33+0.0)*tbit_s+2e-11}' 1
+ '{(33+0.125)*tbit_s-2e-11}' 1
+ '{(33+0.125)*tbit_s}' 0
+ '{(34+0.0)*tbit_s}' 0
+ '{(34+0.0)*tbit_s+2e-11}' 1
+ '{(34+0.125)*tbit_s-2e-11}' 1
+ '{(34+0.125)*tbit_s}' 0
+ '{(35+0.0)*tbit_s}' 0
+ '{(35+0.0)*tbit_s+2e-11}' 1
+ '{(35+0.125)*tbit_s-2e-11}' 1
+ '{(35+0.125)*tbit_s}' 0
+ '{(37+0.0)*tbit_s}' 0
+ '{(37+0.0)*tbit_s+2e-11}' 1
+ '{(37+0.125)*tbit_s-2e-11}' 1
+ '{(37+0.125)*tbit_s}' 0
+ '{(38+0.0)*tbit_s}' 0
+ '{(38+0.0)*tbit_s+2e-11}' 1
+ '{(38+0.125)*tbit_s-2e-11}' 1
+ '{(38+0.125)*tbit_s}' 0
+ '{(39+0.0)*tbit_s}' 0
+ '{(39+0.0)*tbit_s+2e-11}' 1
+ '{(39+0.125)*tbit_s-2e-11}' 1
+ '{(39+0.125)*tbit_s}' 0
+ '{(40+0.0)*tbit_s}' 0
+ '{(40+0.0)*tbit_s+2e-11}' 1
+ '{(40+0.125)*tbit_s-2e-11}' 1
+ '{(40+0.125)*tbit_s}' 0
+ '{(41+0.0)*tbit_s}' 0
+ '{(41+0.0)*tbit_s+2e-11}' 1
+ '{(41+0.125)*tbit_s-2e-11}' 1
+ '{(41+0.125)*tbit_s}' 0
+ '{(44+0.0)*tbit_s}' 0
+ '{(44+0.0)*tbit_s+2e-11}' 1
+ '{(44+0.125)*tbit_s-2e-11}' 1
+ '{(44+0.125)*tbit_s}' 0
+ '{(45+0.0)*tbit_s}' 0
+ '{(45+0.0)*tbit_s+2e-11}' 1
+ '{(45+0.125)*tbit_s-2e-11}' 1
+ '{(45+0.125)*tbit_s}' 0
+ '{(46+0.0)*tbit_s}' 0
+ '{(46+0.0)*tbit_s+2e-11}' 1
+ '{(46+0.125)*tbit_s-2e-11}' 1
+ '{(46+0.125)*tbit_s}' 0
+ '{(47+0.0)*tbit_s}' 0
+ '{(47+0.0)*tbit_s+2e-11}' 1
+ '{(47+0.125)*tbit_s-2e-11}' 1
+ '{(47+0.125)*tbit_s}' 0
+ '{(49+0.0)*tbit_s}' 0
+ '{(49+0.0)*tbit_s+2e-11}' 1
+ '{(49+0.125)*tbit_s-2e-11}' 1
+ '{(49+0.125)*tbit_s}' 0
+ '{(51+0.0)*tbit_s}' 0
+ '{(51+0.0)*tbit_s+2e-11}' 1
+ '{(51+0.125)*tbit_s-2e-11}' 1
+ '{(51+0.125)*tbit_s}' 0
+ '{(52+0.0)*tbit_s}' 0
+ '{(52+0.0)*tbit_s+2e-11}' 1
+ '{(52+0.125)*tbit_s-2e-11}' 1
+ '{(52+0.125)*tbit_s}' 0
+ '{(53+0.0)*tbit_s}' 0
+ '{(53+0.0)*tbit_s+2e-11}' 1
+ '{(53+0.125)*tbit_s-2e-11}' 1
+ '{(53+0.125)*tbit_s}' 0
+ '{(58+0.0)*tbit_s}' 0
+ '{(58+0.0)*tbit_s+2e-11}' 1
+ '{(58+0.125)*tbit_s-2e-11}' 1
+ '{(58+0.125)*tbit_s}' 0
+ '{(59+0.0)*tbit_s}' 0
+ '{(59+0.0)*tbit_s+2e-11}' 1
+ '{(59+0.125)*tbit_s-2e-11}' 1
+ '{(59+0.125)*tbit_s}' 0
+ '{(61+0.0)*tbit_s}' 0
+ '{(61+0.0)*tbit_s+2e-11}' 1
+ '{(61+0.125)*tbit_s-2e-11}' 1
+ '{(61+0.125)*tbit_s}' 0
+ '{(62+0.0)*tbit_s}' 0
+ '{(62+0.0)*tbit_s+2e-11}' 1
+ '{(62+0.125)*tbit_s-2e-11}' 1
+ '{(62+0.125)*tbit_s}' 0
+ '{(63+0.0)*tbit_s}' 0
+ '{(63+0.0)*tbit_s+2e-11}' 1
+ '{(63+0.125)*tbit_s-2e-11}' 1
+ '{(63+0.125)*tbit_s}' 0
+ '{(65+0.0)*tbit_s}' 0
+ '{(65+0.0)*tbit_s+2e-11}' 1
+ '{(65+0.125)*tbit_s-2e-11}' 1
+ '{(65+0.125)*tbit_s}' 0
+ '{(68+0.0)*tbit_s}' 0
+ '{(68+0.0)*tbit_s+2e-11}' 1
+ '{(68+0.125)*tbit_s-2e-11}' 1
+ '{(68+0.125)*tbit_s}' 0
+ '{(69+0.0)*tbit_s}' 0
+ '{(69+0.0)*tbit_s+2e-11}' 1
+ '{(69+0.125)*tbit_s-2e-11}' 1
+ '{(69+0.125)*tbit_s}' 0
+ '{(73+0.0)*tbit_s}' 0
+ '{(73+0.0)*tbit_s+2e-11}' 1
+ '{(73+0.125)*tbit_s-2e-11}' 1
+ '{(73+0.125)*tbit_s}' 0
+ '{(75+0.0)*tbit_s}' 0
+ '{(75+0.0)*tbit_s+2e-11}' 1
+ '{(75+0.125)*tbit_s-2e-11}' 1
+ '{(75+0.125)*tbit_s}' 0
+ '{(77+0.0)*tbit_s}' 0
+ '{(77+0.0)*tbit_s+2e-11}' 1
+ '{(77+0.125)*tbit_s-2e-11}' 1
+ '{(77+0.125)*tbit_s}' 0
+ '{(78+0.0)*tbit_s}' 0
+ '{(78+0.0)*tbit_s+2e-11}' 1
+ '{(78+0.125)*tbit_s-2e-11}' 1
+ '{(78+0.125)*tbit_s}' 0
+ '{(84+0.0)*tbit_s}' 0
+ '{(84+0.0)*tbit_s+2e-11}' 1
+ '{(84+0.125)*tbit_s-2e-11}' 1
+ '{(84+0.125)*tbit_s}' 0
+ '{(86+0.0)*tbit_s}' 0
+ '{(86+0.0)*tbit_s+2e-11}' 1
+ '{(86+0.125)*tbit_s-2e-11}' 1
+ '{(86+0.125)*tbit_s}' 0
+ '{(87+0.0)*tbit_s}' 0
+ '{(87+0.0)*tbit_s+2e-11}' 1
+ '{(87+0.125)*tbit_s-2e-11}' 1
+ '{(87+0.125)*tbit_s}' 0
+ '{(88+0.0)*tbit_s}' 0
+ '{(88+0.0)*tbit_s+2e-11}' 1
+ '{(88+0.125)*tbit_s-2e-11}' 1
+ '{(88+0.125)*tbit_s}' 0
+ '{(89+0.0)*tbit_s}' 0
+ '{(89+0.0)*tbit_s+2e-11}' 1
+ '{(89+0.125)*tbit_s-2e-11}' 1
+ '{(89+0.125)*tbit_s}' 0
+ '{(93+0.0)*tbit_s}' 0
+ '{(93+0.0)*tbit_s+2e-11}' 1
+ '{(93+0.125)*tbit_s-2e-11}' 1
+ '{(93+0.125)*tbit_s}' 0
+ '{(94+0.0)*tbit_s}' 0
+ '{(94+0.0)*tbit_s+2e-11}' 1
+ '{(94+0.125)*tbit_s-2e-11}' 1
+ '{(94+0.125)*tbit_s}' 0
+ '{(95+0.0)*tbit_s}' 0
+ '{(95+0.0)*tbit_s+2e-11}' 1
+ '{(95+0.125)*tbit_s-2e-11}' 1
+ '{(95+0.125)*tbit_s}' 0
+ '{(97+0.0)*tbit_s}' 0
+ '{(97+0.0)*tbit_s+2e-11}' 1
+ '{(97+0.125)*tbit_s-2e-11}' 1
+ '{(97+0.125)*tbit_s}' 0
+ '{(98+0.0)*tbit_s}' 0
+ '{(98+0.0)*tbit_s+2e-11}' 1
+ '{(98+0.125)*tbit_s-2e-11}' 1
+ '{(98+0.125)*tbit_s}' 0
+ '{(100+0.0)*tbit_s}' 0
+ '{(100+0.0)*tbit_s+2e-11}' 1
+ '{(100+0.125)*tbit_s-2e-11}' 1
+ '{(100+0.125)*tbit_s}' 0
+ '{(101+0.0)*tbit_s}' 0
+ '{(101+0.0)*tbit_s+2e-11}' 1
+ '{(101+0.125)*tbit_s-2e-11}' 1
+ '{(101+0.125)*tbit_s}' 0
+ '{(104+0.0)*tbit_s}' 0
+ '{(104+0.0)*tbit_s+2e-11}' 1
+ '{(104+0.125)*tbit_s-2e-11}' 1
+ '{(104+0.125)*tbit_s}' 0
+ '{(107+0.0)*tbit_s}' 0
+ '{(107+0.0)*tbit_s+2e-11}' 1
+ '{(107+0.125)*tbit_s-2e-11}' 1
+ '{(107+0.125)*tbit_s}' 0
+ '{(109+0.0)*tbit_s}' 0
+ '{(109+0.0)*tbit_s+2e-11}' 1
+ '{(109+0.125)*tbit_s-2e-11}' 1
+ '{(109+0.125)*tbit_s}' 0
+ '{(112+0.0)*tbit_s}' 0
+ '{(112+0.0)*tbit_s+2e-11}' 1
+ '{(112+0.125)*tbit_s-2e-11}' 1
+ '{(112+0.125)*tbit_s}' 0
+ '{(117+0.0)*tbit_s}' 0
+ '{(117+0.0)*tbit_s+2e-11}' 1
+ '{(117+0.125)*tbit_s-2e-11}' 1
+ '{(117+0.125)*tbit_s}' 0
+ '{(120+0.0)*tbit_s}' 0
+ '{(120+0.0)*tbit_s+2e-11}' 1
+ '{(120+0.125)*tbit_s-2e-11}' 1
+ '{(120+0.125)*tbit_s}' 0
+ '{(121+0.0)*tbit_s}' 0
+ '{(121+0.0)*tbit_s+2e-11}' 1
+ '{(121+0.125)*tbit_s-2e-11}' 1
+ '{(121+0.125)*tbit_s}' 0
+ '{(122+0.0)*tbit_s}' 0
+ '{(122+0.0)*tbit_s+2e-11}' 1
+ '{(122+0.125)*tbit_s-2e-11}' 1
+ '{(122+0.125)*tbit_s}' 0
+ '{(125+0.0)*tbit_s}' 0
+ '{(125+0.0)*tbit_s+2e-11}' 1
+ '{(125+0.125)*tbit_s-2e-11}' 1
+ '{(125+0.125)*tbit_s}' 0
+ '{(127+0.0)*tbit_s}' 0
+ '{(127+0.0)*tbit_s+2e-11}' 1
+ '{(127+0.125)*tbit_s-2e-11}' 1
+ '{(127+0.125)*tbit_s}' 0
+ '{(128+0.0)*tbit_s}' 0
+ '{(128+0.0)*tbit_s+2e-11}' 1
+ '{(128+0.125)*tbit_s-2e-11}' 1
+ '{(128+0.125)*tbit_s}' 0
+ '{(130+0.0)*tbit_s}' 0
+ '{(130+0.0)*tbit_s+2e-11}' 1
+ '{(130+0.125)*tbit_s-2e-11}' 1
+ '{(130+0.125)*tbit_s}' 0
+ '{(134+0.0)*tbit_s}' 0
+ '{(134+0.0)*tbit_s+2e-11}' 1
+ '{(134+0.125)*tbit_s-2e-11}' 1
+ '{(134+0.125)*tbit_s}' 0
+ '{(138+0.0)*tbit_s}' 0
+ '{(138+0.0)*tbit_s+2e-11}' 1
+ '{(138+0.125)*tbit_s-2e-11}' 1
+ '{(138+0.125)*tbit_s}' 0
+ '{(139+0.0)*tbit_s}' 0
+ '{(139+0.0)*tbit_s+2e-11}' 1
+ '{(139+0.125)*tbit_s-2e-11}' 1
+ '{(139+0.125)*tbit_s}' 0
+ '{(142+0.0)*tbit_s}' 0
+ '{(142+0.0)*tbit_s+2e-11}' 1
+ '{(142+0.125)*tbit_s-2e-11}' 1
+ '{(142+0.125)*tbit_s}' 0
+ '{(143+0.0)*tbit_s}' 0
+ '{(143+0.0)*tbit_s+2e-11}' 1
+ '{(143+0.125)*tbit_s-2e-11}' 1
+ '{(143+0.125)*tbit_s}' 0
+ '{(145+0.0)*tbit_s}' 0
+ '{(145+0.0)*tbit_s+2e-11}' 1
+ '{(145+0.125)*tbit_s-2e-11}' 1
+ '{(145+0.125)*tbit_s}' 0
+ '{(147+0.0)*tbit_s}' 0
+ '{(147+0.0)*tbit_s+2e-11}' 1
+ '{(147+0.125)*tbit_s-2e-11}' 1
+ '{(147+0.125)*tbit_s}' 0
+ '{(149+0.0)*tbit_s}' 0
+ '{(149+0.0)*tbit_s+2e-11}' 1
+ '{(149+0.125)*tbit_s-2e-11}' 1
+ '{(149+0.125)*tbit_s}' 0
+ )
vcomb1_1 comb1_1 0 PWL(0 0
+ '{(23+0.125)*tbit_s}' 0
+ '{(23+0.125)*tbit_s+2e-11}' 1
+ '{(23+0.25)*tbit_s-2e-11}' 1
+ '{(23+0.25)*tbit_s}' 0
+ '{(24+0.125)*tbit_s}' 0
+ '{(24+0.125)*tbit_s+2e-11}' 1
+ '{(24+0.25)*tbit_s-2e-11}' 1
+ '{(24+0.25)*tbit_s}' 0
+ '{(25+0.125)*tbit_s}' 0
+ '{(25+0.125)*tbit_s+2e-11}' 1
+ '{(25+0.25)*tbit_s-2e-11}' 1
+ '{(25+0.25)*tbit_s}' 0
+ '{(26+0.125)*tbit_s}' 0
+ '{(26+0.125)*tbit_s+2e-11}' 1
+ '{(26+0.25)*tbit_s-2e-11}' 1
+ '{(26+0.25)*tbit_s}' 0
+ '{(27+0.125)*tbit_s}' 0
+ '{(27+0.125)*tbit_s+2e-11}' 1
+ '{(27+0.25)*tbit_s-2e-11}' 1
+ '{(27+0.25)*tbit_s}' 0
+ '{(28+0.125)*tbit_s}' 0
+ '{(28+0.125)*tbit_s+2e-11}' 1
+ '{(28+0.25)*tbit_s-2e-11}' 1
+ '{(28+0.25)*tbit_s}' 0
+ '{(29+0.125)*tbit_s}' 0
+ '{(29+0.125)*tbit_s+2e-11}' 1
+ '{(29+0.25)*tbit_s-2e-11}' 1
+ '{(29+0.25)*tbit_s}' 0
+ '{(36+0.125)*tbit_s}' 0
+ '{(36+0.125)*tbit_s+2e-11}' 1
+ '{(36+0.25)*tbit_s-2e-11}' 1
+ '{(36+0.25)*tbit_s}' 0
+ '{(42+0.125)*tbit_s}' 0
+ '{(42+0.125)*tbit_s+2e-11}' 1
+ '{(42+0.25)*tbit_s-2e-11}' 1
+ '{(42+0.25)*tbit_s}' 0
+ '{(43+0.125)*tbit_s}' 0
+ '{(43+0.125)*tbit_s+2e-11}' 1
+ '{(43+0.25)*tbit_s-2e-11}' 1
+ '{(43+0.25)*tbit_s}' 0
+ '{(48+0.125)*tbit_s}' 0
+ '{(48+0.125)*tbit_s+2e-11}' 1
+ '{(48+0.25)*tbit_s-2e-11}' 1
+ '{(48+0.25)*tbit_s}' 0
+ '{(50+0.125)*tbit_s}' 0
+ '{(50+0.125)*tbit_s+2e-11}' 1
+ '{(50+0.25)*tbit_s-2e-11}' 1
+ '{(50+0.25)*tbit_s}' 0
+ '{(54+0.125)*tbit_s}' 0
+ '{(54+0.125)*tbit_s+2e-11}' 1
+ '{(54+0.25)*tbit_s-2e-11}' 1
+ '{(54+0.25)*tbit_s}' 0
+ '{(55+0.125)*tbit_s}' 0
+ '{(55+0.125)*tbit_s+2e-11}' 1
+ '{(55+0.25)*tbit_s-2e-11}' 1
+ '{(55+0.25)*tbit_s}' 0
+ '{(56+0.125)*tbit_s}' 0
+ '{(56+0.125)*tbit_s+2e-11}' 1
+ '{(56+0.25)*tbit_s-2e-11}' 1
+ '{(56+0.25)*tbit_s}' 0
+ '{(57+0.125)*tbit_s}' 0
+ '{(57+0.125)*tbit_s+2e-11}' 1
+ '{(57+0.25)*tbit_s-2e-11}' 1
+ '{(57+0.25)*tbit_s}' 0
+ '{(60+0.125)*tbit_s}' 0
+ '{(60+0.125)*tbit_s+2e-11}' 1
+ '{(60+0.25)*tbit_s-2e-11}' 1
+ '{(60+0.25)*tbit_s}' 0
+ '{(64+0.125)*tbit_s}' 0
+ '{(64+0.125)*tbit_s+2e-11}' 1
+ '{(64+0.25)*tbit_s-2e-11}' 1
+ '{(64+0.25)*tbit_s}' 0
+ '{(66+0.125)*tbit_s}' 0
+ '{(66+0.125)*tbit_s+2e-11}' 1
+ '{(66+0.25)*tbit_s-2e-11}' 1
+ '{(66+0.25)*tbit_s}' 0
+ '{(67+0.125)*tbit_s}' 0
+ '{(67+0.125)*tbit_s+2e-11}' 1
+ '{(67+0.25)*tbit_s-2e-11}' 1
+ '{(67+0.25)*tbit_s}' 0
+ '{(70+0.125)*tbit_s}' 0
+ '{(70+0.125)*tbit_s+2e-11}' 1
+ '{(70+0.25)*tbit_s-2e-11}' 1
+ '{(70+0.25)*tbit_s}' 0
+ '{(71+0.125)*tbit_s}' 0
+ '{(71+0.125)*tbit_s+2e-11}' 1
+ '{(71+0.25)*tbit_s-2e-11}' 1
+ '{(71+0.25)*tbit_s}' 0
+ '{(72+0.125)*tbit_s}' 0
+ '{(72+0.125)*tbit_s+2e-11}' 1
+ '{(72+0.25)*tbit_s-2e-11}' 1
+ '{(72+0.25)*tbit_s}' 0
+ '{(74+0.125)*tbit_s}' 0
+ '{(74+0.125)*tbit_s+2e-11}' 1
+ '{(74+0.25)*tbit_s-2e-11}' 1
+ '{(74+0.25)*tbit_s}' 0
+ '{(76+0.125)*tbit_s}' 0
+ '{(76+0.125)*tbit_s+2e-11}' 1
+ '{(76+0.25)*tbit_s-2e-11}' 1
+ '{(76+0.25)*tbit_s}' 0
+ '{(79+0.125)*tbit_s}' 0
+ '{(79+0.125)*tbit_s+2e-11}' 1
+ '{(79+0.25)*tbit_s-2e-11}' 1
+ '{(79+0.25)*tbit_s}' 0
+ '{(80+0.125)*tbit_s}' 0
+ '{(80+0.125)*tbit_s+2e-11}' 1
+ '{(80+0.25)*tbit_s-2e-11}' 1
+ '{(80+0.25)*tbit_s}' 0
+ '{(81+0.125)*tbit_s}' 0
+ '{(81+0.125)*tbit_s+2e-11}' 1
+ '{(81+0.25)*tbit_s-2e-11}' 1
+ '{(81+0.25)*tbit_s}' 0
+ '{(82+0.125)*tbit_s}' 0
+ '{(82+0.125)*tbit_s+2e-11}' 1
+ '{(82+0.25)*tbit_s-2e-11}' 1
+ '{(82+0.25)*tbit_s}' 0
+ '{(83+0.125)*tbit_s}' 0
+ '{(83+0.125)*tbit_s+2e-11}' 1
+ '{(83+0.25)*tbit_s-2e-11}' 1
+ '{(83+0.25)*tbit_s}' 0
+ '{(85+0.125)*tbit_s}' 0
+ '{(85+0.125)*tbit_s+2e-11}' 1
+ '{(85+0.25)*tbit_s-2e-11}' 1
+ '{(85+0.25)*tbit_s}' 0
+ '{(90+0.125)*tbit_s}' 0
+ '{(90+0.125)*tbit_s+2e-11}' 1
+ '{(90+0.25)*tbit_s-2e-11}' 1
+ '{(90+0.25)*tbit_s}' 0
+ '{(91+0.125)*tbit_s}' 0
+ '{(91+0.125)*tbit_s+2e-11}' 1
+ '{(91+0.25)*tbit_s-2e-11}' 1
+ '{(91+0.25)*tbit_s}' 0
+ '{(92+0.125)*tbit_s}' 0
+ '{(92+0.125)*tbit_s+2e-11}' 1
+ '{(92+0.25)*tbit_s-2e-11}' 1
+ '{(92+0.25)*tbit_s}' 0
+ '{(96+0.125)*tbit_s}' 0
+ '{(96+0.125)*tbit_s+2e-11}' 1
+ '{(96+0.25)*tbit_s-2e-11}' 1
+ '{(96+0.25)*tbit_s}' 0
+ '{(99+0.125)*tbit_s}' 0
+ '{(99+0.125)*tbit_s+2e-11}' 1
+ '{(99+0.25)*tbit_s-2e-11}' 1
+ '{(99+0.25)*tbit_s}' 0
+ '{(102+0.125)*tbit_s}' 0
+ '{(102+0.125)*tbit_s+2e-11}' 1
+ '{(102+0.25)*tbit_s-2e-11}' 1
+ '{(102+0.25)*tbit_s}' 0
+ '{(103+0.125)*tbit_s}' 0
+ '{(103+0.125)*tbit_s+2e-11}' 1
+ '{(103+0.25)*tbit_s-2e-11}' 1
+ '{(103+0.25)*tbit_s}' 0
+ '{(105+0.125)*tbit_s}' 0
+ '{(105+0.125)*tbit_s+2e-11}' 1
+ '{(105+0.25)*tbit_s-2e-11}' 1
+ '{(105+0.25)*tbit_s}' 0
+ '{(106+0.125)*tbit_s}' 0
+ '{(106+0.125)*tbit_s+2e-11}' 1
+ '{(106+0.25)*tbit_s-2e-11}' 1
+ '{(106+0.25)*tbit_s}' 0
+ '{(108+0.125)*tbit_s}' 0
+ '{(108+0.125)*tbit_s+2e-11}' 1
+ '{(108+0.25)*tbit_s-2e-11}' 1
+ '{(108+0.25)*tbit_s}' 0
+ '{(110+0.125)*tbit_s}' 0
+ '{(110+0.125)*tbit_s+2e-11}' 1
+ '{(110+0.25)*tbit_s-2e-11}' 1
+ '{(110+0.25)*tbit_s}' 0
+ '{(111+0.125)*tbit_s}' 0
+ '{(111+0.125)*tbit_s+2e-11}' 1
+ '{(111+0.25)*tbit_s-2e-11}' 1
+ '{(111+0.25)*tbit_s}' 0
+ '{(113+0.125)*tbit_s}' 0
+ '{(113+0.125)*tbit_s+2e-11}' 1
+ '{(113+0.25)*tbit_s-2e-11}' 1
+ '{(113+0.25)*tbit_s}' 0
+ '{(114+0.125)*tbit_s}' 0
+ '{(114+0.125)*tbit_s+2e-11}' 1
+ '{(114+0.25)*tbit_s-2e-11}' 1
+ '{(114+0.25)*tbit_s}' 0
+ '{(115+0.125)*tbit_s}' 0
+ '{(115+0.125)*tbit_s+2e-11}' 1
+ '{(115+0.25)*tbit_s-2e-11}' 1
+ '{(115+0.25)*tbit_s}' 0
+ '{(116+0.125)*tbit_s}' 0
+ '{(116+0.125)*tbit_s+2e-11}' 1
+ '{(116+0.25)*tbit_s-2e-11}' 1
+ '{(116+0.25)*tbit_s}' 0
+ '{(118+0.125)*tbit_s}' 0
+ '{(118+0.125)*tbit_s+2e-11}' 1
+ '{(118+0.25)*tbit_s-2e-11}' 1
+ '{(118+0.25)*tbit_s}' 0
+ '{(119+0.125)*tbit_s}' 0
+ '{(119+0.125)*tbit_s+2e-11}' 1
+ '{(119+0.25)*tbit_s-2e-11}' 1
+ '{(119+0.25)*tbit_s}' 0
+ '{(123+0.125)*tbit_s}' 0
+ '{(123+0.125)*tbit_s+2e-11}' 1
+ '{(123+0.25)*tbit_s-2e-11}' 1
+ '{(123+0.25)*tbit_s}' 0
+ '{(124+0.125)*tbit_s}' 0
+ '{(124+0.125)*tbit_s+2e-11}' 1
+ '{(124+0.25)*tbit_s-2e-11}' 1
+ '{(124+0.25)*tbit_s}' 0
+ '{(126+0.125)*tbit_s}' 0
+ '{(126+0.125)*tbit_s+2e-11}' 1
+ '{(126+0.25)*tbit_s-2e-11}' 1
+ '{(126+0.25)*tbit_s}' 0
+ '{(129+0.125)*tbit_s}' 0
+ '{(129+0.125)*tbit_s+2e-11}' 1
+ '{(129+0.25)*tbit_s-2e-11}' 1
+ '{(129+0.25)*tbit_s}' 0
+ '{(131+0.125)*tbit_s}' 0
+ '{(131+0.125)*tbit_s+2e-11}' 1
+ '{(131+0.25)*tbit_s-2e-11}' 1
+ '{(131+0.25)*tbit_s}' 0
+ '{(132+0.125)*tbit_s}' 0
+ '{(132+0.125)*tbit_s+2e-11}' 1
+ '{(132+0.25)*tbit_s-2e-11}' 1
+ '{(132+0.25)*tbit_s}' 0
+ '{(133+0.125)*tbit_s}' 0
+ '{(133+0.125)*tbit_s+2e-11}' 1
+ '{(133+0.25)*tbit_s-2e-11}' 1
+ '{(133+0.25)*tbit_s}' 0
+ '{(135+0.125)*tbit_s}' 0
+ '{(135+0.125)*tbit_s+2e-11}' 1
+ '{(135+0.25)*tbit_s-2e-11}' 1
+ '{(135+0.25)*tbit_s}' 0
+ '{(136+0.125)*tbit_s}' 0
+ '{(136+0.125)*tbit_s+2e-11}' 1
+ '{(136+0.25)*tbit_s-2e-11}' 1
+ '{(136+0.25)*tbit_s}' 0
+ '{(137+0.125)*tbit_s}' 0
+ '{(137+0.125)*tbit_s+2e-11}' 1
+ '{(137+0.25)*tbit_s-2e-11}' 1
+ '{(137+0.25)*tbit_s}' 0
+ '{(140+0.125)*tbit_s}' 0
+ '{(140+0.125)*tbit_s+2e-11}' 1
+ '{(140+0.25)*tbit_s-2e-11}' 1
+ '{(140+0.25)*tbit_s}' 0
+ '{(141+0.125)*tbit_s}' 0
+ '{(141+0.125)*tbit_s+2e-11}' 1
+ '{(141+0.25)*tbit_s-2e-11}' 1
+ '{(141+0.25)*tbit_s}' 0
+ '{(144+0.125)*tbit_s}' 0
+ '{(144+0.125)*tbit_s+2e-11}' 1
+ '{(144+0.25)*tbit_s-2e-11}' 1
+ '{(144+0.25)*tbit_s}' 0
+ '{(146+0.125)*tbit_s}' 0
+ '{(146+0.125)*tbit_s+2e-11}' 1
+ '{(146+0.25)*tbit_s-2e-11}' 1
+ '{(146+0.25)*tbit_s}' 0
+ '{(148+0.125)*tbit_s}' 0
+ '{(148+0.125)*tbit_s+2e-11}' 1
+ '{(148+0.25)*tbit_s-2e-11}' 1
+ '{(148+0.25)*tbit_s}' 0
+ )
vcomb0_1 comb0_1 0 PWL(0 0
+ '{(30+0.125)*tbit_s}' 0
+ '{(30+0.125)*tbit_s+2e-11}' 1
+ '{(30+0.25)*tbit_s-2e-11}' 1
+ '{(30+0.25)*tbit_s}' 0
+ '{(31+0.125)*tbit_s}' 0
+ '{(31+0.125)*tbit_s+2e-11}' 1
+ '{(31+0.25)*tbit_s-2e-11}' 1
+ '{(31+0.25)*tbit_s}' 0
+ '{(32+0.125)*tbit_s}' 0
+ '{(32+0.125)*tbit_s+2e-11}' 1
+ '{(32+0.25)*tbit_s-2e-11}' 1
+ '{(32+0.25)*tbit_s}' 0
+ '{(33+0.125)*tbit_s}' 0
+ '{(33+0.125)*tbit_s+2e-11}' 1
+ '{(33+0.25)*tbit_s-2e-11}' 1
+ '{(33+0.25)*tbit_s}' 0
+ '{(34+0.125)*tbit_s}' 0
+ '{(34+0.125)*tbit_s+2e-11}' 1
+ '{(34+0.25)*tbit_s-2e-11}' 1
+ '{(34+0.25)*tbit_s}' 0
+ '{(35+0.125)*tbit_s}' 0
+ '{(35+0.125)*tbit_s+2e-11}' 1
+ '{(35+0.25)*tbit_s-2e-11}' 1
+ '{(35+0.25)*tbit_s}' 0
+ '{(37+0.125)*tbit_s}' 0
+ '{(37+0.125)*tbit_s+2e-11}' 1
+ '{(37+0.25)*tbit_s-2e-11}' 1
+ '{(37+0.25)*tbit_s}' 0
+ '{(38+0.125)*tbit_s}' 0
+ '{(38+0.125)*tbit_s+2e-11}' 1
+ '{(38+0.25)*tbit_s-2e-11}' 1
+ '{(38+0.25)*tbit_s}' 0
+ '{(39+0.125)*tbit_s}' 0
+ '{(39+0.125)*tbit_s+2e-11}' 1
+ '{(39+0.25)*tbit_s-2e-11}' 1
+ '{(39+0.25)*tbit_s}' 0
+ '{(40+0.125)*tbit_s}' 0
+ '{(40+0.125)*tbit_s+2e-11}' 1
+ '{(40+0.25)*tbit_s-2e-11}' 1
+ '{(40+0.25)*tbit_s}' 0
+ '{(41+0.125)*tbit_s}' 0
+ '{(41+0.125)*tbit_s+2e-11}' 1
+ '{(41+0.25)*tbit_s-2e-11}' 1
+ '{(41+0.25)*tbit_s}' 0
+ '{(44+0.125)*tbit_s}' 0
+ '{(44+0.125)*tbit_s+2e-11}' 1
+ '{(44+0.25)*tbit_s-2e-11}' 1
+ '{(44+0.25)*tbit_s}' 0
+ '{(45+0.125)*tbit_s}' 0
+ '{(45+0.125)*tbit_s+2e-11}' 1
+ '{(45+0.25)*tbit_s-2e-11}' 1
+ '{(45+0.25)*tbit_s}' 0
+ '{(46+0.125)*tbit_s}' 0
+ '{(46+0.125)*tbit_s+2e-11}' 1
+ '{(46+0.25)*tbit_s-2e-11}' 1
+ '{(46+0.25)*tbit_s}' 0
+ '{(47+0.125)*tbit_s}' 0
+ '{(47+0.125)*tbit_s+2e-11}' 1
+ '{(47+0.25)*tbit_s-2e-11}' 1
+ '{(47+0.25)*tbit_s}' 0
+ '{(49+0.125)*tbit_s}' 0
+ '{(49+0.125)*tbit_s+2e-11}' 1
+ '{(49+0.25)*tbit_s-2e-11}' 1
+ '{(49+0.25)*tbit_s}' 0
+ '{(51+0.125)*tbit_s}' 0
+ '{(51+0.125)*tbit_s+2e-11}' 1
+ '{(51+0.25)*tbit_s-2e-11}' 1
+ '{(51+0.25)*tbit_s}' 0
+ '{(52+0.125)*tbit_s}' 0
+ '{(52+0.125)*tbit_s+2e-11}' 1
+ '{(52+0.25)*tbit_s-2e-11}' 1
+ '{(52+0.25)*tbit_s}' 0
+ '{(53+0.125)*tbit_s}' 0
+ '{(53+0.125)*tbit_s+2e-11}' 1
+ '{(53+0.25)*tbit_s-2e-11}' 1
+ '{(53+0.25)*tbit_s}' 0
+ '{(58+0.125)*tbit_s}' 0
+ '{(58+0.125)*tbit_s+2e-11}' 1
+ '{(58+0.25)*tbit_s-2e-11}' 1
+ '{(58+0.25)*tbit_s}' 0
+ '{(59+0.125)*tbit_s}' 0
+ '{(59+0.125)*tbit_s+2e-11}' 1
+ '{(59+0.25)*tbit_s-2e-11}' 1
+ '{(59+0.25)*tbit_s}' 0
+ '{(61+0.125)*tbit_s}' 0
+ '{(61+0.125)*tbit_s+2e-11}' 1
+ '{(61+0.25)*tbit_s-2e-11}' 1
+ '{(61+0.25)*tbit_s}' 0
+ '{(62+0.125)*tbit_s}' 0
+ '{(62+0.125)*tbit_s+2e-11}' 1
+ '{(62+0.25)*tbit_s-2e-11}' 1
+ '{(62+0.25)*tbit_s}' 0
+ '{(63+0.125)*tbit_s}' 0
+ '{(63+0.125)*tbit_s+2e-11}' 1
+ '{(63+0.25)*tbit_s-2e-11}' 1
+ '{(63+0.25)*tbit_s}' 0
+ '{(65+0.125)*tbit_s}' 0
+ '{(65+0.125)*tbit_s+2e-11}' 1
+ '{(65+0.25)*tbit_s-2e-11}' 1
+ '{(65+0.25)*tbit_s}' 0
+ '{(68+0.125)*tbit_s}' 0
+ '{(68+0.125)*tbit_s+2e-11}' 1
+ '{(68+0.25)*tbit_s-2e-11}' 1
+ '{(68+0.25)*tbit_s}' 0
+ '{(69+0.125)*tbit_s}' 0
+ '{(69+0.125)*tbit_s+2e-11}' 1
+ '{(69+0.25)*tbit_s-2e-11}' 1
+ '{(69+0.25)*tbit_s}' 0
+ '{(73+0.125)*tbit_s}' 0
+ '{(73+0.125)*tbit_s+2e-11}' 1
+ '{(73+0.25)*tbit_s-2e-11}' 1
+ '{(73+0.25)*tbit_s}' 0
+ '{(75+0.125)*tbit_s}' 0
+ '{(75+0.125)*tbit_s+2e-11}' 1
+ '{(75+0.25)*tbit_s-2e-11}' 1
+ '{(75+0.25)*tbit_s}' 0
+ '{(77+0.125)*tbit_s}' 0
+ '{(77+0.125)*tbit_s+2e-11}' 1
+ '{(77+0.25)*tbit_s-2e-11}' 1
+ '{(77+0.25)*tbit_s}' 0
+ '{(78+0.125)*tbit_s}' 0
+ '{(78+0.125)*tbit_s+2e-11}' 1
+ '{(78+0.25)*tbit_s-2e-11}' 1
+ '{(78+0.25)*tbit_s}' 0
+ '{(84+0.125)*tbit_s}' 0
+ '{(84+0.125)*tbit_s+2e-11}' 1
+ '{(84+0.25)*tbit_s-2e-11}' 1
+ '{(84+0.25)*tbit_s}' 0
+ '{(86+0.125)*tbit_s}' 0
+ '{(86+0.125)*tbit_s+2e-11}' 1
+ '{(86+0.25)*tbit_s-2e-11}' 1
+ '{(86+0.25)*tbit_s}' 0
+ '{(87+0.125)*tbit_s}' 0
+ '{(87+0.125)*tbit_s+2e-11}' 1
+ '{(87+0.25)*tbit_s-2e-11}' 1
+ '{(87+0.25)*tbit_s}' 0
+ '{(88+0.125)*tbit_s}' 0
+ '{(88+0.125)*tbit_s+2e-11}' 1
+ '{(88+0.25)*tbit_s-2e-11}' 1
+ '{(88+0.25)*tbit_s}' 0
+ '{(89+0.125)*tbit_s}' 0
+ '{(89+0.125)*tbit_s+2e-11}' 1
+ '{(89+0.25)*tbit_s-2e-11}' 1
+ '{(89+0.25)*tbit_s}' 0
+ '{(93+0.125)*tbit_s}' 0
+ '{(93+0.125)*tbit_s+2e-11}' 1
+ '{(93+0.25)*tbit_s-2e-11}' 1
+ '{(93+0.25)*tbit_s}' 0
+ '{(94+0.125)*tbit_s}' 0
+ '{(94+0.125)*tbit_s+2e-11}' 1
+ '{(94+0.25)*tbit_s-2e-11}' 1
+ '{(94+0.25)*tbit_s}' 0
+ '{(95+0.125)*tbit_s}' 0
+ '{(95+0.125)*tbit_s+2e-11}' 1
+ '{(95+0.25)*tbit_s-2e-11}' 1
+ '{(95+0.25)*tbit_s}' 0
+ '{(97+0.125)*tbit_s}' 0
+ '{(97+0.125)*tbit_s+2e-11}' 1
+ '{(97+0.25)*tbit_s-2e-11}' 1
+ '{(97+0.25)*tbit_s}' 0
+ '{(98+0.125)*tbit_s}' 0
+ '{(98+0.125)*tbit_s+2e-11}' 1
+ '{(98+0.25)*tbit_s-2e-11}' 1
+ '{(98+0.25)*tbit_s}' 0
+ '{(100+0.125)*tbit_s}' 0
+ '{(100+0.125)*tbit_s+2e-11}' 1
+ '{(100+0.25)*tbit_s-2e-11}' 1
+ '{(100+0.25)*tbit_s}' 0
+ '{(101+0.125)*tbit_s}' 0
+ '{(101+0.125)*tbit_s+2e-11}' 1
+ '{(101+0.25)*tbit_s-2e-11}' 1
+ '{(101+0.25)*tbit_s}' 0
+ '{(104+0.125)*tbit_s}' 0
+ '{(104+0.125)*tbit_s+2e-11}' 1
+ '{(104+0.25)*tbit_s-2e-11}' 1
+ '{(104+0.25)*tbit_s}' 0
+ '{(107+0.125)*tbit_s}' 0
+ '{(107+0.125)*tbit_s+2e-11}' 1
+ '{(107+0.25)*tbit_s-2e-11}' 1
+ '{(107+0.25)*tbit_s}' 0
+ '{(109+0.125)*tbit_s}' 0
+ '{(109+0.125)*tbit_s+2e-11}' 1
+ '{(109+0.25)*tbit_s-2e-11}' 1
+ '{(109+0.25)*tbit_s}' 0
+ '{(112+0.125)*tbit_s}' 0
+ '{(112+0.125)*tbit_s+2e-11}' 1
+ '{(112+0.25)*tbit_s-2e-11}' 1
+ '{(112+0.25)*tbit_s}' 0
+ '{(117+0.125)*tbit_s}' 0
+ '{(117+0.125)*tbit_s+2e-11}' 1
+ '{(117+0.25)*tbit_s-2e-11}' 1
+ '{(117+0.25)*tbit_s}' 0
+ '{(120+0.125)*tbit_s}' 0
+ '{(120+0.125)*tbit_s+2e-11}' 1
+ '{(120+0.25)*tbit_s-2e-11}' 1
+ '{(120+0.25)*tbit_s}' 0
+ '{(121+0.125)*tbit_s}' 0
+ '{(121+0.125)*tbit_s+2e-11}' 1
+ '{(121+0.25)*tbit_s-2e-11}' 1
+ '{(121+0.25)*tbit_s}' 0
+ '{(122+0.125)*tbit_s}' 0
+ '{(122+0.125)*tbit_s+2e-11}' 1
+ '{(122+0.25)*tbit_s-2e-11}' 1
+ '{(122+0.25)*tbit_s}' 0
+ '{(125+0.125)*tbit_s}' 0
+ '{(125+0.125)*tbit_s+2e-11}' 1
+ '{(125+0.25)*tbit_s-2e-11}' 1
+ '{(125+0.25)*tbit_s}' 0
+ '{(127+0.125)*tbit_s}' 0
+ '{(127+0.125)*tbit_s+2e-11}' 1
+ '{(127+0.25)*tbit_s-2e-11}' 1
+ '{(127+0.25)*tbit_s}' 0
+ '{(128+0.125)*tbit_s}' 0
+ '{(128+0.125)*tbit_s+2e-11}' 1
+ '{(128+0.25)*tbit_s-2e-11}' 1
+ '{(128+0.25)*tbit_s}' 0
+ '{(130+0.125)*tbit_s}' 0
+ '{(130+0.125)*tbit_s+2e-11}' 1
+ '{(130+0.25)*tbit_s-2e-11}' 1
+ '{(130+0.25)*tbit_s}' 0
+ '{(134+0.125)*tbit_s}' 0
+ '{(134+0.125)*tbit_s+2e-11}' 1
+ '{(134+0.25)*tbit_s-2e-11}' 1
+ '{(134+0.25)*tbit_s}' 0
+ '{(138+0.125)*tbit_s}' 0
+ '{(138+0.125)*tbit_s+2e-11}' 1
+ '{(138+0.25)*tbit_s-2e-11}' 1
+ '{(138+0.25)*tbit_s}' 0
+ '{(139+0.125)*tbit_s}' 0
+ '{(139+0.125)*tbit_s+2e-11}' 1
+ '{(139+0.25)*tbit_s-2e-11}' 1
+ '{(139+0.25)*tbit_s}' 0
+ '{(142+0.125)*tbit_s}' 0
+ '{(142+0.125)*tbit_s+2e-11}' 1
+ '{(142+0.25)*tbit_s-2e-11}' 1
+ '{(142+0.25)*tbit_s}' 0
+ '{(143+0.125)*tbit_s}' 0
+ '{(143+0.125)*tbit_s+2e-11}' 1
+ '{(143+0.25)*tbit_s-2e-11}' 1
+ '{(143+0.25)*tbit_s}' 0
+ '{(145+0.125)*tbit_s}' 0
+ '{(145+0.125)*tbit_s+2e-11}' 1
+ '{(145+0.25)*tbit_s-2e-11}' 1
+ '{(145+0.25)*tbit_s}' 0
+ '{(147+0.125)*tbit_s}' 0
+ '{(147+0.125)*tbit_s+2e-11}' 1
+ '{(147+0.25)*tbit_s-2e-11}' 1
+ '{(147+0.25)*tbit_s}' 0
+ '{(149+0.125)*tbit_s}' 0
+ '{(149+0.125)*tbit_s+2e-11}' 1
+ '{(149+0.25)*tbit_s-2e-11}' 1
+ '{(149+0.25)*tbit_s}' 0
+ )
vcomb1_2 comb1_2 0 PWL(0 0
+ '{(23+0.25)*tbit_s}' 0
+ '{(23+0.25)*tbit_s+2e-11}' 1
+ '{(23+0.375)*tbit_s-2e-11}' 1
+ '{(23+0.375)*tbit_s}' 0
+ '{(24+0.25)*tbit_s}' 0
+ '{(24+0.25)*tbit_s+2e-11}' 1
+ '{(24+0.375)*tbit_s-2e-11}' 1
+ '{(24+0.375)*tbit_s}' 0
+ '{(25+0.25)*tbit_s}' 0
+ '{(25+0.25)*tbit_s+2e-11}' 1
+ '{(25+0.375)*tbit_s-2e-11}' 1
+ '{(25+0.375)*tbit_s}' 0
+ '{(26+0.25)*tbit_s}' 0
+ '{(26+0.25)*tbit_s+2e-11}' 1
+ '{(26+0.375)*tbit_s-2e-11}' 1
+ '{(26+0.375)*tbit_s}' 0
+ '{(27+0.25)*tbit_s}' 0
+ '{(27+0.25)*tbit_s+2e-11}' 1
+ '{(27+0.375)*tbit_s-2e-11}' 1
+ '{(27+0.375)*tbit_s}' 0
+ '{(28+0.25)*tbit_s}' 0
+ '{(28+0.25)*tbit_s+2e-11}' 1
+ '{(28+0.375)*tbit_s-2e-11}' 1
+ '{(28+0.375)*tbit_s}' 0
+ '{(29+0.25)*tbit_s}' 0
+ '{(29+0.25)*tbit_s+2e-11}' 1
+ '{(29+0.375)*tbit_s-2e-11}' 1
+ '{(29+0.375)*tbit_s}' 0
+ '{(36+0.25)*tbit_s}' 0
+ '{(36+0.25)*tbit_s+2e-11}' 1
+ '{(36+0.375)*tbit_s-2e-11}' 1
+ '{(36+0.375)*tbit_s}' 0
+ '{(42+0.25)*tbit_s}' 0
+ '{(42+0.25)*tbit_s+2e-11}' 1
+ '{(42+0.375)*tbit_s-2e-11}' 1
+ '{(42+0.375)*tbit_s}' 0
+ '{(43+0.25)*tbit_s}' 0
+ '{(43+0.25)*tbit_s+2e-11}' 1
+ '{(43+0.375)*tbit_s-2e-11}' 1
+ '{(43+0.375)*tbit_s}' 0
+ '{(48+0.25)*tbit_s}' 0
+ '{(48+0.25)*tbit_s+2e-11}' 1
+ '{(48+0.375)*tbit_s-2e-11}' 1
+ '{(48+0.375)*tbit_s}' 0
+ '{(50+0.25)*tbit_s}' 0
+ '{(50+0.25)*tbit_s+2e-11}' 1
+ '{(50+0.375)*tbit_s-2e-11}' 1
+ '{(50+0.375)*tbit_s}' 0
+ '{(54+0.25)*tbit_s}' 0
+ '{(54+0.25)*tbit_s+2e-11}' 1
+ '{(54+0.375)*tbit_s-2e-11}' 1
+ '{(54+0.375)*tbit_s}' 0
+ '{(55+0.25)*tbit_s}' 0
+ '{(55+0.25)*tbit_s+2e-11}' 1
+ '{(55+0.375)*tbit_s-2e-11}' 1
+ '{(55+0.375)*tbit_s}' 0
+ '{(56+0.25)*tbit_s}' 0
+ '{(56+0.25)*tbit_s+2e-11}' 1
+ '{(56+0.375)*tbit_s-2e-11}' 1
+ '{(56+0.375)*tbit_s}' 0
+ '{(57+0.25)*tbit_s}' 0
+ '{(57+0.25)*tbit_s+2e-11}' 1
+ '{(57+0.375)*tbit_s-2e-11}' 1
+ '{(57+0.375)*tbit_s}' 0
+ '{(60+0.25)*tbit_s}' 0
+ '{(60+0.25)*tbit_s+2e-11}' 1
+ '{(60+0.375)*tbit_s-2e-11}' 1
+ '{(60+0.375)*tbit_s}' 0
+ '{(64+0.25)*tbit_s}' 0
+ '{(64+0.25)*tbit_s+2e-11}' 1
+ '{(64+0.375)*tbit_s-2e-11}' 1
+ '{(64+0.375)*tbit_s}' 0
+ '{(66+0.25)*tbit_s}' 0
+ '{(66+0.25)*tbit_s+2e-11}' 1
+ '{(66+0.375)*tbit_s-2e-11}' 1
+ '{(66+0.375)*tbit_s}' 0
+ '{(67+0.25)*tbit_s}' 0
+ '{(67+0.25)*tbit_s+2e-11}' 1
+ '{(67+0.375)*tbit_s-2e-11}' 1
+ '{(67+0.375)*tbit_s}' 0
+ '{(70+0.25)*tbit_s}' 0
+ '{(70+0.25)*tbit_s+2e-11}' 1
+ '{(70+0.375)*tbit_s-2e-11}' 1
+ '{(70+0.375)*tbit_s}' 0
+ '{(71+0.25)*tbit_s}' 0
+ '{(71+0.25)*tbit_s+2e-11}' 1
+ '{(71+0.375)*tbit_s-2e-11}' 1
+ '{(71+0.375)*tbit_s}' 0
+ '{(72+0.25)*tbit_s}' 0
+ '{(72+0.25)*tbit_s+2e-11}' 1
+ '{(72+0.375)*tbit_s-2e-11}' 1
+ '{(72+0.375)*tbit_s}' 0
+ '{(74+0.25)*tbit_s}' 0
+ '{(74+0.25)*tbit_s+2e-11}' 1
+ '{(74+0.375)*tbit_s-2e-11}' 1
+ '{(74+0.375)*tbit_s}' 0
+ '{(76+0.25)*tbit_s}' 0
+ '{(76+0.25)*tbit_s+2e-11}' 1
+ '{(76+0.375)*tbit_s-2e-11}' 1
+ '{(76+0.375)*tbit_s}' 0
+ '{(79+0.25)*tbit_s}' 0
+ '{(79+0.25)*tbit_s+2e-11}' 1
+ '{(79+0.375)*tbit_s-2e-11}' 1
+ '{(79+0.375)*tbit_s}' 0
+ '{(80+0.25)*tbit_s}' 0
+ '{(80+0.25)*tbit_s+2e-11}' 1
+ '{(80+0.375)*tbit_s-2e-11}' 1
+ '{(80+0.375)*tbit_s}' 0
+ '{(81+0.25)*tbit_s}' 0
+ '{(81+0.25)*tbit_s+2e-11}' 1
+ '{(81+0.375)*tbit_s-2e-11}' 1
+ '{(81+0.375)*tbit_s}' 0
+ '{(82+0.25)*tbit_s}' 0
+ '{(82+0.25)*tbit_s+2e-11}' 1
+ '{(82+0.375)*tbit_s-2e-11}' 1
+ '{(82+0.375)*tbit_s}' 0
+ '{(83+0.25)*tbit_s}' 0
+ '{(83+0.25)*tbit_s+2e-11}' 1
+ '{(83+0.375)*tbit_s-2e-11}' 1
+ '{(83+0.375)*tbit_s}' 0
+ '{(85+0.25)*tbit_s}' 0
+ '{(85+0.25)*tbit_s+2e-11}' 1
+ '{(85+0.375)*tbit_s-2e-11}' 1
+ '{(85+0.375)*tbit_s}' 0
+ '{(90+0.25)*tbit_s}' 0
+ '{(90+0.25)*tbit_s+2e-11}' 1
+ '{(90+0.375)*tbit_s-2e-11}' 1
+ '{(90+0.375)*tbit_s}' 0
+ '{(91+0.25)*tbit_s}' 0
+ '{(91+0.25)*tbit_s+2e-11}' 1
+ '{(91+0.375)*tbit_s-2e-11}' 1
+ '{(91+0.375)*tbit_s}' 0
+ '{(92+0.25)*tbit_s}' 0
+ '{(92+0.25)*tbit_s+2e-11}' 1
+ '{(92+0.375)*tbit_s-2e-11}' 1
+ '{(92+0.375)*tbit_s}' 0
+ '{(96+0.25)*tbit_s}' 0
+ '{(96+0.25)*tbit_s+2e-11}' 1
+ '{(96+0.375)*tbit_s-2e-11}' 1
+ '{(96+0.375)*tbit_s}' 0
+ '{(99+0.25)*tbit_s}' 0
+ '{(99+0.25)*tbit_s+2e-11}' 1
+ '{(99+0.375)*tbit_s-2e-11}' 1
+ '{(99+0.375)*tbit_s}' 0
+ '{(102+0.25)*tbit_s}' 0
+ '{(102+0.25)*tbit_s+2e-11}' 1
+ '{(102+0.375)*tbit_s-2e-11}' 1
+ '{(102+0.375)*tbit_s}' 0
+ '{(103+0.25)*tbit_s}' 0
+ '{(103+0.25)*tbit_s+2e-11}' 1
+ '{(103+0.375)*tbit_s-2e-11}' 1
+ '{(103+0.375)*tbit_s}' 0
+ '{(105+0.25)*tbit_s}' 0
+ '{(105+0.25)*tbit_s+2e-11}' 1
+ '{(105+0.375)*tbit_s-2e-11}' 1
+ '{(105+0.375)*tbit_s}' 0
+ '{(106+0.25)*tbit_s}' 0
+ '{(106+0.25)*tbit_s+2e-11}' 1
+ '{(106+0.375)*tbit_s-2e-11}' 1
+ '{(106+0.375)*tbit_s}' 0
+ '{(108+0.25)*tbit_s}' 0
+ '{(108+0.25)*tbit_s+2e-11}' 1
+ '{(108+0.375)*tbit_s-2e-11}' 1
+ '{(108+0.375)*tbit_s}' 0
+ '{(110+0.25)*tbit_s}' 0
+ '{(110+0.25)*tbit_s+2e-11}' 1
+ '{(110+0.375)*tbit_s-2e-11}' 1
+ '{(110+0.375)*tbit_s}' 0
+ '{(111+0.25)*tbit_s}' 0
+ '{(111+0.25)*tbit_s+2e-11}' 1
+ '{(111+0.375)*tbit_s-2e-11}' 1
+ '{(111+0.375)*tbit_s}' 0
+ '{(113+0.25)*tbit_s}' 0
+ '{(113+0.25)*tbit_s+2e-11}' 1
+ '{(113+0.375)*tbit_s-2e-11}' 1
+ '{(113+0.375)*tbit_s}' 0
+ '{(114+0.25)*tbit_s}' 0
+ '{(114+0.25)*tbit_s+2e-11}' 1
+ '{(114+0.375)*tbit_s-2e-11}' 1
+ '{(114+0.375)*tbit_s}' 0
+ '{(115+0.25)*tbit_s}' 0
+ '{(115+0.25)*tbit_s+2e-11}' 1
+ '{(115+0.375)*tbit_s-2e-11}' 1
+ '{(115+0.375)*tbit_s}' 0
+ '{(116+0.25)*tbit_s}' 0
+ '{(116+0.25)*tbit_s+2e-11}' 1
+ '{(116+0.375)*tbit_s-2e-11}' 1
+ '{(116+0.375)*tbit_s}' 0
+ '{(118+0.25)*tbit_s}' 0
+ '{(118+0.25)*tbit_s+2e-11}' 1
+ '{(118+0.375)*tbit_s-2e-11}' 1
+ '{(118+0.375)*tbit_s}' 0
+ '{(119+0.25)*tbit_s}' 0
+ '{(119+0.25)*tbit_s+2e-11}' 1
+ '{(119+0.375)*tbit_s-2e-11}' 1
+ '{(119+0.375)*tbit_s}' 0
+ '{(123+0.25)*tbit_s}' 0
+ '{(123+0.25)*tbit_s+2e-11}' 1
+ '{(123+0.375)*tbit_s-2e-11}' 1
+ '{(123+0.375)*tbit_s}' 0
+ '{(124+0.25)*tbit_s}' 0
+ '{(124+0.25)*tbit_s+2e-11}' 1
+ '{(124+0.375)*tbit_s-2e-11}' 1
+ '{(124+0.375)*tbit_s}' 0
+ '{(126+0.25)*tbit_s}' 0
+ '{(126+0.25)*tbit_s+2e-11}' 1
+ '{(126+0.375)*tbit_s-2e-11}' 1
+ '{(126+0.375)*tbit_s}' 0
+ '{(129+0.25)*tbit_s}' 0
+ '{(129+0.25)*tbit_s+2e-11}' 1
+ '{(129+0.375)*tbit_s-2e-11}' 1
+ '{(129+0.375)*tbit_s}' 0
+ '{(131+0.25)*tbit_s}' 0
+ '{(131+0.25)*tbit_s+2e-11}' 1
+ '{(131+0.375)*tbit_s-2e-11}' 1
+ '{(131+0.375)*tbit_s}' 0
+ '{(132+0.25)*tbit_s}' 0
+ '{(132+0.25)*tbit_s+2e-11}' 1
+ '{(132+0.375)*tbit_s-2e-11}' 1
+ '{(132+0.375)*tbit_s}' 0
+ '{(133+0.25)*tbit_s}' 0
+ '{(133+0.25)*tbit_s+2e-11}' 1
+ '{(133+0.375)*tbit_s-2e-11}' 1
+ '{(133+0.375)*tbit_s}' 0
+ '{(135+0.25)*tbit_s}' 0
+ '{(135+0.25)*tbit_s+2e-11}' 1
+ '{(135+0.375)*tbit_s-2e-11}' 1
+ '{(135+0.375)*tbit_s}' 0
+ '{(136+0.25)*tbit_s}' 0
+ '{(136+0.25)*tbit_s+2e-11}' 1
+ '{(136+0.375)*tbit_s-2e-11}' 1
+ '{(136+0.375)*tbit_s}' 0
+ '{(137+0.25)*tbit_s}' 0
+ '{(137+0.25)*tbit_s+2e-11}' 1
+ '{(137+0.375)*tbit_s-2e-11}' 1
+ '{(137+0.375)*tbit_s}' 0
+ '{(140+0.25)*tbit_s}' 0
+ '{(140+0.25)*tbit_s+2e-11}' 1
+ '{(140+0.375)*tbit_s-2e-11}' 1
+ '{(140+0.375)*tbit_s}' 0
+ '{(141+0.25)*tbit_s}' 0
+ '{(141+0.25)*tbit_s+2e-11}' 1
+ '{(141+0.375)*tbit_s-2e-11}' 1
+ '{(141+0.375)*tbit_s}' 0
+ '{(144+0.25)*tbit_s}' 0
+ '{(144+0.25)*tbit_s+2e-11}' 1
+ '{(144+0.375)*tbit_s-2e-11}' 1
+ '{(144+0.375)*tbit_s}' 0
+ '{(146+0.25)*tbit_s}' 0
+ '{(146+0.25)*tbit_s+2e-11}' 1
+ '{(146+0.375)*tbit_s-2e-11}' 1
+ '{(146+0.375)*tbit_s}' 0
+ '{(148+0.25)*tbit_s}' 0
+ '{(148+0.25)*tbit_s+2e-11}' 1
+ '{(148+0.375)*tbit_s-2e-11}' 1
+ '{(148+0.375)*tbit_s}' 0
+ )
vcomb0_2 comb0_2 0 PWL(0 0
+ '{(30+0.25)*tbit_s}' 0
+ '{(30+0.25)*tbit_s+2e-11}' 1
+ '{(30+0.375)*tbit_s-2e-11}' 1
+ '{(30+0.375)*tbit_s}' 0
+ '{(31+0.25)*tbit_s}' 0
+ '{(31+0.25)*tbit_s+2e-11}' 1
+ '{(31+0.375)*tbit_s-2e-11}' 1
+ '{(31+0.375)*tbit_s}' 0
+ '{(32+0.25)*tbit_s}' 0
+ '{(32+0.25)*tbit_s+2e-11}' 1
+ '{(32+0.375)*tbit_s-2e-11}' 1
+ '{(32+0.375)*tbit_s}' 0
+ '{(33+0.25)*tbit_s}' 0
+ '{(33+0.25)*tbit_s+2e-11}' 1
+ '{(33+0.375)*tbit_s-2e-11}' 1
+ '{(33+0.375)*tbit_s}' 0
+ '{(34+0.25)*tbit_s}' 0
+ '{(34+0.25)*tbit_s+2e-11}' 1
+ '{(34+0.375)*tbit_s-2e-11}' 1
+ '{(34+0.375)*tbit_s}' 0
+ '{(35+0.25)*tbit_s}' 0
+ '{(35+0.25)*tbit_s+2e-11}' 1
+ '{(35+0.375)*tbit_s-2e-11}' 1
+ '{(35+0.375)*tbit_s}' 0
+ '{(37+0.25)*tbit_s}' 0
+ '{(37+0.25)*tbit_s+2e-11}' 1
+ '{(37+0.375)*tbit_s-2e-11}' 1
+ '{(37+0.375)*tbit_s}' 0
+ '{(38+0.25)*tbit_s}' 0
+ '{(38+0.25)*tbit_s+2e-11}' 1
+ '{(38+0.375)*tbit_s-2e-11}' 1
+ '{(38+0.375)*tbit_s}' 0
+ '{(39+0.25)*tbit_s}' 0
+ '{(39+0.25)*tbit_s+2e-11}' 1
+ '{(39+0.375)*tbit_s-2e-11}' 1
+ '{(39+0.375)*tbit_s}' 0
+ '{(40+0.25)*tbit_s}' 0
+ '{(40+0.25)*tbit_s+2e-11}' 1
+ '{(40+0.375)*tbit_s-2e-11}' 1
+ '{(40+0.375)*tbit_s}' 0
+ '{(41+0.25)*tbit_s}' 0
+ '{(41+0.25)*tbit_s+2e-11}' 1
+ '{(41+0.375)*tbit_s-2e-11}' 1
+ '{(41+0.375)*tbit_s}' 0
+ '{(44+0.25)*tbit_s}' 0
+ '{(44+0.25)*tbit_s+2e-11}' 1
+ '{(44+0.375)*tbit_s-2e-11}' 1
+ '{(44+0.375)*tbit_s}' 0
+ '{(45+0.25)*tbit_s}' 0
+ '{(45+0.25)*tbit_s+2e-11}' 1
+ '{(45+0.375)*tbit_s-2e-11}' 1
+ '{(45+0.375)*tbit_s}' 0
+ '{(46+0.25)*tbit_s}' 0
+ '{(46+0.25)*tbit_s+2e-11}' 1
+ '{(46+0.375)*tbit_s-2e-11}' 1
+ '{(46+0.375)*tbit_s}' 0
+ '{(47+0.25)*tbit_s}' 0
+ '{(47+0.25)*tbit_s+2e-11}' 1
+ '{(47+0.375)*tbit_s-2e-11}' 1
+ '{(47+0.375)*tbit_s}' 0
+ '{(49+0.25)*tbit_s}' 0
+ '{(49+0.25)*tbit_s+2e-11}' 1
+ '{(49+0.375)*tbit_s-2e-11}' 1
+ '{(49+0.375)*tbit_s}' 0
+ '{(51+0.25)*tbit_s}' 0
+ '{(51+0.25)*tbit_s+2e-11}' 1
+ '{(51+0.375)*tbit_s-2e-11}' 1
+ '{(51+0.375)*tbit_s}' 0
+ '{(52+0.25)*tbit_s}' 0
+ '{(52+0.25)*tbit_s+2e-11}' 1
+ '{(52+0.375)*tbit_s-2e-11}' 1
+ '{(52+0.375)*tbit_s}' 0
+ '{(53+0.25)*tbit_s}' 0
+ '{(53+0.25)*tbit_s+2e-11}' 1
+ '{(53+0.375)*tbit_s-2e-11}' 1
+ '{(53+0.375)*tbit_s}' 0
+ '{(58+0.25)*tbit_s}' 0
+ '{(58+0.25)*tbit_s+2e-11}' 1
+ '{(58+0.375)*tbit_s-2e-11}' 1
+ '{(58+0.375)*tbit_s}' 0
+ '{(59+0.25)*tbit_s}' 0
+ '{(59+0.25)*tbit_s+2e-11}' 1
+ '{(59+0.375)*tbit_s-2e-11}' 1
+ '{(59+0.375)*tbit_s}' 0
+ '{(61+0.25)*tbit_s}' 0
+ '{(61+0.25)*tbit_s+2e-11}' 1
+ '{(61+0.375)*tbit_s-2e-11}' 1
+ '{(61+0.375)*tbit_s}' 0
+ '{(62+0.25)*tbit_s}' 0
+ '{(62+0.25)*tbit_s+2e-11}' 1
+ '{(62+0.375)*tbit_s-2e-11}' 1
+ '{(62+0.375)*tbit_s}' 0
+ '{(63+0.25)*tbit_s}' 0
+ '{(63+0.25)*tbit_s+2e-11}' 1
+ '{(63+0.375)*tbit_s-2e-11}' 1
+ '{(63+0.375)*tbit_s}' 0
+ '{(65+0.25)*tbit_s}' 0
+ '{(65+0.25)*tbit_s+2e-11}' 1
+ '{(65+0.375)*tbit_s-2e-11}' 1
+ '{(65+0.375)*tbit_s}' 0
+ '{(68+0.25)*tbit_s}' 0
+ '{(68+0.25)*tbit_s+2e-11}' 1
+ '{(68+0.375)*tbit_s-2e-11}' 1
+ '{(68+0.375)*tbit_s}' 0
+ '{(69+0.25)*tbit_s}' 0
+ '{(69+0.25)*tbit_s+2e-11}' 1
+ '{(69+0.375)*tbit_s-2e-11}' 1
+ '{(69+0.375)*tbit_s}' 0
+ '{(73+0.25)*tbit_s}' 0
+ '{(73+0.25)*tbit_s+2e-11}' 1
+ '{(73+0.375)*tbit_s-2e-11}' 1
+ '{(73+0.375)*tbit_s}' 0
+ '{(75+0.25)*tbit_s}' 0
+ '{(75+0.25)*tbit_s+2e-11}' 1
+ '{(75+0.375)*tbit_s-2e-11}' 1
+ '{(75+0.375)*tbit_s}' 0
+ '{(77+0.25)*tbit_s}' 0
+ '{(77+0.25)*tbit_s+2e-11}' 1
+ '{(77+0.375)*tbit_s-2e-11}' 1
+ '{(77+0.375)*tbit_s}' 0
+ '{(78+0.25)*tbit_s}' 0
+ '{(78+0.25)*tbit_s+2e-11}' 1
+ '{(78+0.375)*tbit_s-2e-11}' 1
+ '{(78+0.375)*tbit_s}' 0
+ '{(84+0.25)*tbit_s}' 0
+ '{(84+0.25)*tbit_s+2e-11}' 1
+ '{(84+0.375)*tbit_s-2e-11}' 1
+ '{(84+0.375)*tbit_s}' 0
+ '{(86+0.25)*tbit_s}' 0
+ '{(86+0.25)*tbit_s+2e-11}' 1
+ '{(86+0.375)*tbit_s-2e-11}' 1
+ '{(86+0.375)*tbit_s}' 0
+ '{(87+0.25)*tbit_s}' 0
+ '{(87+0.25)*tbit_s+2e-11}' 1
+ '{(87+0.375)*tbit_s-2e-11}' 1
+ '{(87+0.375)*tbit_s}' 0
+ '{(88+0.25)*tbit_s}' 0
+ '{(88+0.25)*tbit_s+2e-11}' 1
+ '{(88+0.375)*tbit_s-2e-11}' 1
+ '{(88+0.375)*tbit_s}' 0
+ '{(89+0.25)*tbit_s}' 0
+ '{(89+0.25)*tbit_s+2e-11}' 1
+ '{(89+0.375)*tbit_s-2e-11}' 1
+ '{(89+0.375)*tbit_s}' 0
+ '{(93+0.25)*tbit_s}' 0
+ '{(93+0.25)*tbit_s+2e-11}' 1
+ '{(93+0.375)*tbit_s-2e-11}' 1
+ '{(93+0.375)*tbit_s}' 0
+ '{(94+0.25)*tbit_s}' 0
+ '{(94+0.25)*tbit_s+2e-11}' 1
+ '{(94+0.375)*tbit_s-2e-11}' 1
+ '{(94+0.375)*tbit_s}' 0
+ '{(95+0.25)*tbit_s}' 0
+ '{(95+0.25)*tbit_s+2e-11}' 1
+ '{(95+0.375)*tbit_s-2e-11}' 1
+ '{(95+0.375)*tbit_s}' 0
+ '{(97+0.25)*tbit_s}' 0
+ '{(97+0.25)*tbit_s+2e-11}' 1
+ '{(97+0.375)*tbit_s-2e-11}' 1
+ '{(97+0.375)*tbit_s}' 0
+ '{(98+0.25)*tbit_s}' 0
+ '{(98+0.25)*tbit_s+2e-11}' 1
+ '{(98+0.375)*tbit_s-2e-11}' 1
+ '{(98+0.375)*tbit_s}' 0
+ '{(100+0.25)*tbit_s}' 0
+ '{(100+0.25)*tbit_s+2e-11}' 1
+ '{(100+0.375)*tbit_s-2e-11}' 1
+ '{(100+0.375)*tbit_s}' 0
+ '{(101+0.25)*tbit_s}' 0
+ '{(101+0.25)*tbit_s+2e-11}' 1
+ '{(101+0.375)*tbit_s-2e-11}' 1
+ '{(101+0.375)*tbit_s}' 0
+ '{(104+0.25)*tbit_s}' 0
+ '{(104+0.25)*tbit_s+2e-11}' 1
+ '{(104+0.375)*tbit_s-2e-11}' 1
+ '{(104+0.375)*tbit_s}' 0
+ '{(107+0.25)*tbit_s}' 0
+ '{(107+0.25)*tbit_s+2e-11}' 1
+ '{(107+0.375)*tbit_s-2e-11}' 1
+ '{(107+0.375)*tbit_s}' 0
+ '{(109+0.25)*tbit_s}' 0
+ '{(109+0.25)*tbit_s+2e-11}' 1
+ '{(109+0.375)*tbit_s-2e-11}' 1
+ '{(109+0.375)*tbit_s}' 0
+ '{(112+0.25)*tbit_s}' 0
+ '{(112+0.25)*tbit_s+2e-11}' 1
+ '{(112+0.375)*tbit_s-2e-11}' 1
+ '{(112+0.375)*tbit_s}' 0
+ '{(117+0.25)*tbit_s}' 0
+ '{(117+0.25)*tbit_s+2e-11}' 1
+ '{(117+0.375)*tbit_s-2e-11}' 1
+ '{(117+0.375)*tbit_s}' 0
+ '{(120+0.25)*tbit_s}' 0
+ '{(120+0.25)*tbit_s+2e-11}' 1
+ '{(120+0.375)*tbit_s-2e-11}' 1
+ '{(120+0.375)*tbit_s}' 0
+ '{(121+0.25)*tbit_s}' 0
+ '{(121+0.25)*tbit_s+2e-11}' 1
+ '{(121+0.375)*tbit_s-2e-11}' 1
+ '{(121+0.375)*tbit_s}' 0
+ '{(122+0.25)*tbit_s}' 0
+ '{(122+0.25)*tbit_s+2e-11}' 1
+ '{(122+0.375)*tbit_s-2e-11}' 1
+ '{(122+0.375)*tbit_s}' 0
+ '{(125+0.25)*tbit_s}' 0
+ '{(125+0.25)*tbit_s+2e-11}' 1
+ '{(125+0.375)*tbit_s-2e-11}' 1
+ '{(125+0.375)*tbit_s}' 0
+ '{(127+0.25)*tbit_s}' 0
+ '{(127+0.25)*tbit_s+2e-11}' 1
+ '{(127+0.375)*tbit_s-2e-11}' 1
+ '{(127+0.375)*tbit_s}' 0
+ '{(128+0.25)*tbit_s}' 0
+ '{(128+0.25)*tbit_s+2e-11}' 1
+ '{(128+0.375)*tbit_s-2e-11}' 1
+ '{(128+0.375)*tbit_s}' 0
+ '{(130+0.25)*tbit_s}' 0
+ '{(130+0.25)*tbit_s+2e-11}' 1
+ '{(130+0.375)*tbit_s-2e-11}' 1
+ '{(130+0.375)*tbit_s}' 0
+ '{(134+0.25)*tbit_s}' 0
+ '{(134+0.25)*tbit_s+2e-11}' 1
+ '{(134+0.375)*tbit_s-2e-11}' 1
+ '{(134+0.375)*tbit_s}' 0
+ '{(138+0.25)*tbit_s}' 0
+ '{(138+0.25)*tbit_s+2e-11}' 1
+ '{(138+0.375)*tbit_s-2e-11}' 1
+ '{(138+0.375)*tbit_s}' 0
+ '{(139+0.25)*tbit_s}' 0
+ '{(139+0.25)*tbit_s+2e-11}' 1
+ '{(139+0.375)*tbit_s-2e-11}' 1
+ '{(139+0.375)*tbit_s}' 0
+ '{(142+0.25)*tbit_s}' 0
+ '{(142+0.25)*tbit_s+2e-11}' 1
+ '{(142+0.375)*tbit_s-2e-11}' 1
+ '{(142+0.375)*tbit_s}' 0
+ '{(143+0.25)*tbit_s}' 0
+ '{(143+0.25)*tbit_s+2e-11}' 1
+ '{(143+0.375)*tbit_s-2e-11}' 1
+ '{(143+0.375)*tbit_s}' 0
+ '{(145+0.25)*tbit_s}' 0
+ '{(145+0.25)*tbit_s+2e-11}' 1
+ '{(145+0.375)*tbit_s-2e-11}' 1
+ '{(145+0.375)*tbit_s}' 0
+ '{(147+0.25)*tbit_s}' 0
+ '{(147+0.25)*tbit_s+2e-11}' 1
+ '{(147+0.375)*tbit_s-2e-11}' 1
+ '{(147+0.375)*tbit_s}' 0
+ '{(149+0.25)*tbit_s}' 0
+ '{(149+0.25)*tbit_s+2e-11}' 1
+ '{(149+0.375)*tbit_s-2e-11}' 1
+ '{(149+0.375)*tbit_s}' 0
+ )
vcomb1_3 comb1_3 0 PWL(0 0
+ '{(23+0.375)*tbit_s}' 0
+ '{(23+0.375)*tbit_s+2e-11}' 1
+ '{(23+0.5)*tbit_s-2e-11}' 1
+ '{(23+0.5)*tbit_s}' 0
+ '{(24+0.375)*tbit_s}' 0
+ '{(24+0.375)*tbit_s+2e-11}' 1
+ '{(24+0.5)*tbit_s-2e-11}' 1
+ '{(24+0.5)*tbit_s}' 0
+ '{(25+0.375)*tbit_s}' 0
+ '{(25+0.375)*tbit_s+2e-11}' 1
+ '{(25+0.5)*tbit_s-2e-11}' 1
+ '{(25+0.5)*tbit_s}' 0
+ '{(26+0.375)*tbit_s}' 0
+ '{(26+0.375)*tbit_s+2e-11}' 1
+ '{(26+0.5)*tbit_s-2e-11}' 1
+ '{(26+0.5)*tbit_s}' 0
+ '{(27+0.375)*tbit_s}' 0
+ '{(27+0.375)*tbit_s+2e-11}' 1
+ '{(27+0.5)*tbit_s-2e-11}' 1
+ '{(27+0.5)*tbit_s}' 0
+ '{(28+0.375)*tbit_s}' 0
+ '{(28+0.375)*tbit_s+2e-11}' 1
+ '{(28+0.5)*tbit_s-2e-11}' 1
+ '{(28+0.5)*tbit_s}' 0
+ '{(29+0.375)*tbit_s}' 0
+ '{(29+0.375)*tbit_s+2e-11}' 1
+ '{(29+0.5)*tbit_s-2e-11}' 1
+ '{(29+0.5)*tbit_s}' 0
+ '{(36+0.375)*tbit_s}' 0
+ '{(36+0.375)*tbit_s+2e-11}' 1
+ '{(36+0.5)*tbit_s-2e-11}' 1
+ '{(36+0.5)*tbit_s}' 0
+ '{(42+0.375)*tbit_s}' 0
+ '{(42+0.375)*tbit_s+2e-11}' 1
+ '{(42+0.5)*tbit_s-2e-11}' 1
+ '{(42+0.5)*tbit_s}' 0
+ '{(43+0.375)*tbit_s}' 0
+ '{(43+0.375)*tbit_s+2e-11}' 1
+ '{(43+0.5)*tbit_s-2e-11}' 1
+ '{(43+0.5)*tbit_s}' 0
+ '{(48+0.375)*tbit_s}' 0
+ '{(48+0.375)*tbit_s+2e-11}' 1
+ '{(48+0.5)*tbit_s-2e-11}' 1
+ '{(48+0.5)*tbit_s}' 0
+ '{(50+0.375)*tbit_s}' 0
+ '{(50+0.375)*tbit_s+2e-11}' 1
+ '{(50+0.5)*tbit_s-2e-11}' 1
+ '{(50+0.5)*tbit_s}' 0
+ '{(54+0.375)*tbit_s}' 0
+ '{(54+0.375)*tbit_s+2e-11}' 1
+ '{(54+0.5)*tbit_s-2e-11}' 1
+ '{(54+0.5)*tbit_s}' 0
+ '{(55+0.375)*tbit_s}' 0
+ '{(55+0.375)*tbit_s+2e-11}' 1
+ '{(55+0.5)*tbit_s-2e-11}' 1
+ '{(55+0.5)*tbit_s}' 0
+ '{(56+0.375)*tbit_s}' 0
+ '{(56+0.375)*tbit_s+2e-11}' 1
+ '{(56+0.5)*tbit_s-2e-11}' 1
+ '{(56+0.5)*tbit_s}' 0
+ '{(57+0.375)*tbit_s}' 0
+ '{(57+0.375)*tbit_s+2e-11}' 1
+ '{(57+0.5)*tbit_s-2e-11}' 1
+ '{(57+0.5)*tbit_s}' 0
+ '{(60+0.375)*tbit_s}' 0
+ '{(60+0.375)*tbit_s+2e-11}' 1
+ '{(60+0.5)*tbit_s-2e-11}' 1
+ '{(60+0.5)*tbit_s}' 0
+ '{(64+0.375)*tbit_s}' 0
+ '{(64+0.375)*tbit_s+2e-11}' 1
+ '{(64+0.5)*tbit_s-2e-11}' 1
+ '{(64+0.5)*tbit_s}' 0
+ '{(66+0.375)*tbit_s}' 0
+ '{(66+0.375)*tbit_s+2e-11}' 1
+ '{(66+0.5)*tbit_s-2e-11}' 1
+ '{(66+0.5)*tbit_s}' 0
+ '{(67+0.375)*tbit_s}' 0
+ '{(67+0.375)*tbit_s+2e-11}' 1
+ '{(67+0.5)*tbit_s-2e-11}' 1
+ '{(67+0.5)*tbit_s}' 0
+ '{(70+0.375)*tbit_s}' 0
+ '{(70+0.375)*tbit_s+2e-11}' 1
+ '{(70+0.5)*tbit_s-2e-11}' 1
+ '{(70+0.5)*tbit_s}' 0
+ '{(71+0.375)*tbit_s}' 0
+ '{(71+0.375)*tbit_s+2e-11}' 1
+ '{(71+0.5)*tbit_s-2e-11}' 1
+ '{(71+0.5)*tbit_s}' 0
+ '{(72+0.375)*tbit_s}' 0
+ '{(72+0.375)*tbit_s+2e-11}' 1
+ '{(72+0.5)*tbit_s-2e-11}' 1
+ '{(72+0.5)*tbit_s}' 0
+ '{(74+0.375)*tbit_s}' 0
+ '{(74+0.375)*tbit_s+2e-11}' 1
+ '{(74+0.5)*tbit_s-2e-11}' 1
+ '{(74+0.5)*tbit_s}' 0
+ '{(76+0.375)*tbit_s}' 0
+ '{(76+0.375)*tbit_s+2e-11}' 1
+ '{(76+0.5)*tbit_s-2e-11}' 1
+ '{(76+0.5)*tbit_s}' 0
+ '{(79+0.375)*tbit_s}' 0
+ '{(79+0.375)*tbit_s+2e-11}' 1
+ '{(79+0.5)*tbit_s-2e-11}' 1
+ '{(79+0.5)*tbit_s}' 0
+ '{(80+0.375)*tbit_s}' 0
+ '{(80+0.375)*tbit_s+2e-11}' 1
+ '{(80+0.5)*tbit_s-2e-11}' 1
+ '{(80+0.5)*tbit_s}' 0
+ '{(81+0.375)*tbit_s}' 0
+ '{(81+0.375)*tbit_s+2e-11}' 1
+ '{(81+0.5)*tbit_s-2e-11}' 1
+ '{(81+0.5)*tbit_s}' 0
+ '{(82+0.375)*tbit_s}' 0
+ '{(82+0.375)*tbit_s+2e-11}' 1
+ '{(82+0.5)*tbit_s-2e-11}' 1
+ '{(82+0.5)*tbit_s}' 0
+ '{(83+0.375)*tbit_s}' 0
+ '{(83+0.375)*tbit_s+2e-11}' 1
+ '{(83+0.5)*tbit_s-2e-11}' 1
+ '{(83+0.5)*tbit_s}' 0
+ '{(85+0.375)*tbit_s}' 0
+ '{(85+0.375)*tbit_s+2e-11}' 1
+ '{(85+0.5)*tbit_s-2e-11}' 1
+ '{(85+0.5)*tbit_s}' 0
+ '{(90+0.375)*tbit_s}' 0
+ '{(90+0.375)*tbit_s+2e-11}' 1
+ '{(90+0.5)*tbit_s-2e-11}' 1
+ '{(90+0.5)*tbit_s}' 0
+ '{(91+0.375)*tbit_s}' 0
+ '{(91+0.375)*tbit_s+2e-11}' 1
+ '{(91+0.5)*tbit_s-2e-11}' 1
+ '{(91+0.5)*tbit_s}' 0
+ '{(92+0.375)*tbit_s}' 0
+ '{(92+0.375)*tbit_s+2e-11}' 1
+ '{(92+0.5)*tbit_s-2e-11}' 1
+ '{(92+0.5)*tbit_s}' 0
+ '{(96+0.375)*tbit_s}' 0
+ '{(96+0.375)*tbit_s+2e-11}' 1
+ '{(96+0.5)*tbit_s-2e-11}' 1
+ '{(96+0.5)*tbit_s}' 0
+ '{(99+0.375)*tbit_s}' 0
+ '{(99+0.375)*tbit_s+2e-11}' 1
+ '{(99+0.5)*tbit_s-2e-11}' 1
+ '{(99+0.5)*tbit_s}' 0
+ '{(102+0.375)*tbit_s}' 0
+ '{(102+0.375)*tbit_s+2e-11}' 1
+ '{(102+0.5)*tbit_s-2e-11}' 1
+ '{(102+0.5)*tbit_s}' 0
+ '{(103+0.375)*tbit_s}' 0
+ '{(103+0.375)*tbit_s+2e-11}' 1
+ '{(103+0.5)*tbit_s-2e-11}' 1
+ '{(103+0.5)*tbit_s}' 0
+ '{(105+0.375)*tbit_s}' 0
+ '{(105+0.375)*tbit_s+2e-11}' 1
+ '{(105+0.5)*tbit_s-2e-11}' 1
+ '{(105+0.5)*tbit_s}' 0
+ '{(106+0.375)*tbit_s}' 0
+ '{(106+0.375)*tbit_s+2e-11}' 1
+ '{(106+0.5)*tbit_s-2e-11}' 1
+ '{(106+0.5)*tbit_s}' 0
+ '{(108+0.375)*tbit_s}' 0
+ '{(108+0.375)*tbit_s+2e-11}' 1
+ '{(108+0.5)*tbit_s-2e-11}' 1
+ '{(108+0.5)*tbit_s}' 0
+ '{(110+0.375)*tbit_s}' 0
+ '{(110+0.375)*tbit_s+2e-11}' 1
+ '{(110+0.5)*tbit_s-2e-11}' 1
+ '{(110+0.5)*tbit_s}' 0
+ '{(111+0.375)*tbit_s}' 0
+ '{(111+0.375)*tbit_s+2e-11}' 1
+ '{(111+0.5)*tbit_s-2e-11}' 1
+ '{(111+0.5)*tbit_s}' 0
+ '{(113+0.375)*tbit_s}' 0
+ '{(113+0.375)*tbit_s+2e-11}' 1
+ '{(113+0.5)*tbit_s-2e-11}' 1
+ '{(113+0.5)*tbit_s}' 0
+ '{(114+0.375)*tbit_s}' 0
+ '{(114+0.375)*tbit_s+2e-11}' 1
+ '{(114+0.5)*tbit_s-2e-11}' 1
+ '{(114+0.5)*tbit_s}' 0
+ '{(115+0.375)*tbit_s}' 0
+ '{(115+0.375)*tbit_s+2e-11}' 1
+ '{(115+0.5)*tbit_s-2e-11}' 1
+ '{(115+0.5)*tbit_s}' 0
+ '{(116+0.375)*tbit_s}' 0
+ '{(116+0.375)*tbit_s+2e-11}' 1
+ '{(116+0.5)*tbit_s-2e-11}' 1
+ '{(116+0.5)*tbit_s}' 0
+ '{(118+0.375)*tbit_s}' 0
+ '{(118+0.375)*tbit_s+2e-11}' 1
+ '{(118+0.5)*tbit_s-2e-11}' 1
+ '{(118+0.5)*tbit_s}' 0
+ '{(119+0.375)*tbit_s}' 0
+ '{(119+0.375)*tbit_s+2e-11}' 1
+ '{(119+0.5)*tbit_s-2e-11}' 1
+ '{(119+0.5)*tbit_s}' 0
+ '{(123+0.375)*tbit_s}' 0
+ '{(123+0.375)*tbit_s+2e-11}' 1
+ '{(123+0.5)*tbit_s-2e-11}' 1
+ '{(123+0.5)*tbit_s}' 0
+ '{(124+0.375)*tbit_s}' 0
+ '{(124+0.375)*tbit_s+2e-11}' 1
+ '{(124+0.5)*tbit_s-2e-11}' 1
+ '{(124+0.5)*tbit_s}' 0
+ '{(126+0.375)*tbit_s}' 0
+ '{(126+0.375)*tbit_s+2e-11}' 1
+ '{(126+0.5)*tbit_s-2e-11}' 1
+ '{(126+0.5)*tbit_s}' 0
+ '{(129+0.375)*tbit_s}' 0
+ '{(129+0.375)*tbit_s+2e-11}' 1
+ '{(129+0.5)*tbit_s-2e-11}' 1
+ '{(129+0.5)*tbit_s}' 0
+ '{(131+0.375)*tbit_s}' 0
+ '{(131+0.375)*tbit_s+2e-11}' 1
+ '{(131+0.5)*tbit_s-2e-11}' 1
+ '{(131+0.5)*tbit_s}' 0
+ '{(132+0.375)*tbit_s}' 0
+ '{(132+0.375)*tbit_s+2e-11}' 1
+ '{(132+0.5)*tbit_s-2e-11}' 1
+ '{(132+0.5)*tbit_s}' 0
+ '{(133+0.375)*tbit_s}' 0
+ '{(133+0.375)*tbit_s+2e-11}' 1
+ '{(133+0.5)*tbit_s-2e-11}' 1
+ '{(133+0.5)*tbit_s}' 0
+ '{(135+0.375)*tbit_s}' 0
+ '{(135+0.375)*tbit_s+2e-11}' 1
+ '{(135+0.5)*tbit_s-2e-11}' 1
+ '{(135+0.5)*tbit_s}' 0
+ '{(136+0.375)*tbit_s}' 0
+ '{(136+0.375)*tbit_s+2e-11}' 1
+ '{(136+0.5)*tbit_s-2e-11}' 1
+ '{(136+0.5)*tbit_s}' 0
+ '{(137+0.375)*tbit_s}' 0
+ '{(137+0.375)*tbit_s+2e-11}' 1
+ '{(137+0.5)*tbit_s-2e-11}' 1
+ '{(137+0.5)*tbit_s}' 0
+ '{(140+0.375)*tbit_s}' 0
+ '{(140+0.375)*tbit_s+2e-11}' 1
+ '{(140+0.5)*tbit_s-2e-11}' 1
+ '{(140+0.5)*tbit_s}' 0
+ '{(141+0.375)*tbit_s}' 0
+ '{(141+0.375)*tbit_s+2e-11}' 1
+ '{(141+0.5)*tbit_s-2e-11}' 1
+ '{(141+0.5)*tbit_s}' 0
+ '{(144+0.375)*tbit_s}' 0
+ '{(144+0.375)*tbit_s+2e-11}' 1
+ '{(144+0.5)*tbit_s-2e-11}' 1
+ '{(144+0.5)*tbit_s}' 0
+ '{(146+0.375)*tbit_s}' 0
+ '{(146+0.375)*tbit_s+2e-11}' 1
+ '{(146+0.5)*tbit_s-2e-11}' 1
+ '{(146+0.5)*tbit_s}' 0
+ '{(148+0.375)*tbit_s}' 0
+ '{(148+0.375)*tbit_s+2e-11}' 1
+ '{(148+0.5)*tbit_s-2e-11}' 1
+ '{(148+0.5)*tbit_s}' 0
+ )
vcomb0_3 comb0_3 0 PWL(0 0
+ '{(30+0.375)*tbit_s}' 0
+ '{(30+0.375)*tbit_s+2e-11}' 1
+ '{(30+0.5)*tbit_s-2e-11}' 1
+ '{(30+0.5)*tbit_s}' 0
+ '{(31+0.375)*tbit_s}' 0
+ '{(31+0.375)*tbit_s+2e-11}' 1
+ '{(31+0.5)*tbit_s-2e-11}' 1
+ '{(31+0.5)*tbit_s}' 0
+ '{(32+0.375)*tbit_s}' 0
+ '{(32+0.375)*tbit_s+2e-11}' 1
+ '{(32+0.5)*tbit_s-2e-11}' 1
+ '{(32+0.5)*tbit_s}' 0
+ '{(33+0.375)*tbit_s}' 0
+ '{(33+0.375)*tbit_s+2e-11}' 1
+ '{(33+0.5)*tbit_s-2e-11}' 1
+ '{(33+0.5)*tbit_s}' 0
+ '{(34+0.375)*tbit_s}' 0
+ '{(34+0.375)*tbit_s+2e-11}' 1
+ '{(34+0.5)*tbit_s-2e-11}' 1
+ '{(34+0.5)*tbit_s}' 0
+ '{(35+0.375)*tbit_s}' 0
+ '{(35+0.375)*tbit_s+2e-11}' 1
+ '{(35+0.5)*tbit_s-2e-11}' 1
+ '{(35+0.5)*tbit_s}' 0
+ '{(37+0.375)*tbit_s}' 0
+ '{(37+0.375)*tbit_s+2e-11}' 1
+ '{(37+0.5)*tbit_s-2e-11}' 1
+ '{(37+0.5)*tbit_s}' 0
+ '{(38+0.375)*tbit_s}' 0
+ '{(38+0.375)*tbit_s+2e-11}' 1
+ '{(38+0.5)*tbit_s-2e-11}' 1
+ '{(38+0.5)*tbit_s}' 0
+ '{(39+0.375)*tbit_s}' 0
+ '{(39+0.375)*tbit_s+2e-11}' 1
+ '{(39+0.5)*tbit_s-2e-11}' 1
+ '{(39+0.5)*tbit_s}' 0
+ '{(40+0.375)*tbit_s}' 0
+ '{(40+0.375)*tbit_s+2e-11}' 1
+ '{(40+0.5)*tbit_s-2e-11}' 1
+ '{(40+0.5)*tbit_s}' 0
+ '{(41+0.375)*tbit_s}' 0
+ '{(41+0.375)*tbit_s+2e-11}' 1
+ '{(41+0.5)*tbit_s-2e-11}' 1
+ '{(41+0.5)*tbit_s}' 0
+ '{(44+0.375)*tbit_s}' 0
+ '{(44+0.375)*tbit_s+2e-11}' 1
+ '{(44+0.5)*tbit_s-2e-11}' 1
+ '{(44+0.5)*tbit_s}' 0
+ '{(45+0.375)*tbit_s}' 0
+ '{(45+0.375)*tbit_s+2e-11}' 1
+ '{(45+0.5)*tbit_s-2e-11}' 1
+ '{(45+0.5)*tbit_s}' 0
+ '{(46+0.375)*tbit_s}' 0
+ '{(46+0.375)*tbit_s+2e-11}' 1
+ '{(46+0.5)*tbit_s-2e-11}' 1
+ '{(46+0.5)*tbit_s}' 0
+ '{(47+0.375)*tbit_s}' 0
+ '{(47+0.375)*tbit_s+2e-11}' 1
+ '{(47+0.5)*tbit_s-2e-11}' 1
+ '{(47+0.5)*tbit_s}' 0
+ '{(49+0.375)*tbit_s}' 0
+ '{(49+0.375)*tbit_s+2e-11}' 1
+ '{(49+0.5)*tbit_s-2e-11}' 1
+ '{(49+0.5)*tbit_s}' 0
+ '{(51+0.375)*tbit_s}' 0
+ '{(51+0.375)*tbit_s+2e-11}' 1
+ '{(51+0.5)*tbit_s-2e-11}' 1
+ '{(51+0.5)*tbit_s}' 0
+ '{(52+0.375)*tbit_s}' 0
+ '{(52+0.375)*tbit_s+2e-11}' 1
+ '{(52+0.5)*tbit_s-2e-11}' 1
+ '{(52+0.5)*tbit_s}' 0
+ '{(53+0.375)*tbit_s}' 0
+ '{(53+0.375)*tbit_s+2e-11}' 1
+ '{(53+0.5)*tbit_s-2e-11}' 1
+ '{(53+0.5)*tbit_s}' 0
+ '{(58+0.375)*tbit_s}' 0
+ '{(58+0.375)*tbit_s+2e-11}' 1
+ '{(58+0.5)*tbit_s-2e-11}' 1
+ '{(58+0.5)*tbit_s}' 0
+ '{(59+0.375)*tbit_s}' 0
+ '{(59+0.375)*tbit_s+2e-11}' 1
+ '{(59+0.5)*tbit_s-2e-11}' 1
+ '{(59+0.5)*tbit_s}' 0
+ '{(61+0.375)*tbit_s}' 0
+ '{(61+0.375)*tbit_s+2e-11}' 1
+ '{(61+0.5)*tbit_s-2e-11}' 1
+ '{(61+0.5)*tbit_s}' 0
+ '{(62+0.375)*tbit_s}' 0
+ '{(62+0.375)*tbit_s+2e-11}' 1
+ '{(62+0.5)*tbit_s-2e-11}' 1
+ '{(62+0.5)*tbit_s}' 0
+ '{(63+0.375)*tbit_s}' 0
+ '{(63+0.375)*tbit_s+2e-11}' 1
+ '{(63+0.5)*tbit_s-2e-11}' 1
+ '{(63+0.5)*tbit_s}' 0
+ '{(65+0.375)*tbit_s}' 0
+ '{(65+0.375)*tbit_s+2e-11}' 1
+ '{(65+0.5)*tbit_s-2e-11}' 1
+ '{(65+0.5)*tbit_s}' 0
+ '{(68+0.375)*tbit_s}' 0
+ '{(68+0.375)*tbit_s+2e-11}' 1
+ '{(68+0.5)*tbit_s-2e-11}' 1
+ '{(68+0.5)*tbit_s}' 0
+ '{(69+0.375)*tbit_s}' 0
+ '{(69+0.375)*tbit_s+2e-11}' 1
+ '{(69+0.5)*tbit_s-2e-11}' 1
+ '{(69+0.5)*tbit_s}' 0
+ '{(73+0.375)*tbit_s}' 0
+ '{(73+0.375)*tbit_s+2e-11}' 1
+ '{(73+0.5)*tbit_s-2e-11}' 1
+ '{(73+0.5)*tbit_s}' 0
+ '{(75+0.375)*tbit_s}' 0
+ '{(75+0.375)*tbit_s+2e-11}' 1
+ '{(75+0.5)*tbit_s-2e-11}' 1
+ '{(75+0.5)*tbit_s}' 0
+ '{(77+0.375)*tbit_s}' 0
+ '{(77+0.375)*tbit_s+2e-11}' 1
+ '{(77+0.5)*tbit_s-2e-11}' 1
+ '{(77+0.5)*tbit_s}' 0
+ '{(78+0.375)*tbit_s}' 0
+ '{(78+0.375)*tbit_s+2e-11}' 1
+ '{(78+0.5)*tbit_s-2e-11}' 1
+ '{(78+0.5)*tbit_s}' 0
+ '{(84+0.375)*tbit_s}' 0
+ '{(84+0.375)*tbit_s+2e-11}' 1
+ '{(84+0.5)*tbit_s-2e-11}' 1
+ '{(84+0.5)*tbit_s}' 0
+ '{(86+0.375)*tbit_s}' 0
+ '{(86+0.375)*tbit_s+2e-11}' 1
+ '{(86+0.5)*tbit_s-2e-11}' 1
+ '{(86+0.5)*tbit_s}' 0
+ '{(87+0.375)*tbit_s}' 0
+ '{(87+0.375)*tbit_s+2e-11}' 1
+ '{(87+0.5)*tbit_s-2e-11}' 1
+ '{(87+0.5)*tbit_s}' 0
+ '{(88+0.375)*tbit_s}' 0
+ '{(88+0.375)*tbit_s+2e-11}' 1
+ '{(88+0.5)*tbit_s-2e-11}' 1
+ '{(88+0.5)*tbit_s}' 0
+ '{(89+0.375)*tbit_s}' 0
+ '{(89+0.375)*tbit_s+2e-11}' 1
+ '{(89+0.5)*tbit_s-2e-11}' 1
+ '{(89+0.5)*tbit_s}' 0
+ '{(93+0.375)*tbit_s}' 0
+ '{(93+0.375)*tbit_s+2e-11}' 1
+ '{(93+0.5)*tbit_s-2e-11}' 1
+ '{(93+0.5)*tbit_s}' 0
+ '{(94+0.375)*tbit_s}' 0
+ '{(94+0.375)*tbit_s+2e-11}' 1
+ '{(94+0.5)*tbit_s-2e-11}' 1
+ '{(94+0.5)*tbit_s}' 0
+ '{(95+0.375)*tbit_s}' 0
+ '{(95+0.375)*tbit_s+2e-11}' 1
+ '{(95+0.5)*tbit_s-2e-11}' 1
+ '{(95+0.5)*tbit_s}' 0
+ '{(97+0.375)*tbit_s}' 0
+ '{(97+0.375)*tbit_s+2e-11}' 1
+ '{(97+0.5)*tbit_s-2e-11}' 1
+ '{(97+0.5)*tbit_s}' 0
+ '{(98+0.375)*tbit_s}' 0
+ '{(98+0.375)*tbit_s+2e-11}' 1
+ '{(98+0.5)*tbit_s-2e-11}' 1
+ '{(98+0.5)*tbit_s}' 0
+ '{(100+0.375)*tbit_s}' 0
+ '{(100+0.375)*tbit_s+2e-11}' 1
+ '{(100+0.5)*tbit_s-2e-11}' 1
+ '{(100+0.5)*tbit_s}' 0
+ '{(101+0.375)*tbit_s}' 0
+ '{(101+0.375)*tbit_s+2e-11}' 1
+ '{(101+0.5)*tbit_s-2e-11}' 1
+ '{(101+0.5)*tbit_s}' 0
+ '{(104+0.375)*tbit_s}' 0
+ '{(104+0.375)*tbit_s+2e-11}' 1
+ '{(104+0.5)*tbit_s-2e-11}' 1
+ '{(104+0.5)*tbit_s}' 0
+ '{(107+0.375)*tbit_s}' 0
+ '{(107+0.375)*tbit_s+2e-11}' 1
+ '{(107+0.5)*tbit_s-2e-11}' 1
+ '{(107+0.5)*tbit_s}' 0
+ '{(109+0.375)*tbit_s}' 0
+ '{(109+0.375)*tbit_s+2e-11}' 1
+ '{(109+0.5)*tbit_s-2e-11}' 1
+ '{(109+0.5)*tbit_s}' 0
+ '{(112+0.375)*tbit_s}' 0
+ '{(112+0.375)*tbit_s+2e-11}' 1
+ '{(112+0.5)*tbit_s-2e-11}' 1
+ '{(112+0.5)*tbit_s}' 0
+ '{(117+0.375)*tbit_s}' 0
+ '{(117+0.375)*tbit_s+2e-11}' 1
+ '{(117+0.5)*tbit_s-2e-11}' 1
+ '{(117+0.5)*tbit_s}' 0
+ '{(120+0.375)*tbit_s}' 0
+ '{(120+0.375)*tbit_s+2e-11}' 1
+ '{(120+0.5)*tbit_s-2e-11}' 1
+ '{(120+0.5)*tbit_s}' 0
+ '{(121+0.375)*tbit_s}' 0
+ '{(121+0.375)*tbit_s+2e-11}' 1
+ '{(121+0.5)*tbit_s-2e-11}' 1
+ '{(121+0.5)*tbit_s}' 0
+ '{(122+0.375)*tbit_s}' 0
+ '{(122+0.375)*tbit_s+2e-11}' 1
+ '{(122+0.5)*tbit_s-2e-11}' 1
+ '{(122+0.5)*tbit_s}' 0
+ '{(125+0.375)*tbit_s}' 0
+ '{(125+0.375)*tbit_s+2e-11}' 1
+ '{(125+0.5)*tbit_s-2e-11}' 1
+ '{(125+0.5)*tbit_s}' 0
+ '{(127+0.375)*tbit_s}' 0
+ '{(127+0.375)*tbit_s+2e-11}' 1
+ '{(127+0.5)*tbit_s-2e-11}' 1
+ '{(127+0.5)*tbit_s}' 0
+ '{(128+0.375)*tbit_s}' 0
+ '{(128+0.375)*tbit_s+2e-11}' 1
+ '{(128+0.5)*tbit_s-2e-11}' 1
+ '{(128+0.5)*tbit_s}' 0
+ '{(130+0.375)*tbit_s}' 0
+ '{(130+0.375)*tbit_s+2e-11}' 1
+ '{(130+0.5)*tbit_s-2e-11}' 1
+ '{(130+0.5)*tbit_s}' 0
+ '{(134+0.375)*tbit_s}' 0
+ '{(134+0.375)*tbit_s+2e-11}' 1
+ '{(134+0.5)*tbit_s-2e-11}' 1
+ '{(134+0.5)*tbit_s}' 0
+ '{(138+0.375)*tbit_s}' 0
+ '{(138+0.375)*tbit_s+2e-11}' 1
+ '{(138+0.5)*tbit_s-2e-11}' 1
+ '{(138+0.5)*tbit_s}' 0
+ '{(139+0.375)*tbit_s}' 0
+ '{(139+0.375)*tbit_s+2e-11}' 1
+ '{(139+0.5)*tbit_s-2e-11}' 1
+ '{(139+0.5)*tbit_s}' 0
+ '{(142+0.375)*tbit_s}' 0
+ '{(142+0.375)*tbit_s+2e-11}' 1
+ '{(142+0.5)*tbit_s-2e-11}' 1
+ '{(142+0.5)*tbit_s}' 0
+ '{(143+0.375)*tbit_s}' 0
+ '{(143+0.375)*tbit_s+2e-11}' 1
+ '{(143+0.5)*tbit_s-2e-11}' 1
+ '{(143+0.5)*tbit_s}' 0
+ '{(145+0.375)*tbit_s}' 0
+ '{(145+0.375)*tbit_s+2e-11}' 1
+ '{(145+0.5)*tbit_s-2e-11}' 1
+ '{(145+0.5)*tbit_s}' 0
+ '{(147+0.375)*tbit_s}' 0
+ '{(147+0.375)*tbit_s+2e-11}' 1
+ '{(147+0.5)*tbit_s-2e-11}' 1
+ '{(147+0.5)*tbit_s}' 0
+ '{(149+0.375)*tbit_s}' 0
+ '{(149+0.375)*tbit_s+2e-11}' 1
+ '{(149+0.5)*tbit_s-2e-11}' 1
+ '{(149+0.5)*tbit_s}' 0
+ )
vcomb1_4 comb1_4 0 PWL(0 0
+ '{(23+0.5)*tbit_s}' 0
+ '{(23+0.5)*tbit_s+2e-11}' 1
+ '{(23+0.625)*tbit_s-2e-11}' 1
+ '{(23+0.625)*tbit_s}' 0
+ '{(24+0.5)*tbit_s}' 0
+ '{(24+0.5)*tbit_s+2e-11}' 1
+ '{(24+0.625)*tbit_s-2e-11}' 1
+ '{(24+0.625)*tbit_s}' 0
+ '{(25+0.5)*tbit_s}' 0
+ '{(25+0.5)*tbit_s+2e-11}' 1
+ '{(25+0.625)*tbit_s-2e-11}' 1
+ '{(25+0.625)*tbit_s}' 0
+ '{(26+0.5)*tbit_s}' 0
+ '{(26+0.5)*tbit_s+2e-11}' 1
+ '{(26+0.625)*tbit_s-2e-11}' 1
+ '{(26+0.625)*tbit_s}' 0
+ '{(27+0.5)*tbit_s}' 0
+ '{(27+0.5)*tbit_s+2e-11}' 1
+ '{(27+0.625)*tbit_s-2e-11}' 1
+ '{(27+0.625)*tbit_s}' 0
+ '{(28+0.5)*tbit_s}' 0
+ '{(28+0.5)*tbit_s+2e-11}' 1
+ '{(28+0.625)*tbit_s-2e-11}' 1
+ '{(28+0.625)*tbit_s}' 0
+ '{(29+0.5)*tbit_s}' 0
+ '{(29+0.5)*tbit_s+2e-11}' 1
+ '{(29+0.625)*tbit_s-2e-11}' 1
+ '{(29+0.625)*tbit_s}' 0
+ '{(36+0.5)*tbit_s}' 0
+ '{(36+0.5)*tbit_s+2e-11}' 1
+ '{(36+0.625)*tbit_s-2e-11}' 1
+ '{(36+0.625)*tbit_s}' 0
+ '{(42+0.5)*tbit_s}' 0
+ '{(42+0.5)*tbit_s+2e-11}' 1
+ '{(42+0.625)*tbit_s-2e-11}' 1
+ '{(42+0.625)*tbit_s}' 0
+ '{(43+0.5)*tbit_s}' 0
+ '{(43+0.5)*tbit_s+2e-11}' 1
+ '{(43+0.625)*tbit_s-2e-11}' 1
+ '{(43+0.625)*tbit_s}' 0
+ '{(48+0.5)*tbit_s}' 0
+ '{(48+0.5)*tbit_s+2e-11}' 1
+ '{(48+0.625)*tbit_s-2e-11}' 1
+ '{(48+0.625)*tbit_s}' 0
+ '{(50+0.5)*tbit_s}' 0
+ '{(50+0.5)*tbit_s+2e-11}' 1
+ '{(50+0.625)*tbit_s-2e-11}' 1
+ '{(50+0.625)*tbit_s}' 0
+ '{(54+0.5)*tbit_s}' 0
+ '{(54+0.5)*tbit_s+2e-11}' 1
+ '{(54+0.625)*tbit_s-2e-11}' 1
+ '{(54+0.625)*tbit_s}' 0
+ '{(55+0.5)*tbit_s}' 0
+ '{(55+0.5)*tbit_s+2e-11}' 1
+ '{(55+0.625)*tbit_s-2e-11}' 1
+ '{(55+0.625)*tbit_s}' 0
+ '{(56+0.5)*tbit_s}' 0
+ '{(56+0.5)*tbit_s+2e-11}' 1
+ '{(56+0.625)*tbit_s-2e-11}' 1
+ '{(56+0.625)*tbit_s}' 0
+ '{(57+0.5)*tbit_s}' 0
+ '{(57+0.5)*tbit_s+2e-11}' 1
+ '{(57+0.625)*tbit_s-2e-11}' 1
+ '{(57+0.625)*tbit_s}' 0
+ '{(60+0.5)*tbit_s}' 0
+ '{(60+0.5)*tbit_s+2e-11}' 1
+ '{(60+0.625)*tbit_s-2e-11}' 1
+ '{(60+0.625)*tbit_s}' 0
+ '{(64+0.5)*tbit_s}' 0
+ '{(64+0.5)*tbit_s+2e-11}' 1
+ '{(64+0.625)*tbit_s-2e-11}' 1
+ '{(64+0.625)*tbit_s}' 0
+ '{(66+0.5)*tbit_s}' 0
+ '{(66+0.5)*tbit_s+2e-11}' 1
+ '{(66+0.625)*tbit_s-2e-11}' 1
+ '{(66+0.625)*tbit_s}' 0
+ '{(67+0.5)*tbit_s}' 0
+ '{(67+0.5)*tbit_s+2e-11}' 1
+ '{(67+0.625)*tbit_s-2e-11}' 1
+ '{(67+0.625)*tbit_s}' 0
+ '{(70+0.5)*tbit_s}' 0
+ '{(70+0.5)*tbit_s+2e-11}' 1
+ '{(70+0.625)*tbit_s-2e-11}' 1
+ '{(70+0.625)*tbit_s}' 0
+ '{(71+0.5)*tbit_s}' 0
+ '{(71+0.5)*tbit_s+2e-11}' 1
+ '{(71+0.625)*tbit_s-2e-11}' 1
+ '{(71+0.625)*tbit_s}' 0
+ '{(72+0.5)*tbit_s}' 0
+ '{(72+0.5)*tbit_s+2e-11}' 1
+ '{(72+0.625)*tbit_s-2e-11}' 1
+ '{(72+0.625)*tbit_s}' 0
+ '{(74+0.5)*tbit_s}' 0
+ '{(74+0.5)*tbit_s+2e-11}' 1
+ '{(74+0.625)*tbit_s-2e-11}' 1
+ '{(74+0.625)*tbit_s}' 0
+ '{(76+0.5)*tbit_s}' 0
+ '{(76+0.5)*tbit_s+2e-11}' 1
+ '{(76+0.625)*tbit_s-2e-11}' 1
+ '{(76+0.625)*tbit_s}' 0
+ '{(79+0.5)*tbit_s}' 0
+ '{(79+0.5)*tbit_s+2e-11}' 1
+ '{(79+0.625)*tbit_s-2e-11}' 1
+ '{(79+0.625)*tbit_s}' 0
+ '{(80+0.5)*tbit_s}' 0
+ '{(80+0.5)*tbit_s+2e-11}' 1
+ '{(80+0.625)*tbit_s-2e-11}' 1
+ '{(80+0.625)*tbit_s}' 0
+ '{(81+0.5)*tbit_s}' 0
+ '{(81+0.5)*tbit_s+2e-11}' 1
+ '{(81+0.625)*tbit_s-2e-11}' 1
+ '{(81+0.625)*tbit_s}' 0
+ '{(82+0.5)*tbit_s}' 0
+ '{(82+0.5)*tbit_s+2e-11}' 1
+ '{(82+0.625)*tbit_s-2e-11}' 1
+ '{(82+0.625)*tbit_s}' 0
+ '{(83+0.5)*tbit_s}' 0
+ '{(83+0.5)*tbit_s+2e-11}' 1
+ '{(83+0.625)*tbit_s-2e-11}' 1
+ '{(83+0.625)*tbit_s}' 0
+ '{(85+0.5)*tbit_s}' 0
+ '{(85+0.5)*tbit_s+2e-11}' 1
+ '{(85+0.625)*tbit_s-2e-11}' 1
+ '{(85+0.625)*tbit_s}' 0
+ '{(90+0.5)*tbit_s}' 0
+ '{(90+0.5)*tbit_s+2e-11}' 1
+ '{(90+0.625)*tbit_s-2e-11}' 1
+ '{(90+0.625)*tbit_s}' 0
+ '{(91+0.5)*tbit_s}' 0
+ '{(91+0.5)*tbit_s+2e-11}' 1
+ '{(91+0.625)*tbit_s-2e-11}' 1
+ '{(91+0.625)*tbit_s}' 0
+ '{(92+0.5)*tbit_s}' 0
+ '{(92+0.5)*tbit_s+2e-11}' 1
+ '{(92+0.625)*tbit_s-2e-11}' 1
+ '{(92+0.625)*tbit_s}' 0
+ '{(96+0.5)*tbit_s}' 0
+ '{(96+0.5)*tbit_s+2e-11}' 1
+ '{(96+0.625)*tbit_s-2e-11}' 1
+ '{(96+0.625)*tbit_s}' 0
+ '{(99+0.5)*tbit_s}' 0
+ '{(99+0.5)*tbit_s+2e-11}' 1
+ '{(99+0.625)*tbit_s-2e-11}' 1
+ '{(99+0.625)*tbit_s}' 0
+ '{(102+0.5)*tbit_s}' 0
+ '{(102+0.5)*tbit_s+2e-11}' 1
+ '{(102+0.625)*tbit_s-2e-11}' 1
+ '{(102+0.625)*tbit_s}' 0
+ '{(103+0.5)*tbit_s}' 0
+ '{(103+0.5)*tbit_s+2e-11}' 1
+ '{(103+0.625)*tbit_s-2e-11}' 1
+ '{(103+0.625)*tbit_s}' 0
+ '{(105+0.5)*tbit_s}' 0
+ '{(105+0.5)*tbit_s+2e-11}' 1
+ '{(105+0.625)*tbit_s-2e-11}' 1
+ '{(105+0.625)*tbit_s}' 0
+ '{(106+0.5)*tbit_s}' 0
+ '{(106+0.5)*tbit_s+2e-11}' 1
+ '{(106+0.625)*tbit_s-2e-11}' 1
+ '{(106+0.625)*tbit_s}' 0
+ '{(108+0.5)*tbit_s}' 0
+ '{(108+0.5)*tbit_s+2e-11}' 1
+ '{(108+0.625)*tbit_s-2e-11}' 1
+ '{(108+0.625)*tbit_s}' 0
+ '{(110+0.5)*tbit_s}' 0
+ '{(110+0.5)*tbit_s+2e-11}' 1
+ '{(110+0.625)*tbit_s-2e-11}' 1
+ '{(110+0.625)*tbit_s}' 0
+ '{(111+0.5)*tbit_s}' 0
+ '{(111+0.5)*tbit_s+2e-11}' 1
+ '{(111+0.625)*tbit_s-2e-11}' 1
+ '{(111+0.625)*tbit_s}' 0
+ '{(113+0.5)*tbit_s}' 0
+ '{(113+0.5)*tbit_s+2e-11}' 1
+ '{(113+0.625)*tbit_s-2e-11}' 1
+ '{(113+0.625)*tbit_s}' 0
+ '{(114+0.5)*tbit_s}' 0
+ '{(114+0.5)*tbit_s+2e-11}' 1
+ '{(114+0.625)*tbit_s-2e-11}' 1
+ '{(114+0.625)*tbit_s}' 0
+ '{(115+0.5)*tbit_s}' 0
+ '{(115+0.5)*tbit_s+2e-11}' 1
+ '{(115+0.625)*tbit_s-2e-11}' 1
+ '{(115+0.625)*tbit_s}' 0
+ '{(116+0.5)*tbit_s}' 0
+ '{(116+0.5)*tbit_s+2e-11}' 1
+ '{(116+0.625)*tbit_s-2e-11}' 1
+ '{(116+0.625)*tbit_s}' 0
+ '{(118+0.5)*tbit_s}' 0
+ '{(118+0.5)*tbit_s+2e-11}' 1
+ '{(118+0.625)*tbit_s-2e-11}' 1
+ '{(118+0.625)*tbit_s}' 0
+ '{(119+0.5)*tbit_s}' 0
+ '{(119+0.5)*tbit_s+2e-11}' 1
+ '{(119+0.625)*tbit_s-2e-11}' 1
+ '{(119+0.625)*tbit_s}' 0
+ '{(123+0.5)*tbit_s}' 0
+ '{(123+0.5)*tbit_s+2e-11}' 1
+ '{(123+0.625)*tbit_s-2e-11}' 1
+ '{(123+0.625)*tbit_s}' 0
+ '{(124+0.5)*tbit_s}' 0
+ '{(124+0.5)*tbit_s+2e-11}' 1
+ '{(124+0.625)*tbit_s-2e-11}' 1
+ '{(124+0.625)*tbit_s}' 0
+ '{(126+0.5)*tbit_s}' 0
+ '{(126+0.5)*tbit_s+2e-11}' 1
+ '{(126+0.625)*tbit_s-2e-11}' 1
+ '{(126+0.625)*tbit_s}' 0
+ '{(129+0.5)*tbit_s}' 0
+ '{(129+0.5)*tbit_s+2e-11}' 1
+ '{(129+0.625)*tbit_s-2e-11}' 1
+ '{(129+0.625)*tbit_s}' 0
+ '{(131+0.5)*tbit_s}' 0
+ '{(131+0.5)*tbit_s+2e-11}' 1
+ '{(131+0.625)*tbit_s-2e-11}' 1
+ '{(131+0.625)*tbit_s}' 0
+ '{(132+0.5)*tbit_s}' 0
+ '{(132+0.5)*tbit_s+2e-11}' 1
+ '{(132+0.625)*tbit_s-2e-11}' 1
+ '{(132+0.625)*tbit_s}' 0
+ '{(133+0.5)*tbit_s}' 0
+ '{(133+0.5)*tbit_s+2e-11}' 1
+ '{(133+0.625)*tbit_s-2e-11}' 1
+ '{(133+0.625)*tbit_s}' 0
+ '{(135+0.5)*tbit_s}' 0
+ '{(135+0.5)*tbit_s+2e-11}' 1
+ '{(135+0.625)*tbit_s-2e-11}' 1
+ '{(135+0.625)*tbit_s}' 0
+ '{(136+0.5)*tbit_s}' 0
+ '{(136+0.5)*tbit_s+2e-11}' 1
+ '{(136+0.625)*tbit_s-2e-11}' 1
+ '{(136+0.625)*tbit_s}' 0
+ '{(137+0.5)*tbit_s}' 0
+ '{(137+0.5)*tbit_s+2e-11}' 1
+ '{(137+0.625)*tbit_s-2e-11}' 1
+ '{(137+0.625)*tbit_s}' 0
+ '{(140+0.5)*tbit_s}' 0
+ '{(140+0.5)*tbit_s+2e-11}' 1
+ '{(140+0.625)*tbit_s-2e-11}' 1
+ '{(140+0.625)*tbit_s}' 0
+ '{(141+0.5)*tbit_s}' 0
+ '{(141+0.5)*tbit_s+2e-11}' 1
+ '{(141+0.625)*tbit_s-2e-11}' 1
+ '{(141+0.625)*tbit_s}' 0
+ '{(144+0.5)*tbit_s}' 0
+ '{(144+0.5)*tbit_s+2e-11}' 1
+ '{(144+0.625)*tbit_s-2e-11}' 1
+ '{(144+0.625)*tbit_s}' 0
+ '{(146+0.5)*tbit_s}' 0
+ '{(146+0.5)*tbit_s+2e-11}' 1
+ '{(146+0.625)*tbit_s-2e-11}' 1
+ '{(146+0.625)*tbit_s}' 0
+ '{(148+0.5)*tbit_s}' 0
+ '{(148+0.5)*tbit_s+2e-11}' 1
+ '{(148+0.625)*tbit_s-2e-11}' 1
+ '{(148+0.625)*tbit_s}' 0
+ )
vcomb0_4 comb0_4 0 PWL(0 0
+ '{(30+0.5)*tbit_s}' 0
+ '{(30+0.5)*tbit_s+2e-11}' 1
+ '{(30+0.625)*tbit_s-2e-11}' 1
+ '{(30+0.625)*tbit_s}' 0
+ '{(31+0.5)*tbit_s}' 0
+ '{(31+0.5)*tbit_s+2e-11}' 1
+ '{(31+0.625)*tbit_s-2e-11}' 1
+ '{(31+0.625)*tbit_s}' 0
+ '{(32+0.5)*tbit_s}' 0
+ '{(32+0.5)*tbit_s+2e-11}' 1
+ '{(32+0.625)*tbit_s-2e-11}' 1
+ '{(32+0.625)*tbit_s}' 0
+ '{(33+0.5)*tbit_s}' 0
+ '{(33+0.5)*tbit_s+2e-11}' 1
+ '{(33+0.625)*tbit_s-2e-11}' 1
+ '{(33+0.625)*tbit_s}' 0
+ '{(34+0.5)*tbit_s}' 0
+ '{(34+0.5)*tbit_s+2e-11}' 1
+ '{(34+0.625)*tbit_s-2e-11}' 1
+ '{(34+0.625)*tbit_s}' 0
+ '{(35+0.5)*tbit_s}' 0
+ '{(35+0.5)*tbit_s+2e-11}' 1
+ '{(35+0.625)*tbit_s-2e-11}' 1
+ '{(35+0.625)*tbit_s}' 0
+ '{(37+0.5)*tbit_s}' 0
+ '{(37+0.5)*tbit_s+2e-11}' 1
+ '{(37+0.625)*tbit_s-2e-11}' 1
+ '{(37+0.625)*tbit_s}' 0
+ '{(38+0.5)*tbit_s}' 0
+ '{(38+0.5)*tbit_s+2e-11}' 1
+ '{(38+0.625)*tbit_s-2e-11}' 1
+ '{(38+0.625)*tbit_s}' 0
+ '{(39+0.5)*tbit_s}' 0
+ '{(39+0.5)*tbit_s+2e-11}' 1
+ '{(39+0.625)*tbit_s-2e-11}' 1
+ '{(39+0.625)*tbit_s}' 0
+ '{(40+0.5)*tbit_s}' 0
+ '{(40+0.5)*tbit_s+2e-11}' 1
+ '{(40+0.625)*tbit_s-2e-11}' 1
+ '{(40+0.625)*tbit_s}' 0
+ '{(41+0.5)*tbit_s}' 0
+ '{(41+0.5)*tbit_s+2e-11}' 1
+ '{(41+0.625)*tbit_s-2e-11}' 1
+ '{(41+0.625)*tbit_s}' 0
+ '{(44+0.5)*tbit_s}' 0
+ '{(44+0.5)*tbit_s+2e-11}' 1
+ '{(44+0.625)*tbit_s-2e-11}' 1
+ '{(44+0.625)*tbit_s}' 0
+ '{(45+0.5)*tbit_s}' 0
+ '{(45+0.5)*tbit_s+2e-11}' 1
+ '{(45+0.625)*tbit_s-2e-11}' 1
+ '{(45+0.625)*tbit_s}' 0
+ '{(46+0.5)*tbit_s}' 0
+ '{(46+0.5)*tbit_s+2e-11}' 1
+ '{(46+0.625)*tbit_s-2e-11}' 1
+ '{(46+0.625)*tbit_s}' 0
+ '{(47+0.5)*tbit_s}' 0
+ '{(47+0.5)*tbit_s+2e-11}' 1
+ '{(47+0.625)*tbit_s-2e-11}' 1
+ '{(47+0.625)*tbit_s}' 0
+ '{(49+0.5)*tbit_s}' 0
+ '{(49+0.5)*tbit_s+2e-11}' 1
+ '{(49+0.625)*tbit_s-2e-11}' 1
+ '{(49+0.625)*tbit_s}' 0
+ '{(51+0.5)*tbit_s}' 0
+ '{(51+0.5)*tbit_s+2e-11}' 1
+ '{(51+0.625)*tbit_s-2e-11}' 1
+ '{(51+0.625)*tbit_s}' 0
+ '{(52+0.5)*tbit_s}' 0
+ '{(52+0.5)*tbit_s+2e-11}' 1
+ '{(52+0.625)*tbit_s-2e-11}' 1
+ '{(52+0.625)*tbit_s}' 0
+ '{(53+0.5)*tbit_s}' 0
+ '{(53+0.5)*tbit_s+2e-11}' 1
+ '{(53+0.625)*tbit_s-2e-11}' 1
+ '{(53+0.625)*tbit_s}' 0
+ '{(58+0.5)*tbit_s}' 0
+ '{(58+0.5)*tbit_s+2e-11}' 1
+ '{(58+0.625)*tbit_s-2e-11}' 1
+ '{(58+0.625)*tbit_s}' 0
+ '{(59+0.5)*tbit_s}' 0
+ '{(59+0.5)*tbit_s+2e-11}' 1
+ '{(59+0.625)*tbit_s-2e-11}' 1
+ '{(59+0.625)*tbit_s}' 0
+ '{(61+0.5)*tbit_s}' 0
+ '{(61+0.5)*tbit_s+2e-11}' 1
+ '{(61+0.625)*tbit_s-2e-11}' 1
+ '{(61+0.625)*tbit_s}' 0
+ '{(62+0.5)*tbit_s}' 0
+ '{(62+0.5)*tbit_s+2e-11}' 1
+ '{(62+0.625)*tbit_s-2e-11}' 1
+ '{(62+0.625)*tbit_s}' 0
+ '{(63+0.5)*tbit_s}' 0
+ '{(63+0.5)*tbit_s+2e-11}' 1
+ '{(63+0.625)*tbit_s-2e-11}' 1
+ '{(63+0.625)*tbit_s}' 0
+ '{(65+0.5)*tbit_s}' 0
+ '{(65+0.5)*tbit_s+2e-11}' 1
+ '{(65+0.625)*tbit_s-2e-11}' 1
+ '{(65+0.625)*tbit_s}' 0
+ '{(68+0.5)*tbit_s}' 0
+ '{(68+0.5)*tbit_s+2e-11}' 1
+ '{(68+0.625)*tbit_s-2e-11}' 1
+ '{(68+0.625)*tbit_s}' 0
+ '{(69+0.5)*tbit_s}' 0
+ '{(69+0.5)*tbit_s+2e-11}' 1
+ '{(69+0.625)*tbit_s-2e-11}' 1
+ '{(69+0.625)*tbit_s}' 0
+ '{(73+0.5)*tbit_s}' 0
+ '{(73+0.5)*tbit_s+2e-11}' 1
+ '{(73+0.625)*tbit_s-2e-11}' 1
+ '{(73+0.625)*tbit_s}' 0
+ '{(75+0.5)*tbit_s}' 0
+ '{(75+0.5)*tbit_s+2e-11}' 1
+ '{(75+0.625)*tbit_s-2e-11}' 1
+ '{(75+0.625)*tbit_s}' 0
+ '{(77+0.5)*tbit_s}' 0
+ '{(77+0.5)*tbit_s+2e-11}' 1
+ '{(77+0.625)*tbit_s-2e-11}' 1
+ '{(77+0.625)*tbit_s}' 0
+ '{(78+0.5)*tbit_s}' 0
+ '{(78+0.5)*tbit_s+2e-11}' 1
+ '{(78+0.625)*tbit_s-2e-11}' 1
+ '{(78+0.625)*tbit_s}' 0
+ '{(84+0.5)*tbit_s}' 0
+ '{(84+0.5)*tbit_s+2e-11}' 1
+ '{(84+0.625)*tbit_s-2e-11}' 1
+ '{(84+0.625)*tbit_s}' 0
+ '{(86+0.5)*tbit_s}' 0
+ '{(86+0.5)*tbit_s+2e-11}' 1
+ '{(86+0.625)*tbit_s-2e-11}' 1
+ '{(86+0.625)*tbit_s}' 0
+ '{(87+0.5)*tbit_s}' 0
+ '{(87+0.5)*tbit_s+2e-11}' 1
+ '{(87+0.625)*tbit_s-2e-11}' 1
+ '{(87+0.625)*tbit_s}' 0
+ '{(88+0.5)*tbit_s}' 0
+ '{(88+0.5)*tbit_s+2e-11}' 1
+ '{(88+0.625)*tbit_s-2e-11}' 1
+ '{(88+0.625)*tbit_s}' 0
+ '{(89+0.5)*tbit_s}' 0
+ '{(89+0.5)*tbit_s+2e-11}' 1
+ '{(89+0.625)*tbit_s-2e-11}' 1
+ '{(89+0.625)*tbit_s}' 0
+ '{(93+0.5)*tbit_s}' 0
+ '{(93+0.5)*tbit_s+2e-11}' 1
+ '{(93+0.625)*tbit_s-2e-11}' 1
+ '{(93+0.625)*tbit_s}' 0
+ '{(94+0.5)*tbit_s}' 0
+ '{(94+0.5)*tbit_s+2e-11}' 1
+ '{(94+0.625)*tbit_s-2e-11}' 1
+ '{(94+0.625)*tbit_s}' 0
+ '{(95+0.5)*tbit_s}' 0
+ '{(95+0.5)*tbit_s+2e-11}' 1
+ '{(95+0.625)*tbit_s-2e-11}' 1
+ '{(95+0.625)*tbit_s}' 0
+ '{(97+0.5)*tbit_s}' 0
+ '{(97+0.5)*tbit_s+2e-11}' 1
+ '{(97+0.625)*tbit_s-2e-11}' 1
+ '{(97+0.625)*tbit_s}' 0
+ '{(98+0.5)*tbit_s}' 0
+ '{(98+0.5)*tbit_s+2e-11}' 1
+ '{(98+0.625)*tbit_s-2e-11}' 1
+ '{(98+0.625)*tbit_s}' 0
+ '{(100+0.5)*tbit_s}' 0
+ '{(100+0.5)*tbit_s+2e-11}' 1
+ '{(100+0.625)*tbit_s-2e-11}' 1
+ '{(100+0.625)*tbit_s}' 0
+ '{(101+0.5)*tbit_s}' 0
+ '{(101+0.5)*tbit_s+2e-11}' 1
+ '{(101+0.625)*tbit_s-2e-11}' 1
+ '{(101+0.625)*tbit_s}' 0
+ '{(104+0.5)*tbit_s}' 0
+ '{(104+0.5)*tbit_s+2e-11}' 1
+ '{(104+0.625)*tbit_s-2e-11}' 1
+ '{(104+0.625)*tbit_s}' 0
+ '{(107+0.5)*tbit_s}' 0
+ '{(107+0.5)*tbit_s+2e-11}' 1
+ '{(107+0.625)*tbit_s-2e-11}' 1
+ '{(107+0.625)*tbit_s}' 0
+ '{(109+0.5)*tbit_s}' 0
+ '{(109+0.5)*tbit_s+2e-11}' 1
+ '{(109+0.625)*tbit_s-2e-11}' 1
+ '{(109+0.625)*tbit_s}' 0
+ '{(112+0.5)*tbit_s}' 0
+ '{(112+0.5)*tbit_s+2e-11}' 1
+ '{(112+0.625)*tbit_s-2e-11}' 1
+ '{(112+0.625)*tbit_s}' 0
+ '{(117+0.5)*tbit_s}' 0
+ '{(117+0.5)*tbit_s+2e-11}' 1
+ '{(117+0.625)*tbit_s-2e-11}' 1
+ '{(117+0.625)*tbit_s}' 0
+ '{(120+0.5)*tbit_s}' 0
+ '{(120+0.5)*tbit_s+2e-11}' 1
+ '{(120+0.625)*tbit_s-2e-11}' 1
+ '{(120+0.625)*tbit_s}' 0
+ '{(121+0.5)*tbit_s}' 0
+ '{(121+0.5)*tbit_s+2e-11}' 1
+ '{(121+0.625)*tbit_s-2e-11}' 1
+ '{(121+0.625)*tbit_s}' 0
+ '{(122+0.5)*tbit_s}' 0
+ '{(122+0.5)*tbit_s+2e-11}' 1
+ '{(122+0.625)*tbit_s-2e-11}' 1
+ '{(122+0.625)*tbit_s}' 0
+ '{(125+0.5)*tbit_s}' 0
+ '{(125+0.5)*tbit_s+2e-11}' 1
+ '{(125+0.625)*tbit_s-2e-11}' 1
+ '{(125+0.625)*tbit_s}' 0
+ '{(127+0.5)*tbit_s}' 0
+ '{(127+0.5)*tbit_s+2e-11}' 1
+ '{(127+0.625)*tbit_s-2e-11}' 1
+ '{(127+0.625)*tbit_s}' 0
+ '{(128+0.5)*tbit_s}' 0
+ '{(128+0.5)*tbit_s+2e-11}' 1
+ '{(128+0.625)*tbit_s-2e-11}' 1
+ '{(128+0.625)*tbit_s}' 0
+ '{(130+0.5)*tbit_s}' 0
+ '{(130+0.5)*tbit_s+2e-11}' 1
+ '{(130+0.625)*tbit_s-2e-11}' 1
+ '{(130+0.625)*tbit_s}' 0
+ '{(134+0.5)*tbit_s}' 0
+ '{(134+0.5)*tbit_s+2e-11}' 1
+ '{(134+0.625)*tbit_s-2e-11}' 1
+ '{(134+0.625)*tbit_s}' 0
+ '{(138+0.5)*tbit_s}' 0
+ '{(138+0.5)*tbit_s+2e-11}' 1
+ '{(138+0.625)*tbit_s-2e-11}' 1
+ '{(138+0.625)*tbit_s}' 0
+ '{(139+0.5)*tbit_s}' 0
+ '{(139+0.5)*tbit_s+2e-11}' 1
+ '{(139+0.625)*tbit_s-2e-11}' 1
+ '{(139+0.625)*tbit_s}' 0
+ '{(142+0.5)*tbit_s}' 0
+ '{(142+0.5)*tbit_s+2e-11}' 1
+ '{(142+0.625)*tbit_s-2e-11}' 1
+ '{(142+0.625)*tbit_s}' 0
+ '{(143+0.5)*tbit_s}' 0
+ '{(143+0.5)*tbit_s+2e-11}' 1
+ '{(143+0.625)*tbit_s-2e-11}' 1
+ '{(143+0.625)*tbit_s}' 0
+ '{(145+0.5)*tbit_s}' 0
+ '{(145+0.5)*tbit_s+2e-11}' 1
+ '{(145+0.625)*tbit_s-2e-11}' 1
+ '{(145+0.625)*tbit_s}' 0
+ '{(147+0.5)*tbit_s}' 0
+ '{(147+0.5)*tbit_s+2e-11}' 1
+ '{(147+0.625)*tbit_s-2e-11}' 1
+ '{(147+0.625)*tbit_s}' 0
+ '{(149+0.5)*tbit_s}' 0
+ '{(149+0.5)*tbit_s+2e-11}' 1
+ '{(149+0.625)*tbit_s-2e-11}' 1
+ '{(149+0.625)*tbit_s}' 0
+ )
vcomb1_5 comb1_5 0 PWL(0 0
+ '{(23+0.625)*tbit_s}' 0
+ '{(23+0.625)*tbit_s+2e-11}' 1
+ '{(23+0.75)*tbit_s-2e-11}' 1
+ '{(23+0.75)*tbit_s}' 0
+ '{(24+0.625)*tbit_s}' 0
+ '{(24+0.625)*tbit_s+2e-11}' 1
+ '{(24+0.75)*tbit_s-2e-11}' 1
+ '{(24+0.75)*tbit_s}' 0
+ '{(25+0.625)*tbit_s}' 0
+ '{(25+0.625)*tbit_s+2e-11}' 1
+ '{(25+0.75)*tbit_s-2e-11}' 1
+ '{(25+0.75)*tbit_s}' 0
+ '{(26+0.625)*tbit_s}' 0
+ '{(26+0.625)*tbit_s+2e-11}' 1
+ '{(26+0.75)*tbit_s-2e-11}' 1
+ '{(26+0.75)*tbit_s}' 0
+ '{(27+0.625)*tbit_s}' 0
+ '{(27+0.625)*tbit_s+2e-11}' 1
+ '{(27+0.75)*tbit_s-2e-11}' 1
+ '{(27+0.75)*tbit_s}' 0
+ '{(28+0.625)*tbit_s}' 0
+ '{(28+0.625)*tbit_s+2e-11}' 1
+ '{(28+0.75)*tbit_s-2e-11}' 1
+ '{(28+0.75)*tbit_s}' 0
+ '{(29+0.625)*tbit_s}' 0
+ '{(29+0.625)*tbit_s+2e-11}' 1
+ '{(29+0.75)*tbit_s-2e-11}' 1
+ '{(29+0.75)*tbit_s}' 0
+ '{(36+0.625)*tbit_s}' 0
+ '{(36+0.625)*tbit_s+2e-11}' 1
+ '{(36+0.75)*tbit_s-2e-11}' 1
+ '{(36+0.75)*tbit_s}' 0
+ '{(42+0.625)*tbit_s}' 0
+ '{(42+0.625)*tbit_s+2e-11}' 1
+ '{(42+0.75)*tbit_s-2e-11}' 1
+ '{(42+0.75)*tbit_s}' 0
+ '{(43+0.625)*tbit_s}' 0
+ '{(43+0.625)*tbit_s+2e-11}' 1
+ '{(43+0.75)*tbit_s-2e-11}' 1
+ '{(43+0.75)*tbit_s}' 0
+ '{(48+0.625)*tbit_s}' 0
+ '{(48+0.625)*tbit_s+2e-11}' 1
+ '{(48+0.75)*tbit_s-2e-11}' 1
+ '{(48+0.75)*tbit_s}' 0
+ '{(50+0.625)*tbit_s}' 0
+ '{(50+0.625)*tbit_s+2e-11}' 1
+ '{(50+0.75)*tbit_s-2e-11}' 1
+ '{(50+0.75)*tbit_s}' 0
+ '{(54+0.625)*tbit_s}' 0
+ '{(54+0.625)*tbit_s+2e-11}' 1
+ '{(54+0.75)*tbit_s-2e-11}' 1
+ '{(54+0.75)*tbit_s}' 0
+ '{(55+0.625)*tbit_s}' 0
+ '{(55+0.625)*tbit_s+2e-11}' 1
+ '{(55+0.75)*tbit_s-2e-11}' 1
+ '{(55+0.75)*tbit_s}' 0
+ '{(56+0.625)*tbit_s}' 0
+ '{(56+0.625)*tbit_s+2e-11}' 1
+ '{(56+0.75)*tbit_s-2e-11}' 1
+ '{(56+0.75)*tbit_s}' 0
+ '{(57+0.625)*tbit_s}' 0
+ '{(57+0.625)*tbit_s+2e-11}' 1
+ '{(57+0.75)*tbit_s-2e-11}' 1
+ '{(57+0.75)*tbit_s}' 0
+ '{(60+0.625)*tbit_s}' 0
+ '{(60+0.625)*tbit_s+2e-11}' 1
+ '{(60+0.75)*tbit_s-2e-11}' 1
+ '{(60+0.75)*tbit_s}' 0
+ '{(64+0.625)*tbit_s}' 0
+ '{(64+0.625)*tbit_s+2e-11}' 1
+ '{(64+0.75)*tbit_s-2e-11}' 1
+ '{(64+0.75)*tbit_s}' 0
+ '{(66+0.625)*tbit_s}' 0
+ '{(66+0.625)*tbit_s+2e-11}' 1
+ '{(66+0.75)*tbit_s-2e-11}' 1
+ '{(66+0.75)*tbit_s}' 0
+ '{(67+0.625)*tbit_s}' 0
+ '{(67+0.625)*tbit_s+2e-11}' 1
+ '{(67+0.75)*tbit_s-2e-11}' 1
+ '{(67+0.75)*tbit_s}' 0
+ '{(70+0.625)*tbit_s}' 0
+ '{(70+0.625)*tbit_s+2e-11}' 1
+ '{(70+0.75)*tbit_s-2e-11}' 1
+ '{(70+0.75)*tbit_s}' 0
+ '{(71+0.625)*tbit_s}' 0
+ '{(71+0.625)*tbit_s+2e-11}' 1
+ '{(71+0.75)*tbit_s-2e-11}' 1
+ '{(71+0.75)*tbit_s}' 0
+ '{(72+0.625)*tbit_s}' 0
+ '{(72+0.625)*tbit_s+2e-11}' 1
+ '{(72+0.75)*tbit_s-2e-11}' 1
+ '{(72+0.75)*tbit_s}' 0
+ '{(74+0.625)*tbit_s}' 0
+ '{(74+0.625)*tbit_s+2e-11}' 1
+ '{(74+0.75)*tbit_s-2e-11}' 1
+ '{(74+0.75)*tbit_s}' 0
+ '{(76+0.625)*tbit_s}' 0
+ '{(76+0.625)*tbit_s+2e-11}' 1
+ '{(76+0.75)*tbit_s-2e-11}' 1
+ '{(76+0.75)*tbit_s}' 0
+ '{(79+0.625)*tbit_s}' 0
+ '{(79+0.625)*tbit_s+2e-11}' 1
+ '{(79+0.75)*tbit_s-2e-11}' 1
+ '{(79+0.75)*tbit_s}' 0
+ '{(80+0.625)*tbit_s}' 0
+ '{(80+0.625)*tbit_s+2e-11}' 1
+ '{(80+0.75)*tbit_s-2e-11}' 1
+ '{(80+0.75)*tbit_s}' 0
+ '{(81+0.625)*tbit_s}' 0
+ '{(81+0.625)*tbit_s+2e-11}' 1
+ '{(81+0.75)*tbit_s-2e-11}' 1
+ '{(81+0.75)*tbit_s}' 0
+ '{(82+0.625)*tbit_s}' 0
+ '{(82+0.625)*tbit_s+2e-11}' 1
+ '{(82+0.75)*tbit_s-2e-11}' 1
+ '{(82+0.75)*tbit_s}' 0
+ '{(83+0.625)*tbit_s}' 0
+ '{(83+0.625)*tbit_s+2e-11}' 1
+ '{(83+0.75)*tbit_s-2e-11}' 1
+ '{(83+0.75)*tbit_s}' 0
+ '{(85+0.625)*tbit_s}' 0
+ '{(85+0.625)*tbit_s+2e-11}' 1
+ '{(85+0.75)*tbit_s-2e-11}' 1
+ '{(85+0.75)*tbit_s}' 0
+ '{(90+0.625)*tbit_s}' 0
+ '{(90+0.625)*tbit_s+2e-11}' 1
+ '{(90+0.75)*tbit_s-2e-11}' 1
+ '{(90+0.75)*tbit_s}' 0
+ '{(91+0.625)*tbit_s}' 0
+ '{(91+0.625)*tbit_s+2e-11}' 1
+ '{(91+0.75)*tbit_s-2e-11}' 1
+ '{(91+0.75)*tbit_s}' 0
+ '{(92+0.625)*tbit_s}' 0
+ '{(92+0.625)*tbit_s+2e-11}' 1
+ '{(92+0.75)*tbit_s-2e-11}' 1
+ '{(92+0.75)*tbit_s}' 0
+ '{(96+0.625)*tbit_s}' 0
+ '{(96+0.625)*tbit_s+2e-11}' 1
+ '{(96+0.75)*tbit_s-2e-11}' 1
+ '{(96+0.75)*tbit_s}' 0
+ '{(99+0.625)*tbit_s}' 0
+ '{(99+0.625)*tbit_s+2e-11}' 1
+ '{(99+0.75)*tbit_s-2e-11}' 1
+ '{(99+0.75)*tbit_s}' 0
+ '{(102+0.625)*tbit_s}' 0
+ '{(102+0.625)*tbit_s+2e-11}' 1
+ '{(102+0.75)*tbit_s-2e-11}' 1
+ '{(102+0.75)*tbit_s}' 0
+ '{(103+0.625)*tbit_s}' 0
+ '{(103+0.625)*tbit_s+2e-11}' 1
+ '{(103+0.75)*tbit_s-2e-11}' 1
+ '{(103+0.75)*tbit_s}' 0
+ '{(105+0.625)*tbit_s}' 0
+ '{(105+0.625)*tbit_s+2e-11}' 1
+ '{(105+0.75)*tbit_s-2e-11}' 1
+ '{(105+0.75)*tbit_s}' 0
+ '{(106+0.625)*tbit_s}' 0
+ '{(106+0.625)*tbit_s+2e-11}' 1
+ '{(106+0.75)*tbit_s-2e-11}' 1
+ '{(106+0.75)*tbit_s}' 0
+ '{(108+0.625)*tbit_s}' 0
+ '{(108+0.625)*tbit_s+2e-11}' 1
+ '{(108+0.75)*tbit_s-2e-11}' 1
+ '{(108+0.75)*tbit_s}' 0
+ '{(110+0.625)*tbit_s}' 0
+ '{(110+0.625)*tbit_s+2e-11}' 1
+ '{(110+0.75)*tbit_s-2e-11}' 1
+ '{(110+0.75)*tbit_s}' 0
+ '{(111+0.625)*tbit_s}' 0
+ '{(111+0.625)*tbit_s+2e-11}' 1
+ '{(111+0.75)*tbit_s-2e-11}' 1
+ '{(111+0.75)*tbit_s}' 0
+ '{(113+0.625)*tbit_s}' 0
+ '{(113+0.625)*tbit_s+2e-11}' 1
+ '{(113+0.75)*tbit_s-2e-11}' 1
+ '{(113+0.75)*tbit_s}' 0
+ '{(114+0.625)*tbit_s}' 0
+ '{(114+0.625)*tbit_s+2e-11}' 1
+ '{(114+0.75)*tbit_s-2e-11}' 1
+ '{(114+0.75)*tbit_s}' 0
+ '{(115+0.625)*tbit_s}' 0
+ '{(115+0.625)*tbit_s+2e-11}' 1
+ '{(115+0.75)*tbit_s-2e-11}' 1
+ '{(115+0.75)*tbit_s}' 0
+ '{(116+0.625)*tbit_s}' 0
+ '{(116+0.625)*tbit_s+2e-11}' 1
+ '{(116+0.75)*tbit_s-2e-11}' 1
+ '{(116+0.75)*tbit_s}' 0
+ '{(118+0.625)*tbit_s}' 0
+ '{(118+0.625)*tbit_s+2e-11}' 1
+ '{(118+0.75)*tbit_s-2e-11}' 1
+ '{(118+0.75)*tbit_s}' 0
+ '{(119+0.625)*tbit_s}' 0
+ '{(119+0.625)*tbit_s+2e-11}' 1
+ '{(119+0.75)*tbit_s-2e-11}' 1
+ '{(119+0.75)*tbit_s}' 0
+ '{(123+0.625)*tbit_s}' 0
+ '{(123+0.625)*tbit_s+2e-11}' 1
+ '{(123+0.75)*tbit_s-2e-11}' 1
+ '{(123+0.75)*tbit_s}' 0
+ '{(124+0.625)*tbit_s}' 0
+ '{(124+0.625)*tbit_s+2e-11}' 1
+ '{(124+0.75)*tbit_s-2e-11}' 1
+ '{(124+0.75)*tbit_s}' 0
+ '{(126+0.625)*tbit_s}' 0
+ '{(126+0.625)*tbit_s+2e-11}' 1
+ '{(126+0.75)*tbit_s-2e-11}' 1
+ '{(126+0.75)*tbit_s}' 0
+ '{(129+0.625)*tbit_s}' 0
+ '{(129+0.625)*tbit_s+2e-11}' 1
+ '{(129+0.75)*tbit_s-2e-11}' 1
+ '{(129+0.75)*tbit_s}' 0
+ '{(131+0.625)*tbit_s}' 0
+ '{(131+0.625)*tbit_s+2e-11}' 1
+ '{(131+0.75)*tbit_s-2e-11}' 1
+ '{(131+0.75)*tbit_s}' 0
+ '{(132+0.625)*tbit_s}' 0
+ '{(132+0.625)*tbit_s+2e-11}' 1
+ '{(132+0.75)*tbit_s-2e-11}' 1
+ '{(132+0.75)*tbit_s}' 0
+ '{(133+0.625)*tbit_s}' 0
+ '{(133+0.625)*tbit_s+2e-11}' 1
+ '{(133+0.75)*tbit_s-2e-11}' 1
+ '{(133+0.75)*tbit_s}' 0
+ '{(135+0.625)*tbit_s}' 0
+ '{(135+0.625)*tbit_s+2e-11}' 1
+ '{(135+0.75)*tbit_s-2e-11}' 1
+ '{(135+0.75)*tbit_s}' 0
+ '{(136+0.625)*tbit_s}' 0
+ '{(136+0.625)*tbit_s+2e-11}' 1
+ '{(136+0.75)*tbit_s-2e-11}' 1
+ '{(136+0.75)*tbit_s}' 0
+ '{(137+0.625)*tbit_s}' 0
+ '{(137+0.625)*tbit_s+2e-11}' 1
+ '{(137+0.75)*tbit_s-2e-11}' 1
+ '{(137+0.75)*tbit_s}' 0
+ '{(140+0.625)*tbit_s}' 0
+ '{(140+0.625)*tbit_s+2e-11}' 1
+ '{(140+0.75)*tbit_s-2e-11}' 1
+ '{(140+0.75)*tbit_s}' 0
+ '{(141+0.625)*tbit_s}' 0
+ '{(141+0.625)*tbit_s+2e-11}' 1
+ '{(141+0.75)*tbit_s-2e-11}' 1
+ '{(141+0.75)*tbit_s}' 0
+ '{(144+0.625)*tbit_s}' 0
+ '{(144+0.625)*tbit_s+2e-11}' 1
+ '{(144+0.75)*tbit_s-2e-11}' 1
+ '{(144+0.75)*tbit_s}' 0
+ '{(146+0.625)*tbit_s}' 0
+ '{(146+0.625)*tbit_s+2e-11}' 1
+ '{(146+0.75)*tbit_s-2e-11}' 1
+ '{(146+0.75)*tbit_s}' 0
+ '{(148+0.625)*tbit_s}' 0
+ '{(148+0.625)*tbit_s+2e-11}' 1
+ '{(148+0.75)*tbit_s-2e-11}' 1
+ '{(148+0.75)*tbit_s}' 0
+ )
vcomb0_5 comb0_5 0 PWL(0 0
+ '{(30+0.625)*tbit_s}' 0
+ '{(30+0.625)*tbit_s+2e-11}' 1
+ '{(30+0.75)*tbit_s-2e-11}' 1
+ '{(30+0.75)*tbit_s}' 0
+ '{(31+0.625)*tbit_s}' 0
+ '{(31+0.625)*tbit_s+2e-11}' 1
+ '{(31+0.75)*tbit_s-2e-11}' 1
+ '{(31+0.75)*tbit_s}' 0
+ '{(32+0.625)*tbit_s}' 0
+ '{(32+0.625)*tbit_s+2e-11}' 1
+ '{(32+0.75)*tbit_s-2e-11}' 1
+ '{(32+0.75)*tbit_s}' 0
+ '{(33+0.625)*tbit_s}' 0
+ '{(33+0.625)*tbit_s+2e-11}' 1
+ '{(33+0.75)*tbit_s-2e-11}' 1
+ '{(33+0.75)*tbit_s}' 0
+ '{(34+0.625)*tbit_s}' 0
+ '{(34+0.625)*tbit_s+2e-11}' 1
+ '{(34+0.75)*tbit_s-2e-11}' 1
+ '{(34+0.75)*tbit_s}' 0
+ '{(35+0.625)*tbit_s}' 0
+ '{(35+0.625)*tbit_s+2e-11}' 1
+ '{(35+0.75)*tbit_s-2e-11}' 1
+ '{(35+0.75)*tbit_s}' 0
+ '{(37+0.625)*tbit_s}' 0
+ '{(37+0.625)*tbit_s+2e-11}' 1
+ '{(37+0.75)*tbit_s-2e-11}' 1
+ '{(37+0.75)*tbit_s}' 0
+ '{(38+0.625)*tbit_s}' 0
+ '{(38+0.625)*tbit_s+2e-11}' 1
+ '{(38+0.75)*tbit_s-2e-11}' 1
+ '{(38+0.75)*tbit_s}' 0
+ '{(39+0.625)*tbit_s}' 0
+ '{(39+0.625)*tbit_s+2e-11}' 1
+ '{(39+0.75)*tbit_s-2e-11}' 1
+ '{(39+0.75)*tbit_s}' 0
+ '{(40+0.625)*tbit_s}' 0
+ '{(40+0.625)*tbit_s+2e-11}' 1
+ '{(40+0.75)*tbit_s-2e-11}' 1
+ '{(40+0.75)*tbit_s}' 0
+ '{(41+0.625)*tbit_s}' 0
+ '{(41+0.625)*tbit_s+2e-11}' 1
+ '{(41+0.75)*tbit_s-2e-11}' 1
+ '{(41+0.75)*tbit_s}' 0
+ '{(44+0.625)*tbit_s}' 0
+ '{(44+0.625)*tbit_s+2e-11}' 1
+ '{(44+0.75)*tbit_s-2e-11}' 1
+ '{(44+0.75)*tbit_s}' 0
+ '{(45+0.625)*tbit_s}' 0
+ '{(45+0.625)*tbit_s+2e-11}' 1
+ '{(45+0.75)*tbit_s-2e-11}' 1
+ '{(45+0.75)*tbit_s}' 0
+ '{(46+0.625)*tbit_s}' 0
+ '{(46+0.625)*tbit_s+2e-11}' 1
+ '{(46+0.75)*tbit_s-2e-11}' 1
+ '{(46+0.75)*tbit_s}' 0
+ '{(47+0.625)*tbit_s}' 0
+ '{(47+0.625)*tbit_s+2e-11}' 1
+ '{(47+0.75)*tbit_s-2e-11}' 1
+ '{(47+0.75)*tbit_s}' 0
+ '{(49+0.625)*tbit_s}' 0
+ '{(49+0.625)*tbit_s+2e-11}' 1
+ '{(49+0.75)*tbit_s-2e-11}' 1
+ '{(49+0.75)*tbit_s}' 0
+ '{(51+0.625)*tbit_s}' 0
+ '{(51+0.625)*tbit_s+2e-11}' 1
+ '{(51+0.75)*tbit_s-2e-11}' 1
+ '{(51+0.75)*tbit_s}' 0
+ '{(52+0.625)*tbit_s}' 0
+ '{(52+0.625)*tbit_s+2e-11}' 1
+ '{(52+0.75)*tbit_s-2e-11}' 1
+ '{(52+0.75)*tbit_s}' 0
+ '{(53+0.625)*tbit_s}' 0
+ '{(53+0.625)*tbit_s+2e-11}' 1
+ '{(53+0.75)*tbit_s-2e-11}' 1
+ '{(53+0.75)*tbit_s}' 0
+ '{(58+0.625)*tbit_s}' 0
+ '{(58+0.625)*tbit_s+2e-11}' 1
+ '{(58+0.75)*tbit_s-2e-11}' 1
+ '{(58+0.75)*tbit_s}' 0
+ '{(59+0.625)*tbit_s}' 0
+ '{(59+0.625)*tbit_s+2e-11}' 1
+ '{(59+0.75)*tbit_s-2e-11}' 1
+ '{(59+0.75)*tbit_s}' 0
+ '{(61+0.625)*tbit_s}' 0
+ '{(61+0.625)*tbit_s+2e-11}' 1
+ '{(61+0.75)*tbit_s-2e-11}' 1
+ '{(61+0.75)*tbit_s}' 0
+ '{(62+0.625)*tbit_s}' 0
+ '{(62+0.625)*tbit_s+2e-11}' 1
+ '{(62+0.75)*tbit_s-2e-11}' 1
+ '{(62+0.75)*tbit_s}' 0
+ '{(63+0.625)*tbit_s}' 0
+ '{(63+0.625)*tbit_s+2e-11}' 1
+ '{(63+0.75)*tbit_s-2e-11}' 1
+ '{(63+0.75)*tbit_s}' 0
+ '{(65+0.625)*tbit_s}' 0
+ '{(65+0.625)*tbit_s+2e-11}' 1
+ '{(65+0.75)*tbit_s-2e-11}' 1
+ '{(65+0.75)*tbit_s}' 0
+ '{(68+0.625)*tbit_s}' 0
+ '{(68+0.625)*tbit_s+2e-11}' 1
+ '{(68+0.75)*tbit_s-2e-11}' 1
+ '{(68+0.75)*tbit_s}' 0
+ '{(69+0.625)*tbit_s}' 0
+ '{(69+0.625)*tbit_s+2e-11}' 1
+ '{(69+0.75)*tbit_s-2e-11}' 1
+ '{(69+0.75)*tbit_s}' 0
+ '{(73+0.625)*tbit_s}' 0
+ '{(73+0.625)*tbit_s+2e-11}' 1
+ '{(73+0.75)*tbit_s-2e-11}' 1
+ '{(73+0.75)*tbit_s}' 0
+ '{(75+0.625)*tbit_s}' 0
+ '{(75+0.625)*tbit_s+2e-11}' 1
+ '{(75+0.75)*tbit_s-2e-11}' 1
+ '{(75+0.75)*tbit_s}' 0
+ '{(77+0.625)*tbit_s}' 0
+ '{(77+0.625)*tbit_s+2e-11}' 1
+ '{(77+0.75)*tbit_s-2e-11}' 1
+ '{(77+0.75)*tbit_s}' 0
+ '{(78+0.625)*tbit_s}' 0
+ '{(78+0.625)*tbit_s+2e-11}' 1
+ '{(78+0.75)*tbit_s-2e-11}' 1
+ '{(78+0.75)*tbit_s}' 0
+ '{(84+0.625)*tbit_s}' 0
+ '{(84+0.625)*tbit_s+2e-11}' 1
+ '{(84+0.75)*tbit_s-2e-11}' 1
+ '{(84+0.75)*tbit_s}' 0
+ '{(86+0.625)*tbit_s}' 0
+ '{(86+0.625)*tbit_s+2e-11}' 1
+ '{(86+0.75)*tbit_s-2e-11}' 1
+ '{(86+0.75)*tbit_s}' 0
+ '{(87+0.625)*tbit_s}' 0
+ '{(87+0.625)*tbit_s+2e-11}' 1
+ '{(87+0.75)*tbit_s-2e-11}' 1
+ '{(87+0.75)*tbit_s}' 0
+ '{(88+0.625)*tbit_s}' 0
+ '{(88+0.625)*tbit_s+2e-11}' 1
+ '{(88+0.75)*tbit_s-2e-11}' 1
+ '{(88+0.75)*tbit_s}' 0
+ '{(89+0.625)*tbit_s}' 0
+ '{(89+0.625)*tbit_s+2e-11}' 1
+ '{(89+0.75)*tbit_s-2e-11}' 1
+ '{(89+0.75)*tbit_s}' 0
+ '{(93+0.625)*tbit_s}' 0
+ '{(93+0.625)*tbit_s+2e-11}' 1
+ '{(93+0.75)*tbit_s-2e-11}' 1
+ '{(93+0.75)*tbit_s}' 0
+ '{(94+0.625)*tbit_s}' 0
+ '{(94+0.625)*tbit_s+2e-11}' 1
+ '{(94+0.75)*tbit_s-2e-11}' 1
+ '{(94+0.75)*tbit_s}' 0
+ '{(95+0.625)*tbit_s}' 0
+ '{(95+0.625)*tbit_s+2e-11}' 1
+ '{(95+0.75)*tbit_s-2e-11}' 1
+ '{(95+0.75)*tbit_s}' 0
+ '{(97+0.625)*tbit_s}' 0
+ '{(97+0.625)*tbit_s+2e-11}' 1
+ '{(97+0.75)*tbit_s-2e-11}' 1
+ '{(97+0.75)*tbit_s}' 0
+ '{(98+0.625)*tbit_s}' 0
+ '{(98+0.625)*tbit_s+2e-11}' 1
+ '{(98+0.75)*tbit_s-2e-11}' 1
+ '{(98+0.75)*tbit_s}' 0
+ '{(100+0.625)*tbit_s}' 0
+ '{(100+0.625)*tbit_s+2e-11}' 1
+ '{(100+0.75)*tbit_s-2e-11}' 1
+ '{(100+0.75)*tbit_s}' 0
+ '{(101+0.625)*tbit_s}' 0
+ '{(101+0.625)*tbit_s+2e-11}' 1
+ '{(101+0.75)*tbit_s-2e-11}' 1
+ '{(101+0.75)*tbit_s}' 0
+ '{(104+0.625)*tbit_s}' 0
+ '{(104+0.625)*tbit_s+2e-11}' 1
+ '{(104+0.75)*tbit_s-2e-11}' 1
+ '{(104+0.75)*tbit_s}' 0
+ '{(107+0.625)*tbit_s}' 0
+ '{(107+0.625)*tbit_s+2e-11}' 1
+ '{(107+0.75)*tbit_s-2e-11}' 1
+ '{(107+0.75)*tbit_s}' 0
+ '{(109+0.625)*tbit_s}' 0
+ '{(109+0.625)*tbit_s+2e-11}' 1
+ '{(109+0.75)*tbit_s-2e-11}' 1
+ '{(109+0.75)*tbit_s}' 0
+ '{(112+0.625)*tbit_s}' 0
+ '{(112+0.625)*tbit_s+2e-11}' 1
+ '{(112+0.75)*tbit_s-2e-11}' 1
+ '{(112+0.75)*tbit_s}' 0
+ '{(117+0.625)*tbit_s}' 0
+ '{(117+0.625)*tbit_s+2e-11}' 1
+ '{(117+0.75)*tbit_s-2e-11}' 1
+ '{(117+0.75)*tbit_s}' 0
+ '{(120+0.625)*tbit_s}' 0
+ '{(120+0.625)*tbit_s+2e-11}' 1
+ '{(120+0.75)*tbit_s-2e-11}' 1
+ '{(120+0.75)*tbit_s}' 0
+ '{(121+0.625)*tbit_s}' 0
+ '{(121+0.625)*tbit_s+2e-11}' 1
+ '{(121+0.75)*tbit_s-2e-11}' 1
+ '{(121+0.75)*tbit_s}' 0
+ '{(122+0.625)*tbit_s}' 0
+ '{(122+0.625)*tbit_s+2e-11}' 1
+ '{(122+0.75)*tbit_s-2e-11}' 1
+ '{(122+0.75)*tbit_s}' 0
+ '{(125+0.625)*tbit_s}' 0
+ '{(125+0.625)*tbit_s+2e-11}' 1
+ '{(125+0.75)*tbit_s-2e-11}' 1
+ '{(125+0.75)*tbit_s}' 0
+ '{(127+0.625)*tbit_s}' 0
+ '{(127+0.625)*tbit_s+2e-11}' 1
+ '{(127+0.75)*tbit_s-2e-11}' 1
+ '{(127+0.75)*tbit_s}' 0
+ '{(128+0.625)*tbit_s}' 0
+ '{(128+0.625)*tbit_s+2e-11}' 1
+ '{(128+0.75)*tbit_s-2e-11}' 1
+ '{(128+0.75)*tbit_s}' 0
+ '{(130+0.625)*tbit_s}' 0
+ '{(130+0.625)*tbit_s+2e-11}' 1
+ '{(130+0.75)*tbit_s-2e-11}' 1
+ '{(130+0.75)*tbit_s}' 0
+ '{(134+0.625)*tbit_s}' 0
+ '{(134+0.625)*tbit_s+2e-11}' 1
+ '{(134+0.75)*tbit_s-2e-11}' 1
+ '{(134+0.75)*tbit_s}' 0
+ '{(138+0.625)*tbit_s}' 0
+ '{(138+0.625)*tbit_s+2e-11}' 1
+ '{(138+0.75)*tbit_s-2e-11}' 1
+ '{(138+0.75)*tbit_s}' 0
+ '{(139+0.625)*tbit_s}' 0
+ '{(139+0.625)*tbit_s+2e-11}' 1
+ '{(139+0.75)*tbit_s-2e-11}' 1
+ '{(139+0.75)*tbit_s}' 0
+ '{(142+0.625)*tbit_s}' 0
+ '{(142+0.625)*tbit_s+2e-11}' 1
+ '{(142+0.75)*tbit_s-2e-11}' 1
+ '{(142+0.75)*tbit_s}' 0
+ '{(143+0.625)*tbit_s}' 0
+ '{(143+0.625)*tbit_s+2e-11}' 1
+ '{(143+0.75)*tbit_s-2e-11}' 1
+ '{(143+0.75)*tbit_s}' 0
+ '{(145+0.625)*tbit_s}' 0
+ '{(145+0.625)*tbit_s+2e-11}' 1
+ '{(145+0.75)*tbit_s-2e-11}' 1
+ '{(145+0.75)*tbit_s}' 0
+ '{(147+0.625)*tbit_s}' 0
+ '{(147+0.625)*tbit_s+2e-11}' 1
+ '{(147+0.75)*tbit_s-2e-11}' 1
+ '{(147+0.75)*tbit_s}' 0
+ '{(149+0.625)*tbit_s}' 0
+ '{(149+0.625)*tbit_s+2e-11}' 1
+ '{(149+0.75)*tbit_s-2e-11}' 1
+ '{(149+0.75)*tbit_s}' 0
+ )
vcomb1_6 comb1_6 0 PWL(0 0
+ '{(23+0.75)*tbit_s}' 0
+ '{(23+0.75)*tbit_s+2e-11}' 1
+ '{(23+0.875)*tbit_s-2e-11}' 1
+ '{(23+0.875)*tbit_s}' 0
+ '{(24+0.75)*tbit_s}' 0
+ '{(24+0.75)*tbit_s+2e-11}' 1
+ '{(24+0.875)*tbit_s-2e-11}' 1
+ '{(24+0.875)*tbit_s}' 0
+ '{(25+0.75)*tbit_s}' 0
+ '{(25+0.75)*tbit_s+2e-11}' 1
+ '{(25+0.875)*tbit_s-2e-11}' 1
+ '{(25+0.875)*tbit_s}' 0
+ '{(26+0.75)*tbit_s}' 0
+ '{(26+0.75)*tbit_s+2e-11}' 1
+ '{(26+0.875)*tbit_s-2e-11}' 1
+ '{(26+0.875)*tbit_s}' 0
+ '{(27+0.75)*tbit_s}' 0
+ '{(27+0.75)*tbit_s+2e-11}' 1
+ '{(27+0.875)*tbit_s-2e-11}' 1
+ '{(27+0.875)*tbit_s}' 0
+ '{(28+0.75)*tbit_s}' 0
+ '{(28+0.75)*tbit_s+2e-11}' 1
+ '{(28+0.875)*tbit_s-2e-11}' 1
+ '{(28+0.875)*tbit_s}' 0
+ '{(29+0.75)*tbit_s}' 0
+ '{(29+0.75)*tbit_s+2e-11}' 1
+ '{(29+0.875)*tbit_s-2e-11}' 1
+ '{(29+0.875)*tbit_s}' 0
+ '{(36+0.75)*tbit_s}' 0
+ '{(36+0.75)*tbit_s+2e-11}' 1
+ '{(36+0.875)*tbit_s-2e-11}' 1
+ '{(36+0.875)*tbit_s}' 0
+ '{(42+0.75)*tbit_s}' 0
+ '{(42+0.75)*tbit_s+2e-11}' 1
+ '{(42+0.875)*tbit_s-2e-11}' 1
+ '{(42+0.875)*tbit_s}' 0
+ '{(43+0.75)*tbit_s}' 0
+ '{(43+0.75)*tbit_s+2e-11}' 1
+ '{(43+0.875)*tbit_s-2e-11}' 1
+ '{(43+0.875)*tbit_s}' 0
+ '{(48+0.75)*tbit_s}' 0
+ '{(48+0.75)*tbit_s+2e-11}' 1
+ '{(48+0.875)*tbit_s-2e-11}' 1
+ '{(48+0.875)*tbit_s}' 0
+ '{(50+0.75)*tbit_s}' 0
+ '{(50+0.75)*tbit_s+2e-11}' 1
+ '{(50+0.875)*tbit_s-2e-11}' 1
+ '{(50+0.875)*tbit_s}' 0
+ '{(54+0.75)*tbit_s}' 0
+ '{(54+0.75)*tbit_s+2e-11}' 1
+ '{(54+0.875)*tbit_s-2e-11}' 1
+ '{(54+0.875)*tbit_s}' 0
+ '{(55+0.75)*tbit_s}' 0
+ '{(55+0.75)*tbit_s+2e-11}' 1
+ '{(55+0.875)*tbit_s-2e-11}' 1
+ '{(55+0.875)*tbit_s}' 0
+ '{(56+0.75)*tbit_s}' 0
+ '{(56+0.75)*tbit_s+2e-11}' 1
+ '{(56+0.875)*tbit_s-2e-11}' 1
+ '{(56+0.875)*tbit_s}' 0
+ '{(57+0.75)*tbit_s}' 0
+ '{(57+0.75)*tbit_s+2e-11}' 1
+ '{(57+0.875)*tbit_s-2e-11}' 1
+ '{(57+0.875)*tbit_s}' 0
+ '{(60+0.75)*tbit_s}' 0
+ '{(60+0.75)*tbit_s+2e-11}' 1
+ '{(60+0.875)*tbit_s-2e-11}' 1
+ '{(60+0.875)*tbit_s}' 0
+ '{(64+0.75)*tbit_s}' 0
+ '{(64+0.75)*tbit_s+2e-11}' 1
+ '{(64+0.875)*tbit_s-2e-11}' 1
+ '{(64+0.875)*tbit_s}' 0
+ '{(66+0.75)*tbit_s}' 0
+ '{(66+0.75)*tbit_s+2e-11}' 1
+ '{(66+0.875)*tbit_s-2e-11}' 1
+ '{(66+0.875)*tbit_s}' 0
+ '{(67+0.75)*tbit_s}' 0
+ '{(67+0.75)*tbit_s+2e-11}' 1
+ '{(67+0.875)*tbit_s-2e-11}' 1
+ '{(67+0.875)*tbit_s}' 0
+ '{(70+0.75)*tbit_s}' 0
+ '{(70+0.75)*tbit_s+2e-11}' 1
+ '{(70+0.875)*tbit_s-2e-11}' 1
+ '{(70+0.875)*tbit_s}' 0
+ '{(71+0.75)*tbit_s}' 0
+ '{(71+0.75)*tbit_s+2e-11}' 1
+ '{(71+0.875)*tbit_s-2e-11}' 1
+ '{(71+0.875)*tbit_s}' 0
+ '{(72+0.75)*tbit_s}' 0
+ '{(72+0.75)*tbit_s+2e-11}' 1
+ '{(72+0.875)*tbit_s-2e-11}' 1
+ '{(72+0.875)*tbit_s}' 0
+ '{(74+0.75)*tbit_s}' 0
+ '{(74+0.75)*tbit_s+2e-11}' 1
+ '{(74+0.875)*tbit_s-2e-11}' 1
+ '{(74+0.875)*tbit_s}' 0
+ '{(76+0.75)*tbit_s}' 0
+ '{(76+0.75)*tbit_s+2e-11}' 1
+ '{(76+0.875)*tbit_s-2e-11}' 1
+ '{(76+0.875)*tbit_s}' 0
+ '{(79+0.75)*tbit_s}' 0
+ '{(79+0.75)*tbit_s+2e-11}' 1
+ '{(79+0.875)*tbit_s-2e-11}' 1
+ '{(79+0.875)*tbit_s}' 0
+ '{(80+0.75)*tbit_s}' 0
+ '{(80+0.75)*tbit_s+2e-11}' 1
+ '{(80+0.875)*tbit_s-2e-11}' 1
+ '{(80+0.875)*tbit_s}' 0
+ '{(81+0.75)*tbit_s}' 0
+ '{(81+0.75)*tbit_s+2e-11}' 1
+ '{(81+0.875)*tbit_s-2e-11}' 1
+ '{(81+0.875)*tbit_s}' 0
+ '{(82+0.75)*tbit_s}' 0
+ '{(82+0.75)*tbit_s+2e-11}' 1
+ '{(82+0.875)*tbit_s-2e-11}' 1
+ '{(82+0.875)*tbit_s}' 0
+ '{(83+0.75)*tbit_s}' 0
+ '{(83+0.75)*tbit_s+2e-11}' 1
+ '{(83+0.875)*tbit_s-2e-11}' 1
+ '{(83+0.875)*tbit_s}' 0
+ '{(85+0.75)*tbit_s}' 0
+ '{(85+0.75)*tbit_s+2e-11}' 1
+ '{(85+0.875)*tbit_s-2e-11}' 1
+ '{(85+0.875)*tbit_s}' 0
+ '{(90+0.75)*tbit_s}' 0
+ '{(90+0.75)*tbit_s+2e-11}' 1
+ '{(90+0.875)*tbit_s-2e-11}' 1
+ '{(90+0.875)*tbit_s}' 0
+ '{(91+0.75)*tbit_s}' 0
+ '{(91+0.75)*tbit_s+2e-11}' 1
+ '{(91+0.875)*tbit_s-2e-11}' 1
+ '{(91+0.875)*tbit_s}' 0
+ '{(92+0.75)*tbit_s}' 0
+ '{(92+0.75)*tbit_s+2e-11}' 1
+ '{(92+0.875)*tbit_s-2e-11}' 1
+ '{(92+0.875)*tbit_s}' 0
+ '{(96+0.75)*tbit_s}' 0
+ '{(96+0.75)*tbit_s+2e-11}' 1
+ '{(96+0.875)*tbit_s-2e-11}' 1
+ '{(96+0.875)*tbit_s}' 0
+ '{(99+0.75)*tbit_s}' 0
+ '{(99+0.75)*tbit_s+2e-11}' 1
+ '{(99+0.875)*tbit_s-2e-11}' 1
+ '{(99+0.875)*tbit_s}' 0
+ '{(102+0.75)*tbit_s}' 0
+ '{(102+0.75)*tbit_s+2e-11}' 1
+ '{(102+0.875)*tbit_s-2e-11}' 1
+ '{(102+0.875)*tbit_s}' 0
+ '{(103+0.75)*tbit_s}' 0
+ '{(103+0.75)*tbit_s+2e-11}' 1
+ '{(103+0.875)*tbit_s-2e-11}' 1
+ '{(103+0.875)*tbit_s}' 0
+ '{(105+0.75)*tbit_s}' 0
+ '{(105+0.75)*tbit_s+2e-11}' 1
+ '{(105+0.875)*tbit_s-2e-11}' 1
+ '{(105+0.875)*tbit_s}' 0
+ '{(106+0.75)*tbit_s}' 0
+ '{(106+0.75)*tbit_s+2e-11}' 1
+ '{(106+0.875)*tbit_s-2e-11}' 1
+ '{(106+0.875)*tbit_s}' 0
+ '{(108+0.75)*tbit_s}' 0
+ '{(108+0.75)*tbit_s+2e-11}' 1
+ '{(108+0.875)*tbit_s-2e-11}' 1
+ '{(108+0.875)*tbit_s}' 0
+ '{(110+0.75)*tbit_s}' 0
+ '{(110+0.75)*tbit_s+2e-11}' 1
+ '{(110+0.875)*tbit_s-2e-11}' 1
+ '{(110+0.875)*tbit_s}' 0
+ '{(111+0.75)*tbit_s}' 0
+ '{(111+0.75)*tbit_s+2e-11}' 1
+ '{(111+0.875)*tbit_s-2e-11}' 1
+ '{(111+0.875)*tbit_s}' 0
+ '{(113+0.75)*tbit_s}' 0
+ '{(113+0.75)*tbit_s+2e-11}' 1
+ '{(113+0.875)*tbit_s-2e-11}' 1
+ '{(113+0.875)*tbit_s}' 0
+ '{(114+0.75)*tbit_s}' 0
+ '{(114+0.75)*tbit_s+2e-11}' 1
+ '{(114+0.875)*tbit_s-2e-11}' 1
+ '{(114+0.875)*tbit_s}' 0
+ '{(115+0.75)*tbit_s}' 0
+ '{(115+0.75)*tbit_s+2e-11}' 1
+ '{(115+0.875)*tbit_s-2e-11}' 1
+ '{(115+0.875)*tbit_s}' 0
+ '{(116+0.75)*tbit_s}' 0
+ '{(116+0.75)*tbit_s+2e-11}' 1
+ '{(116+0.875)*tbit_s-2e-11}' 1
+ '{(116+0.875)*tbit_s}' 0
+ '{(118+0.75)*tbit_s}' 0
+ '{(118+0.75)*tbit_s+2e-11}' 1
+ '{(118+0.875)*tbit_s-2e-11}' 1
+ '{(118+0.875)*tbit_s}' 0
+ '{(119+0.75)*tbit_s}' 0
+ '{(119+0.75)*tbit_s+2e-11}' 1
+ '{(119+0.875)*tbit_s-2e-11}' 1
+ '{(119+0.875)*tbit_s}' 0
+ '{(123+0.75)*tbit_s}' 0
+ '{(123+0.75)*tbit_s+2e-11}' 1
+ '{(123+0.875)*tbit_s-2e-11}' 1
+ '{(123+0.875)*tbit_s}' 0
+ '{(124+0.75)*tbit_s}' 0
+ '{(124+0.75)*tbit_s+2e-11}' 1
+ '{(124+0.875)*tbit_s-2e-11}' 1
+ '{(124+0.875)*tbit_s}' 0
+ '{(126+0.75)*tbit_s}' 0
+ '{(126+0.75)*tbit_s+2e-11}' 1
+ '{(126+0.875)*tbit_s-2e-11}' 1
+ '{(126+0.875)*tbit_s}' 0
+ '{(129+0.75)*tbit_s}' 0
+ '{(129+0.75)*tbit_s+2e-11}' 1
+ '{(129+0.875)*tbit_s-2e-11}' 1
+ '{(129+0.875)*tbit_s}' 0
+ '{(131+0.75)*tbit_s}' 0
+ '{(131+0.75)*tbit_s+2e-11}' 1
+ '{(131+0.875)*tbit_s-2e-11}' 1
+ '{(131+0.875)*tbit_s}' 0
+ '{(132+0.75)*tbit_s}' 0
+ '{(132+0.75)*tbit_s+2e-11}' 1
+ '{(132+0.875)*tbit_s-2e-11}' 1
+ '{(132+0.875)*tbit_s}' 0
+ '{(133+0.75)*tbit_s}' 0
+ '{(133+0.75)*tbit_s+2e-11}' 1
+ '{(133+0.875)*tbit_s-2e-11}' 1
+ '{(133+0.875)*tbit_s}' 0
+ '{(135+0.75)*tbit_s}' 0
+ '{(135+0.75)*tbit_s+2e-11}' 1
+ '{(135+0.875)*tbit_s-2e-11}' 1
+ '{(135+0.875)*tbit_s}' 0
+ '{(136+0.75)*tbit_s}' 0
+ '{(136+0.75)*tbit_s+2e-11}' 1
+ '{(136+0.875)*tbit_s-2e-11}' 1
+ '{(136+0.875)*tbit_s}' 0
+ '{(137+0.75)*tbit_s}' 0
+ '{(137+0.75)*tbit_s+2e-11}' 1
+ '{(137+0.875)*tbit_s-2e-11}' 1
+ '{(137+0.875)*tbit_s}' 0
+ '{(140+0.75)*tbit_s}' 0
+ '{(140+0.75)*tbit_s+2e-11}' 1
+ '{(140+0.875)*tbit_s-2e-11}' 1
+ '{(140+0.875)*tbit_s}' 0
+ '{(141+0.75)*tbit_s}' 0
+ '{(141+0.75)*tbit_s+2e-11}' 1
+ '{(141+0.875)*tbit_s-2e-11}' 1
+ '{(141+0.875)*tbit_s}' 0
+ '{(144+0.75)*tbit_s}' 0
+ '{(144+0.75)*tbit_s+2e-11}' 1
+ '{(144+0.875)*tbit_s-2e-11}' 1
+ '{(144+0.875)*tbit_s}' 0
+ '{(146+0.75)*tbit_s}' 0
+ '{(146+0.75)*tbit_s+2e-11}' 1
+ '{(146+0.875)*tbit_s-2e-11}' 1
+ '{(146+0.875)*tbit_s}' 0
+ '{(148+0.75)*tbit_s}' 0
+ '{(148+0.75)*tbit_s+2e-11}' 1
+ '{(148+0.875)*tbit_s-2e-11}' 1
+ '{(148+0.875)*tbit_s}' 0
+ )
vcomb0_6 comb0_6 0 PWL(0 0
+ '{(30+0.75)*tbit_s}' 0
+ '{(30+0.75)*tbit_s+2e-11}' 1
+ '{(30+0.875)*tbit_s-2e-11}' 1
+ '{(30+0.875)*tbit_s}' 0
+ '{(31+0.75)*tbit_s}' 0
+ '{(31+0.75)*tbit_s+2e-11}' 1
+ '{(31+0.875)*tbit_s-2e-11}' 1
+ '{(31+0.875)*tbit_s}' 0
+ '{(32+0.75)*tbit_s}' 0
+ '{(32+0.75)*tbit_s+2e-11}' 1
+ '{(32+0.875)*tbit_s-2e-11}' 1
+ '{(32+0.875)*tbit_s}' 0
+ '{(33+0.75)*tbit_s}' 0
+ '{(33+0.75)*tbit_s+2e-11}' 1
+ '{(33+0.875)*tbit_s-2e-11}' 1
+ '{(33+0.875)*tbit_s}' 0
+ '{(34+0.75)*tbit_s}' 0
+ '{(34+0.75)*tbit_s+2e-11}' 1
+ '{(34+0.875)*tbit_s-2e-11}' 1
+ '{(34+0.875)*tbit_s}' 0
+ '{(35+0.75)*tbit_s}' 0
+ '{(35+0.75)*tbit_s+2e-11}' 1
+ '{(35+0.875)*tbit_s-2e-11}' 1
+ '{(35+0.875)*tbit_s}' 0
+ '{(37+0.75)*tbit_s}' 0
+ '{(37+0.75)*tbit_s+2e-11}' 1
+ '{(37+0.875)*tbit_s-2e-11}' 1
+ '{(37+0.875)*tbit_s}' 0
+ '{(38+0.75)*tbit_s}' 0
+ '{(38+0.75)*tbit_s+2e-11}' 1
+ '{(38+0.875)*tbit_s-2e-11}' 1
+ '{(38+0.875)*tbit_s}' 0
+ '{(39+0.75)*tbit_s}' 0
+ '{(39+0.75)*tbit_s+2e-11}' 1
+ '{(39+0.875)*tbit_s-2e-11}' 1
+ '{(39+0.875)*tbit_s}' 0
+ '{(40+0.75)*tbit_s}' 0
+ '{(40+0.75)*tbit_s+2e-11}' 1
+ '{(40+0.875)*tbit_s-2e-11}' 1
+ '{(40+0.875)*tbit_s}' 0
+ '{(41+0.75)*tbit_s}' 0
+ '{(41+0.75)*tbit_s+2e-11}' 1
+ '{(41+0.875)*tbit_s-2e-11}' 1
+ '{(41+0.875)*tbit_s}' 0
+ '{(44+0.75)*tbit_s}' 0
+ '{(44+0.75)*tbit_s+2e-11}' 1
+ '{(44+0.875)*tbit_s-2e-11}' 1
+ '{(44+0.875)*tbit_s}' 0
+ '{(45+0.75)*tbit_s}' 0
+ '{(45+0.75)*tbit_s+2e-11}' 1
+ '{(45+0.875)*tbit_s-2e-11}' 1
+ '{(45+0.875)*tbit_s}' 0
+ '{(46+0.75)*tbit_s}' 0
+ '{(46+0.75)*tbit_s+2e-11}' 1
+ '{(46+0.875)*tbit_s-2e-11}' 1
+ '{(46+0.875)*tbit_s}' 0
+ '{(47+0.75)*tbit_s}' 0
+ '{(47+0.75)*tbit_s+2e-11}' 1
+ '{(47+0.875)*tbit_s-2e-11}' 1
+ '{(47+0.875)*tbit_s}' 0
+ '{(49+0.75)*tbit_s}' 0
+ '{(49+0.75)*tbit_s+2e-11}' 1
+ '{(49+0.875)*tbit_s-2e-11}' 1
+ '{(49+0.875)*tbit_s}' 0
+ '{(51+0.75)*tbit_s}' 0
+ '{(51+0.75)*tbit_s+2e-11}' 1
+ '{(51+0.875)*tbit_s-2e-11}' 1
+ '{(51+0.875)*tbit_s}' 0
+ '{(52+0.75)*tbit_s}' 0
+ '{(52+0.75)*tbit_s+2e-11}' 1
+ '{(52+0.875)*tbit_s-2e-11}' 1
+ '{(52+0.875)*tbit_s}' 0
+ '{(53+0.75)*tbit_s}' 0
+ '{(53+0.75)*tbit_s+2e-11}' 1
+ '{(53+0.875)*tbit_s-2e-11}' 1
+ '{(53+0.875)*tbit_s}' 0
+ '{(58+0.75)*tbit_s}' 0
+ '{(58+0.75)*tbit_s+2e-11}' 1
+ '{(58+0.875)*tbit_s-2e-11}' 1
+ '{(58+0.875)*tbit_s}' 0
+ '{(59+0.75)*tbit_s}' 0
+ '{(59+0.75)*tbit_s+2e-11}' 1
+ '{(59+0.875)*tbit_s-2e-11}' 1
+ '{(59+0.875)*tbit_s}' 0
+ '{(61+0.75)*tbit_s}' 0
+ '{(61+0.75)*tbit_s+2e-11}' 1
+ '{(61+0.875)*tbit_s-2e-11}' 1
+ '{(61+0.875)*tbit_s}' 0
+ '{(62+0.75)*tbit_s}' 0
+ '{(62+0.75)*tbit_s+2e-11}' 1
+ '{(62+0.875)*tbit_s-2e-11}' 1
+ '{(62+0.875)*tbit_s}' 0
+ '{(63+0.75)*tbit_s}' 0
+ '{(63+0.75)*tbit_s+2e-11}' 1
+ '{(63+0.875)*tbit_s-2e-11}' 1
+ '{(63+0.875)*tbit_s}' 0
+ '{(65+0.75)*tbit_s}' 0
+ '{(65+0.75)*tbit_s+2e-11}' 1
+ '{(65+0.875)*tbit_s-2e-11}' 1
+ '{(65+0.875)*tbit_s}' 0
+ '{(68+0.75)*tbit_s}' 0
+ '{(68+0.75)*tbit_s+2e-11}' 1
+ '{(68+0.875)*tbit_s-2e-11}' 1
+ '{(68+0.875)*tbit_s}' 0
+ '{(69+0.75)*tbit_s}' 0
+ '{(69+0.75)*tbit_s+2e-11}' 1
+ '{(69+0.875)*tbit_s-2e-11}' 1
+ '{(69+0.875)*tbit_s}' 0
+ '{(73+0.75)*tbit_s}' 0
+ '{(73+0.75)*tbit_s+2e-11}' 1
+ '{(73+0.875)*tbit_s-2e-11}' 1
+ '{(73+0.875)*tbit_s}' 0
+ '{(75+0.75)*tbit_s}' 0
+ '{(75+0.75)*tbit_s+2e-11}' 1
+ '{(75+0.875)*tbit_s-2e-11}' 1
+ '{(75+0.875)*tbit_s}' 0
+ '{(77+0.75)*tbit_s}' 0
+ '{(77+0.75)*tbit_s+2e-11}' 1
+ '{(77+0.875)*tbit_s-2e-11}' 1
+ '{(77+0.875)*tbit_s}' 0
+ '{(78+0.75)*tbit_s}' 0
+ '{(78+0.75)*tbit_s+2e-11}' 1
+ '{(78+0.875)*tbit_s-2e-11}' 1
+ '{(78+0.875)*tbit_s}' 0
+ '{(84+0.75)*tbit_s}' 0
+ '{(84+0.75)*tbit_s+2e-11}' 1
+ '{(84+0.875)*tbit_s-2e-11}' 1
+ '{(84+0.875)*tbit_s}' 0
+ '{(86+0.75)*tbit_s}' 0
+ '{(86+0.75)*tbit_s+2e-11}' 1
+ '{(86+0.875)*tbit_s-2e-11}' 1
+ '{(86+0.875)*tbit_s}' 0
+ '{(87+0.75)*tbit_s}' 0
+ '{(87+0.75)*tbit_s+2e-11}' 1
+ '{(87+0.875)*tbit_s-2e-11}' 1
+ '{(87+0.875)*tbit_s}' 0
+ '{(88+0.75)*tbit_s}' 0
+ '{(88+0.75)*tbit_s+2e-11}' 1
+ '{(88+0.875)*tbit_s-2e-11}' 1
+ '{(88+0.875)*tbit_s}' 0
+ '{(89+0.75)*tbit_s}' 0
+ '{(89+0.75)*tbit_s+2e-11}' 1
+ '{(89+0.875)*tbit_s-2e-11}' 1
+ '{(89+0.875)*tbit_s}' 0
+ '{(93+0.75)*tbit_s}' 0
+ '{(93+0.75)*tbit_s+2e-11}' 1
+ '{(93+0.875)*tbit_s-2e-11}' 1
+ '{(93+0.875)*tbit_s}' 0
+ '{(94+0.75)*tbit_s}' 0
+ '{(94+0.75)*tbit_s+2e-11}' 1
+ '{(94+0.875)*tbit_s-2e-11}' 1
+ '{(94+0.875)*tbit_s}' 0
+ '{(95+0.75)*tbit_s}' 0
+ '{(95+0.75)*tbit_s+2e-11}' 1
+ '{(95+0.875)*tbit_s-2e-11}' 1
+ '{(95+0.875)*tbit_s}' 0
+ '{(97+0.75)*tbit_s}' 0
+ '{(97+0.75)*tbit_s+2e-11}' 1
+ '{(97+0.875)*tbit_s-2e-11}' 1
+ '{(97+0.875)*tbit_s}' 0
+ '{(98+0.75)*tbit_s}' 0
+ '{(98+0.75)*tbit_s+2e-11}' 1
+ '{(98+0.875)*tbit_s-2e-11}' 1
+ '{(98+0.875)*tbit_s}' 0
+ '{(100+0.75)*tbit_s}' 0
+ '{(100+0.75)*tbit_s+2e-11}' 1
+ '{(100+0.875)*tbit_s-2e-11}' 1
+ '{(100+0.875)*tbit_s}' 0
+ '{(101+0.75)*tbit_s}' 0
+ '{(101+0.75)*tbit_s+2e-11}' 1
+ '{(101+0.875)*tbit_s-2e-11}' 1
+ '{(101+0.875)*tbit_s}' 0
+ '{(104+0.75)*tbit_s}' 0
+ '{(104+0.75)*tbit_s+2e-11}' 1
+ '{(104+0.875)*tbit_s-2e-11}' 1
+ '{(104+0.875)*tbit_s}' 0
+ '{(107+0.75)*tbit_s}' 0
+ '{(107+0.75)*tbit_s+2e-11}' 1
+ '{(107+0.875)*tbit_s-2e-11}' 1
+ '{(107+0.875)*tbit_s}' 0
+ '{(109+0.75)*tbit_s}' 0
+ '{(109+0.75)*tbit_s+2e-11}' 1
+ '{(109+0.875)*tbit_s-2e-11}' 1
+ '{(109+0.875)*tbit_s}' 0
+ '{(112+0.75)*tbit_s}' 0
+ '{(112+0.75)*tbit_s+2e-11}' 1
+ '{(112+0.875)*tbit_s-2e-11}' 1
+ '{(112+0.875)*tbit_s}' 0
+ '{(117+0.75)*tbit_s}' 0
+ '{(117+0.75)*tbit_s+2e-11}' 1
+ '{(117+0.875)*tbit_s-2e-11}' 1
+ '{(117+0.875)*tbit_s}' 0
+ '{(120+0.75)*tbit_s}' 0
+ '{(120+0.75)*tbit_s+2e-11}' 1
+ '{(120+0.875)*tbit_s-2e-11}' 1
+ '{(120+0.875)*tbit_s}' 0
+ '{(121+0.75)*tbit_s}' 0
+ '{(121+0.75)*tbit_s+2e-11}' 1
+ '{(121+0.875)*tbit_s-2e-11}' 1
+ '{(121+0.875)*tbit_s}' 0
+ '{(122+0.75)*tbit_s}' 0
+ '{(122+0.75)*tbit_s+2e-11}' 1
+ '{(122+0.875)*tbit_s-2e-11}' 1
+ '{(122+0.875)*tbit_s}' 0
+ '{(125+0.75)*tbit_s}' 0
+ '{(125+0.75)*tbit_s+2e-11}' 1
+ '{(125+0.875)*tbit_s-2e-11}' 1
+ '{(125+0.875)*tbit_s}' 0
+ '{(127+0.75)*tbit_s}' 0
+ '{(127+0.75)*tbit_s+2e-11}' 1
+ '{(127+0.875)*tbit_s-2e-11}' 1
+ '{(127+0.875)*tbit_s}' 0
+ '{(128+0.75)*tbit_s}' 0
+ '{(128+0.75)*tbit_s+2e-11}' 1
+ '{(128+0.875)*tbit_s-2e-11}' 1
+ '{(128+0.875)*tbit_s}' 0
+ '{(130+0.75)*tbit_s}' 0
+ '{(130+0.75)*tbit_s+2e-11}' 1
+ '{(130+0.875)*tbit_s-2e-11}' 1
+ '{(130+0.875)*tbit_s}' 0
+ '{(134+0.75)*tbit_s}' 0
+ '{(134+0.75)*tbit_s+2e-11}' 1
+ '{(134+0.875)*tbit_s-2e-11}' 1
+ '{(134+0.875)*tbit_s}' 0
+ '{(138+0.75)*tbit_s}' 0
+ '{(138+0.75)*tbit_s+2e-11}' 1
+ '{(138+0.875)*tbit_s-2e-11}' 1
+ '{(138+0.875)*tbit_s}' 0
+ '{(139+0.75)*tbit_s}' 0
+ '{(139+0.75)*tbit_s+2e-11}' 1
+ '{(139+0.875)*tbit_s-2e-11}' 1
+ '{(139+0.875)*tbit_s}' 0
+ '{(142+0.75)*tbit_s}' 0
+ '{(142+0.75)*tbit_s+2e-11}' 1
+ '{(142+0.875)*tbit_s-2e-11}' 1
+ '{(142+0.875)*tbit_s}' 0
+ '{(143+0.75)*tbit_s}' 0
+ '{(143+0.75)*tbit_s+2e-11}' 1
+ '{(143+0.875)*tbit_s-2e-11}' 1
+ '{(143+0.875)*tbit_s}' 0
+ '{(145+0.75)*tbit_s}' 0
+ '{(145+0.75)*tbit_s+2e-11}' 1
+ '{(145+0.875)*tbit_s-2e-11}' 1
+ '{(145+0.875)*tbit_s}' 0
+ '{(147+0.75)*tbit_s}' 0
+ '{(147+0.75)*tbit_s+2e-11}' 1
+ '{(147+0.875)*tbit_s-2e-11}' 1
+ '{(147+0.875)*tbit_s}' 0
+ '{(149+0.75)*tbit_s}' 0
+ '{(149+0.75)*tbit_s+2e-11}' 1
+ '{(149+0.875)*tbit_s-2e-11}' 1
+ '{(149+0.875)*tbit_s}' 0
+ )
vcomb1_7 comb1_7 0 PWL(0 0
+ '{(23+0.875)*tbit_s}' 0
+ '{(23+0.875)*tbit_s+2e-11}' 1
+ '{(23+1.0)*tbit_s-2e-11}' 1
+ '{(23+1.0)*tbit_s}' 0
+ '{(24+0.875)*tbit_s}' 0
+ '{(24+0.875)*tbit_s+2e-11}' 1
+ '{(24+1.0)*tbit_s-2e-11}' 1
+ '{(24+1.0)*tbit_s}' 0
+ '{(25+0.875)*tbit_s}' 0
+ '{(25+0.875)*tbit_s+2e-11}' 1
+ '{(25+1.0)*tbit_s-2e-11}' 1
+ '{(25+1.0)*tbit_s}' 0
+ '{(26+0.875)*tbit_s}' 0
+ '{(26+0.875)*tbit_s+2e-11}' 1
+ '{(26+1.0)*tbit_s-2e-11}' 1
+ '{(26+1.0)*tbit_s}' 0
+ '{(27+0.875)*tbit_s}' 0
+ '{(27+0.875)*tbit_s+2e-11}' 1
+ '{(27+1.0)*tbit_s-2e-11}' 1
+ '{(27+1.0)*tbit_s}' 0
+ '{(28+0.875)*tbit_s}' 0
+ '{(28+0.875)*tbit_s+2e-11}' 1
+ '{(28+1.0)*tbit_s-2e-11}' 1
+ '{(28+1.0)*tbit_s}' 0
+ '{(29+0.875)*tbit_s}' 0
+ '{(29+0.875)*tbit_s+2e-11}' 1
+ '{(29+1.0)*tbit_s-2e-11}' 1
+ '{(29+1.0)*tbit_s}' 0
+ '{(36+0.875)*tbit_s}' 0
+ '{(36+0.875)*tbit_s+2e-11}' 1
+ '{(36+1.0)*tbit_s-2e-11}' 1
+ '{(36+1.0)*tbit_s}' 0
+ '{(42+0.875)*tbit_s}' 0
+ '{(42+0.875)*tbit_s+2e-11}' 1
+ '{(42+1.0)*tbit_s-2e-11}' 1
+ '{(42+1.0)*tbit_s}' 0
+ '{(43+0.875)*tbit_s}' 0
+ '{(43+0.875)*tbit_s+2e-11}' 1
+ '{(43+1.0)*tbit_s-2e-11}' 1
+ '{(43+1.0)*tbit_s}' 0
+ '{(48+0.875)*tbit_s}' 0
+ '{(48+0.875)*tbit_s+2e-11}' 1
+ '{(48+1.0)*tbit_s-2e-11}' 1
+ '{(48+1.0)*tbit_s}' 0
+ '{(50+0.875)*tbit_s}' 0
+ '{(50+0.875)*tbit_s+2e-11}' 1
+ '{(50+1.0)*tbit_s-2e-11}' 1
+ '{(50+1.0)*tbit_s}' 0
+ '{(54+0.875)*tbit_s}' 0
+ '{(54+0.875)*tbit_s+2e-11}' 1
+ '{(54+1.0)*tbit_s-2e-11}' 1
+ '{(54+1.0)*tbit_s}' 0
+ '{(55+0.875)*tbit_s}' 0
+ '{(55+0.875)*tbit_s+2e-11}' 1
+ '{(55+1.0)*tbit_s-2e-11}' 1
+ '{(55+1.0)*tbit_s}' 0
+ '{(56+0.875)*tbit_s}' 0
+ '{(56+0.875)*tbit_s+2e-11}' 1
+ '{(56+1.0)*tbit_s-2e-11}' 1
+ '{(56+1.0)*tbit_s}' 0
+ '{(57+0.875)*tbit_s}' 0
+ '{(57+0.875)*tbit_s+2e-11}' 1
+ '{(57+1.0)*tbit_s-2e-11}' 1
+ '{(57+1.0)*tbit_s}' 0
+ '{(60+0.875)*tbit_s}' 0
+ '{(60+0.875)*tbit_s+2e-11}' 1
+ '{(60+1.0)*tbit_s-2e-11}' 1
+ '{(60+1.0)*tbit_s}' 0
+ '{(64+0.875)*tbit_s}' 0
+ '{(64+0.875)*tbit_s+2e-11}' 1
+ '{(64+1.0)*tbit_s-2e-11}' 1
+ '{(64+1.0)*tbit_s}' 0
+ '{(66+0.875)*tbit_s}' 0
+ '{(66+0.875)*tbit_s+2e-11}' 1
+ '{(66+1.0)*tbit_s-2e-11}' 1
+ '{(66+1.0)*tbit_s}' 0
+ '{(67+0.875)*tbit_s}' 0
+ '{(67+0.875)*tbit_s+2e-11}' 1
+ '{(67+1.0)*tbit_s-2e-11}' 1
+ '{(67+1.0)*tbit_s}' 0
+ '{(70+0.875)*tbit_s}' 0
+ '{(70+0.875)*tbit_s+2e-11}' 1
+ '{(70+1.0)*tbit_s-2e-11}' 1
+ '{(70+1.0)*tbit_s}' 0
+ '{(71+0.875)*tbit_s}' 0
+ '{(71+0.875)*tbit_s+2e-11}' 1
+ '{(71+1.0)*tbit_s-2e-11}' 1
+ '{(71+1.0)*tbit_s}' 0
+ '{(72+0.875)*tbit_s}' 0
+ '{(72+0.875)*tbit_s+2e-11}' 1
+ '{(72+1.0)*tbit_s-2e-11}' 1
+ '{(72+1.0)*tbit_s}' 0
+ '{(74+0.875)*tbit_s}' 0
+ '{(74+0.875)*tbit_s+2e-11}' 1
+ '{(74+1.0)*tbit_s-2e-11}' 1
+ '{(74+1.0)*tbit_s}' 0
+ '{(76+0.875)*tbit_s}' 0
+ '{(76+0.875)*tbit_s+2e-11}' 1
+ '{(76+1.0)*tbit_s-2e-11}' 1
+ '{(76+1.0)*tbit_s}' 0
+ '{(79+0.875)*tbit_s}' 0
+ '{(79+0.875)*tbit_s+2e-11}' 1
+ '{(79+1.0)*tbit_s-2e-11}' 1
+ '{(79+1.0)*tbit_s}' 0
+ '{(80+0.875)*tbit_s}' 0
+ '{(80+0.875)*tbit_s+2e-11}' 1
+ '{(80+1.0)*tbit_s-2e-11}' 1
+ '{(80+1.0)*tbit_s}' 0
+ '{(81+0.875)*tbit_s}' 0
+ '{(81+0.875)*tbit_s+2e-11}' 1
+ '{(81+1.0)*tbit_s-2e-11}' 1
+ '{(81+1.0)*tbit_s}' 0
+ '{(82+0.875)*tbit_s}' 0
+ '{(82+0.875)*tbit_s+2e-11}' 1
+ '{(82+1.0)*tbit_s-2e-11}' 1
+ '{(82+1.0)*tbit_s}' 0
+ '{(83+0.875)*tbit_s}' 0
+ '{(83+0.875)*tbit_s+2e-11}' 1
+ '{(83+1.0)*tbit_s-2e-11}' 1
+ '{(83+1.0)*tbit_s}' 0
+ '{(85+0.875)*tbit_s}' 0
+ '{(85+0.875)*tbit_s+2e-11}' 1
+ '{(85+1.0)*tbit_s-2e-11}' 1
+ '{(85+1.0)*tbit_s}' 0
+ '{(90+0.875)*tbit_s}' 0
+ '{(90+0.875)*tbit_s+2e-11}' 1
+ '{(90+1.0)*tbit_s-2e-11}' 1
+ '{(90+1.0)*tbit_s}' 0
+ '{(91+0.875)*tbit_s}' 0
+ '{(91+0.875)*tbit_s+2e-11}' 1
+ '{(91+1.0)*tbit_s-2e-11}' 1
+ '{(91+1.0)*tbit_s}' 0
+ '{(92+0.875)*tbit_s}' 0
+ '{(92+0.875)*tbit_s+2e-11}' 1
+ '{(92+1.0)*tbit_s-2e-11}' 1
+ '{(92+1.0)*tbit_s}' 0
+ '{(96+0.875)*tbit_s}' 0
+ '{(96+0.875)*tbit_s+2e-11}' 1
+ '{(96+1.0)*tbit_s-2e-11}' 1
+ '{(96+1.0)*tbit_s}' 0
+ '{(99+0.875)*tbit_s}' 0
+ '{(99+0.875)*tbit_s+2e-11}' 1
+ '{(99+1.0)*tbit_s-2e-11}' 1
+ '{(99+1.0)*tbit_s}' 0
+ '{(102+0.875)*tbit_s}' 0
+ '{(102+0.875)*tbit_s+2e-11}' 1
+ '{(102+1.0)*tbit_s-2e-11}' 1
+ '{(102+1.0)*tbit_s}' 0
+ '{(103+0.875)*tbit_s}' 0
+ '{(103+0.875)*tbit_s+2e-11}' 1
+ '{(103+1.0)*tbit_s-2e-11}' 1
+ '{(103+1.0)*tbit_s}' 0
+ '{(105+0.875)*tbit_s}' 0
+ '{(105+0.875)*tbit_s+2e-11}' 1
+ '{(105+1.0)*tbit_s-2e-11}' 1
+ '{(105+1.0)*tbit_s}' 0
+ '{(106+0.875)*tbit_s}' 0
+ '{(106+0.875)*tbit_s+2e-11}' 1
+ '{(106+1.0)*tbit_s-2e-11}' 1
+ '{(106+1.0)*tbit_s}' 0
+ '{(108+0.875)*tbit_s}' 0
+ '{(108+0.875)*tbit_s+2e-11}' 1
+ '{(108+1.0)*tbit_s-2e-11}' 1
+ '{(108+1.0)*tbit_s}' 0
+ '{(110+0.875)*tbit_s}' 0
+ '{(110+0.875)*tbit_s+2e-11}' 1
+ '{(110+1.0)*tbit_s-2e-11}' 1
+ '{(110+1.0)*tbit_s}' 0
+ '{(111+0.875)*tbit_s}' 0
+ '{(111+0.875)*tbit_s+2e-11}' 1
+ '{(111+1.0)*tbit_s-2e-11}' 1
+ '{(111+1.0)*tbit_s}' 0
+ '{(113+0.875)*tbit_s}' 0
+ '{(113+0.875)*tbit_s+2e-11}' 1
+ '{(113+1.0)*tbit_s-2e-11}' 1
+ '{(113+1.0)*tbit_s}' 0
+ '{(114+0.875)*tbit_s}' 0
+ '{(114+0.875)*tbit_s+2e-11}' 1
+ '{(114+1.0)*tbit_s-2e-11}' 1
+ '{(114+1.0)*tbit_s}' 0
+ '{(115+0.875)*tbit_s}' 0
+ '{(115+0.875)*tbit_s+2e-11}' 1
+ '{(115+1.0)*tbit_s-2e-11}' 1
+ '{(115+1.0)*tbit_s}' 0
+ '{(116+0.875)*tbit_s}' 0
+ '{(116+0.875)*tbit_s+2e-11}' 1
+ '{(116+1.0)*tbit_s-2e-11}' 1
+ '{(116+1.0)*tbit_s}' 0
+ '{(118+0.875)*tbit_s}' 0
+ '{(118+0.875)*tbit_s+2e-11}' 1
+ '{(118+1.0)*tbit_s-2e-11}' 1
+ '{(118+1.0)*tbit_s}' 0
+ '{(119+0.875)*tbit_s}' 0
+ '{(119+0.875)*tbit_s+2e-11}' 1
+ '{(119+1.0)*tbit_s-2e-11}' 1
+ '{(119+1.0)*tbit_s}' 0
+ '{(123+0.875)*tbit_s}' 0
+ '{(123+0.875)*tbit_s+2e-11}' 1
+ '{(123+1.0)*tbit_s-2e-11}' 1
+ '{(123+1.0)*tbit_s}' 0
+ '{(124+0.875)*tbit_s}' 0
+ '{(124+0.875)*tbit_s+2e-11}' 1
+ '{(124+1.0)*tbit_s-2e-11}' 1
+ '{(124+1.0)*tbit_s}' 0
+ '{(126+0.875)*tbit_s}' 0
+ '{(126+0.875)*tbit_s+2e-11}' 1
+ '{(126+1.0)*tbit_s-2e-11}' 1
+ '{(126+1.0)*tbit_s}' 0
+ '{(129+0.875)*tbit_s}' 0
+ '{(129+0.875)*tbit_s+2e-11}' 1
+ '{(129+1.0)*tbit_s-2e-11}' 1
+ '{(129+1.0)*tbit_s}' 0
+ '{(131+0.875)*tbit_s}' 0
+ '{(131+0.875)*tbit_s+2e-11}' 1
+ '{(131+1.0)*tbit_s-2e-11}' 1
+ '{(131+1.0)*tbit_s}' 0
+ '{(132+0.875)*tbit_s}' 0
+ '{(132+0.875)*tbit_s+2e-11}' 1
+ '{(132+1.0)*tbit_s-2e-11}' 1
+ '{(132+1.0)*tbit_s}' 0
+ '{(133+0.875)*tbit_s}' 0
+ '{(133+0.875)*tbit_s+2e-11}' 1
+ '{(133+1.0)*tbit_s-2e-11}' 1
+ '{(133+1.0)*tbit_s}' 0
+ '{(135+0.875)*tbit_s}' 0
+ '{(135+0.875)*tbit_s+2e-11}' 1
+ '{(135+1.0)*tbit_s-2e-11}' 1
+ '{(135+1.0)*tbit_s}' 0
+ '{(136+0.875)*tbit_s}' 0
+ '{(136+0.875)*tbit_s+2e-11}' 1
+ '{(136+1.0)*tbit_s-2e-11}' 1
+ '{(136+1.0)*tbit_s}' 0
+ '{(137+0.875)*tbit_s}' 0
+ '{(137+0.875)*tbit_s+2e-11}' 1
+ '{(137+1.0)*tbit_s-2e-11}' 1
+ '{(137+1.0)*tbit_s}' 0
+ '{(140+0.875)*tbit_s}' 0
+ '{(140+0.875)*tbit_s+2e-11}' 1
+ '{(140+1.0)*tbit_s-2e-11}' 1
+ '{(140+1.0)*tbit_s}' 0
+ '{(141+0.875)*tbit_s}' 0
+ '{(141+0.875)*tbit_s+2e-11}' 1
+ '{(141+1.0)*tbit_s-2e-11}' 1
+ '{(141+1.0)*tbit_s}' 0
+ '{(144+0.875)*tbit_s}' 0
+ '{(144+0.875)*tbit_s+2e-11}' 1
+ '{(144+1.0)*tbit_s-2e-11}' 1
+ '{(144+1.0)*tbit_s}' 0
+ '{(146+0.875)*tbit_s}' 0
+ '{(146+0.875)*tbit_s+2e-11}' 1
+ '{(146+1.0)*tbit_s-2e-11}' 1
+ '{(146+1.0)*tbit_s}' 0
+ '{(148+0.875)*tbit_s}' 0
+ '{(148+0.875)*tbit_s+2e-11}' 1
+ '{(148+1.0)*tbit_s-2e-11}' 1
+ '{(148+1.0)*tbit_s}' 0
+ )
vcomb0_7 comb0_7 0 PWL(0 0
+ '{(30+0.875)*tbit_s}' 0
+ '{(30+0.875)*tbit_s+2e-11}' 1
+ '{(30+1.0)*tbit_s-2e-11}' 1
+ '{(30+1.0)*tbit_s}' 0
+ '{(31+0.875)*tbit_s}' 0
+ '{(31+0.875)*tbit_s+2e-11}' 1
+ '{(31+1.0)*tbit_s-2e-11}' 1
+ '{(31+1.0)*tbit_s}' 0
+ '{(32+0.875)*tbit_s}' 0
+ '{(32+0.875)*tbit_s+2e-11}' 1
+ '{(32+1.0)*tbit_s-2e-11}' 1
+ '{(32+1.0)*tbit_s}' 0
+ '{(33+0.875)*tbit_s}' 0
+ '{(33+0.875)*tbit_s+2e-11}' 1
+ '{(33+1.0)*tbit_s-2e-11}' 1
+ '{(33+1.0)*tbit_s}' 0
+ '{(34+0.875)*tbit_s}' 0
+ '{(34+0.875)*tbit_s+2e-11}' 1
+ '{(34+1.0)*tbit_s-2e-11}' 1
+ '{(34+1.0)*tbit_s}' 0
+ '{(35+0.875)*tbit_s}' 0
+ '{(35+0.875)*tbit_s+2e-11}' 1
+ '{(35+1.0)*tbit_s-2e-11}' 1
+ '{(35+1.0)*tbit_s}' 0
+ '{(37+0.875)*tbit_s}' 0
+ '{(37+0.875)*tbit_s+2e-11}' 1
+ '{(37+1.0)*tbit_s-2e-11}' 1
+ '{(37+1.0)*tbit_s}' 0
+ '{(38+0.875)*tbit_s}' 0
+ '{(38+0.875)*tbit_s+2e-11}' 1
+ '{(38+1.0)*tbit_s-2e-11}' 1
+ '{(38+1.0)*tbit_s}' 0
+ '{(39+0.875)*tbit_s}' 0
+ '{(39+0.875)*tbit_s+2e-11}' 1
+ '{(39+1.0)*tbit_s-2e-11}' 1
+ '{(39+1.0)*tbit_s}' 0
+ '{(40+0.875)*tbit_s}' 0
+ '{(40+0.875)*tbit_s+2e-11}' 1
+ '{(40+1.0)*tbit_s-2e-11}' 1
+ '{(40+1.0)*tbit_s}' 0
+ '{(41+0.875)*tbit_s}' 0
+ '{(41+0.875)*tbit_s+2e-11}' 1
+ '{(41+1.0)*tbit_s-2e-11}' 1
+ '{(41+1.0)*tbit_s}' 0
+ '{(44+0.875)*tbit_s}' 0
+ '{(44+0.875)*tbit_s+2e-11}' 1
+ '{(44+1.0)*tbit_s-2e-11}' 1
+ '{(44+1.0)*tbit_s}' 0
+ '{(45+0.875)*tbit_s}' 0
+ '{(45+0.875)*tbit_s+2e-11}' 1
+ '{(45+1.0)*tbit_s-2e-11}' 1
+ '{(45+1.0)*tbit_s}' 0
+ '{(46+0.875)*tbit_s}' 0
+ '{(46+0.875)*tbit_s+2e-11}' 1
+ '{(46+1.0)*tbit_s-2e-11}' 1
+ '{(46+1.0)*tbit_s}' 0
+ '{(47+0.875)*tbit_s}' 0
+ '{(47+0.875)*tbit_s+2e-11}' 1
+ '{(47+1.0)*tbit_s-2e-11}' 1
+ '{(47+1.0)*tbit_s}' 0
+ '{(49+0.875)*tbit_s}' 0
+ '{(49+0.875)*tbit_s+2e-11}' 1
+ '{(49+1.0)*tbit_s-2e-11}' 1
+ '{(49+1.0)*tbit_s}' 0
+ '{(51+0.875)*tbit_s}' 0
+ '{(51+0.875)*tbit_s+2e-11}' 1
+ '{(51+1.0)*tbit_s-2e-11}' 1
+ '{(51+1.0)*tbit_s}' 0
+ '{(52+0.875)*tbit_s}' 0
+ '{(52+0.875)*tbit_s+2e-11}' 1
+ '{(52+1.0)*tbit_s-2e-11}' 1
+ '{(52+1.0)*tbit_s}' 0
+ '{(53+0.875)*tbit_s}' 0
+ '{(53+0.875)*tbit_s+2e-11}' 1
+ '{(53+1.0)*tbit_s-2e-11}' 1
+ '{(53+1.0)*tbit_s}' 0
+ '{(58+0.875)*tbit_s}' 0
+ '{(58+0.875)*tbit_s+2e-11}' 1
+ '{(58+1.0)*tbit_s-2e-11}' 1
+ '{(58+1.0)*tbit_s}' 0
+ '{(59+0.875)*tbit_s}' 0
+ '{(59+0.875)*tbit_s+2e-11}' 1
+ '{(59+1.0)*tbit_s-2e-11}' 1
+ '{(59+1.0)*tbit_s}' 0
+ '{(61+0.875)*tbit_s}' 0
+ '{(61+0.875)*tbit_s+2e-11}' 1
+ '{(61+1.0)*tbit_s-2e-11}' 1
+ '{(61+1.0)*tbit_s}' 0
+ '{(62+0.875)*tbit_s}' 0
+ '{(62+0.875)*tbit_s+2e-11}' 1
+ '{(62+1.0)*tbit_s-2e-11}' 1
+ '{(62+1.0)*tbit_s}' 0
+ '{(63+0.875)*tbit_s}' 0
+ '{(63+0.875)*tbit_s+2e-11}' 1
+ '{(63+1.0)*tbit_s-2e-11}' 1
+ '{(63+1.0)*tbit_s}' 0
+ '{(65+0.875)*tbit_s}' 0
+ '{(65+0.875)*tbit_s+2e-11}' 1
+ '{(65+1.0)*tbit_s-2e-11}' 1
+ '{(65+1.0)*tbit_s}' 0
+ '{(68+0.875)*tbit_s}' 0
+ '{(68+0.875)*tbit_s+2e-11}' 1
+ '{(68+1.0)*tbit_s-2e-11}' 1
+ '{(68+1.0)*tbit_s}' 0
+ '{(69+0.875)*tbit_s}' 0
+ '{(69+0.875)*tbit_s+2e-11}' 1
+ '{(69+1.0)*tbit_s-2e-11}' 1
+ '{(69+1.0)*tbit_s}' 0
+ '{(73+0.875)*tbit_s}' 0
+ '{(73+0.875)*tbit_s+2e-11}' 1
+ '{(73+1.0)*tbit_s-2e-11}' 1
+ '{(73+1.0)*tbit_s}' 0
+ '{(75+0.875)*tbit_s}' 0
+ '{(75+0.875)*tbit_s+2e-11}' 1
+ '{(75+1.0)*tbit_s-2e-11}' 1
+ '{(75+1.0)*tbit_s}' 0
+ '{(77+0.875)*tbit_s}' 0
+ '{(77+0.875)*tbit_s+2e-11}' 1
+ '{(77+1.0)*tbit_s-2e-11}' 1
+ '{(77+1.0)*tbit_s}' 0
+ '{(78+0.875)*tbit_s}' 0
+ '{(78+0.875)*tbit_s+2e-11}' 1
+ '{(78+1.0)*tbit_s-2e-11}' 1
+ '{(78+1.0)*tbit_s}' 0
+ '{(84+0.875)*tbit_s}' 0
+ '{(84+0.875)*tbit_s+2e-11}' 1
+ '{(84+1.0)*tbit_s-2e-11}' 1
+ '{(84+1.0)*tbit_s}' 0
+ '{(86+0.875)*tbit_s}' 0
+ '{(86+0.875)*tbit_s+2e-11}' 1
+ '{(86+1.0)*tbit_s-2e-11}' 1
+ '{(86+1.0)*tbit_s}' 0
+ '{(87+0.875)*tbit_s}' 0
+ '{(87+0.875)*tbit_s+2e-11}' 1
+ '{(87+1.0)*tbit_s-2e-11}' 1
+ '{(87+1.0)*tbit_s}' 0
+ '{(88+0.875)*tbit_s}' 0
+ '{(88+0.875)*tbit_s+2e-11}' 1
+ '{(88+1.0)*tbit_s-2e-11}' 1
+ '{(88+1.0)*tbit_s}' 0
+ '{(89+0.875)*tbit_s}' 0
+ '{(89+0.875)*tbit_s+2e-11}' 1
+ '{(89+1.0)*tbit_s-2e-11}' 1
+ '{(89+1.0)*tbit_s}' 0
+ '{(93+0.875)*tbit_s}' 0
+ '{(93+0.875)*tbit_s+2e-11}' 1
+ '{(93+1.0)*tbit_s-2e-11}' 1
+ '{(93+1.0)*tbit_s}' 0
+ '{(94+0.875)*tbit_s}' 0
+ '{(94+0.875)*tbit_s+2e-11}' 1
+ '{(94+1.0)*tbit_s-2e-11}' 1
+ '{(94+1.0)*tbit_s}' 0
+ '{(95+0.875)*tbit_s}' 0
+ '{(95+0.875)*tbit_s+2e-11}' 1
+ '{(95+1.0)*tbit_s-2e-11}' 1
+ '{(95+1.0)*tbit_s}' 0
+ '{(97+0.875)*tbit_s}' 0
+ '{(97+0.875)*tbit_s+2e-11}' 1
+ '{(97+1.0)*tbit_s-2e-11}' 1
+ '{(97+1.0)*tbit_s}' 0
+ '{(98+0.875)*tbit_s}' 0
+ '{(98+0.875)*tbit_s+2e-11}' 1
+ '{(98+1.0)*tbit_s-2e-11}' 1
+ '{(98+1.0)*tbit_s}' 0
+ '{(100+0.875)*tbit_s}' 0
+ '{(100+0.875)*tbit_s+2e-11}' 1
+ '{(100+1.0)*tbit_s-2e-11}' 1
+ '{(100+1.0)*tbit_s}' 0
+ '{(101+0.875)*tbit_s}' 0
+ '{(101+0.875)*tbit_s+2e-11}' 1
+ '{(101+1.0)*tbit_s-2e-11}' 1
+ '{(101+1.0)*tbit_s}' 0
+ '{(104+0.875)*tbit_s}' 0
+ '{(104+0.875)*tbit_s+2e-11}' 1
+ '{(104+1.0)*tbit_s-2e-11}' 1
+ '{(104+1.0)*tbit_s}' 0
+ '{(107+0.875)*tbit_s}' 0
+ '{(107+0.875)*tbit_s+2e-11}' 1
+ '{(107+1.0)*tbit_s-2e-11}' 1
+ '{(107+1.0)*tbit_s}' 0
+ '{(109+0.875)*tbit_s}' 0
+ '{(109+0.875)*tbit_s+2e-11}' 1
+ '{(109+1.0)*tbit_s-2e-11}' 1
+ '{(109+1.0)*tbit_s}' 0
+ '{(112+0.875)*tbit_s}' 0
+ '{(112+0.875)*tbit_s+2e-11}' 1
+ '{(112+1.0)*tbit_s-2e-11}' 1
+ '{(112+1.0)*tbit_s}' 0
+ '{(117+0.875)*tbit_s}' 0
+ '{(117+0.875)*tbit_s+2e-11}' 1
+ '{(117+1.0)*tbit_s-2e-11}' 1
+ '{(117+1.0)*tbit_s}' 0
+ '{(120+0.875)*tbit_s}' 0
+ '{(120+0.875)*tbit_s+2e-11}' 1
+ '{(120+1.0)*tbit_s-2e-11}' 1
+ '{(120+1.0)*tbit_s}' 0
+ '{(121+0.875)*tbit_s}' 0
+ '{(121+0.875)*tbit_s+2e-11}' 1
+ '{(121+1.0)*tbit_s-2e-11}' 1
+ '{(121+1.0)*tbit_s}' 0
+ '{(122+0.875)*tbit_s}' 0
+ '{(122+0.875)*tbit_s+2e-11}' 1
+ '{(122+1.0)*tbit_s-2e-11}' 1
+ '{(122+1.0)*tbit_s}' 0
+ '{(125+0.875)*tbit_s}' 0
+ '{(125+0.875)*tbit_s+2e-11}' 1
+ '{(125+1.0)*tbit_s-2e-11}' 1
+ '{(125+1.0)*tbit_s}' 0
+ '{(127+0.875)*tbit_s}' 0
+ '{(127+0.875)*tbit_s+2e-11}' 1
+ '{(127+1.0)*tbit_s-2e-11}' 1
+ '{(127+1.0)*tbit_s}' 0
+ '{(128+0.875)*tbit_s}' 0
+ '{(128+0.875)*tbit_s+2e-11}' 1
+ '{(128+1.0)*tbit_s-2e-11}' 1
+ '{(128+1.0)*tbit_s}' 0
+ '{(130+0.875)*tbit_s}' 0
+ '{(130+0.875)*tbit_s+2e-11}' 1
+ '{(130+1.0)*tbit_s-2e-11}' 1
+ '{(130+1.0)*tbit_s}' 0
+ '{(134+0.875)*tbit_s}' 0
+ '{(134+0.875)*tbit_s+2e-11}' 1
+ '{(134+1.0)*tbit_s-2e-11}' 1
+ '{(134+1.0)*tbit_s}' 0
+ '{(138+0.875)*tbit_s}' 0
+ '{(138+0.875)*tbit_s+2e-11}' 1
+ '{(138+1.0)*tbit_s-2e-11}' 1
+ '{(138+1.0)*tbit_s}' 0
+ '{(139+0.875)*tbit_s}' 0
+ '{(139+0.875)*tbit_s+2e-11}' 1
+ '{(139+1.0)*tbit_s-2e-11}' 1
+ '{(139+1.0)*tbit_s}' 0
+ '{(142+0.875)*tbit_s}' 0
+ '{(142+0.875)*tbit_s+2e-11}' 1
+ '{(142+1.0)*tbit_s-2e-11}' 1
+ '{(142+1.0)*tbit_s}' 0
+ '{(143+0.875)*tbit_s}' 0
+ '{(143+0.875)*tbit_s+2e-11}' 1
+ '{(143+1.0)*tbit_s-2e-11}' 1
+ '{(143+1.0)*tbit_s}' 0
+ '{(145+0.875)*tbit_s}' 0
+ '{(145+0.875)*tbit_s+2e-11}' 1
+ '{(145+1.0)*tbit_s-2e-11}' 1
+ '{(145+1.0)*tbit_s}' 0
+ '{(147+0.875)*tbit_s}' 0
+ '{(147+0.875)*tbit_s+2e-11}' 1
+ '{(147+1.0)*tbit_s-2e-11}' 1
+ '{(147+1.0)*tbit_s}' 0
+ '{(149+0.875)*tbit_s}' 0
+ '{(149+0.875)*tbit_s+2e-11}' 1
+ '{(149+1.0)*tbit_s-2e-11}' 1
+ '{(149+1.0)*tbit_s}' 0
+ )

* ---- driver copies: 0/1/2 pF pad capacitance (design/cml-driver-sizing.md #5) -
xc0 outp_c0 outn_c0 inp inn ib_c0 0 cml_driver
ib_c0src 0 ib_c0 dc {iref}
rp_c0 avcc outp_c0 {rterm}
rn_c0 avcc outn_c0 {rterm}
ediff_c0 vd_c0 0 outn_c0 outp_c0 1

xc1 outp_c1 outn_c1 inp inn ib_c1 0 cml_driver
ib_c1src 0 ib_c1 dc {iref}
rp_c1 avcc outp_c1 {rterm}
rn_c1 avcc outn_c1 {rterm}
cp_c1 outp_c1 0 1p
cn_c1 outn_c1 0 1p
ediff_c1 vd_c1 0 outn_c1 outp_c1 1

xc2 outp_c2 outn_c2 inp inn ib_c2 0 cml_driver
ib_c2src 0 ib_c2 dc {iref}
rp_c2 avcc outp_c2 {rterm}
rn_c2 avcc outn_c2 {rterm}
cp_c2 outp_c2 0 2p
cn_c2 outn_c2 0 2p
ediff_c2 vd_c2 0 outn_c2 outp_c2 1
