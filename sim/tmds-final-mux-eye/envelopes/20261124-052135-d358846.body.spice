* tmds-final-mux-eye -- whole-grid klt sim body (T1 item 5 envelope)
* GENERATED by sim/run_envelope.py from tmds-final-mux-eye/testbench/tb.json, do not edit
* grid: 5 process corners x 3 temperatures x 3 supplies x 2 rates = 90 corners,
* swept in the request JSON (corners.process / temperature_c / params) over this one
* body; the .param lines below are the defaults each corner overrides with
* alterparam (nominal supply, the first declared rate, first declared temperature).
* analysis  : tran 10e-12 61e-9 0 20e-12
* DUT       : ../../dut/tmds_output_stage.spice (schematic, sha256 afa79028fa54dbb05b4bf37178752e7b58ccddab40413bd1ae2b3226b94ba301)
* testbench : ../testbench/tmds_final_mux_eye.spice (sha256 1e77eb555788a334f8a2c88e9ada976775eba79e182af04a3816577e39cf3988)
.param vdd_nom=3.3
.param vdd_val=3.3
.param temp_c=-40.0
.param rate_val=742.5
.options reltol=1e-06
.options abstol=1e-09
.options vntol=1e-06
.options noinit
.include "../../dut/tmds_output_stage.spice"
.include "../testbench/tmds_final_mux_eye.spice"
