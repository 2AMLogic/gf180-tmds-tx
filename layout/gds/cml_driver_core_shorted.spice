* extracted by klt extract --deck gf180mcu

* cell cml_driver_core_shorted
* pin IBIAS
* pin INN
* pin INP
* pin OUTN
* pin OUTP,VSS
* pin TAIL
* pin vsubs
.SUBCKT cml_driver_core_shorted IBIAS INN INP OUTN OUTP|VSS TAIL vsubs
* device instance $1 r0 *1 92.67,1.82 nfet
M$1 TAIL IBIAS OUTP|VSS vsubs nfet L=0.5U W=2U AS=0.42P AD=0.42P PS=2.42U
+ PD=2.42U
* device instance $2 r0 *1 93.59,1.82 nfet
M$2 OUTP|VSS IBIAS TAIL vsubs nfet L=0.5U W=2U AS=0.42P AD=0.42P PS=2.42U
+ PD=2.42U
* device instance $3 r0 *1 94.51,1.82 nfet
M$3 TAIL IBIAS OUTP|VSS vsubs nfet L=0.5U W=2U AS=0.42P AD=0.42P PS=2.42U
+ PD=2.42U
* device instance $4 r0 *1 95.43,1.82 nfet
M$4 OUTP|VSS IBIAS TAIL vsubs nfet L=0.5U W=2U AS=0.42P AD=0.42P PS=2.42U
+ PD=2.42U
* device instance $5 r0 *1 96.35,1.82 nfet
M$5 TAIL IBIAS OUTP|VSS vsubs nfet L=0.5U W=2U AS=0.42P AD=0.42P PS=2.42U
+ PD=2.42U
* device instance $6 r0 *1 97.27,1.82 nfet
M$6 OUTP|VSS IBIAS TAIL vsubs nfet L=0.5U W=2U AS=0.42P AD=0.42P PS=2.42U
+ PD=2.42U
* device instance $7 r0 *1 98.19,1.82 nfet
M$7 TAIL IBIAS OUTP|VSS vsubs nfet L=0.5U W=2U AS=0.42P AD=0.42P PS=2.42U
+ PD=2.42U
* device instance $8 r0 *1 99.11,1.82 nfet
M$8 OUTP|VSS IBIAS TAIL vsubs nfet L=0.5U W=2U AS=0.42P AD=0.42P PS=2.42U
+ PD=2.42U
* device instance $9 r0 *1 100.03,1.82 nfet
M$9 TAIL IBIAS OUTP|VSS vsubs nfet L=0.5U W=2U AS=0.42P AD=0.42P PS=2.42U
+ PD=2.42U
* device instance $10 r0 *1 100.95,1.82 nfet
M$10 OUTP|VSS IBIAS TAIL vsubs nfet L=0.5U W=2U AS=0.42P AD=0.42P PS=2.42U
+ PD=2.42U
* device instance $11 r0 *1 101.87,1.82 nfet
M$11 TAIL IBIAS OUTP|VSS vsubs nfet L=0.5U W=2U AS=0.42P AD=0.42P PS=2.42U
+ PD=2.42U
* device instance $12 r0 *1 102.79,1.82 nfet
M$12 OUTP|VSS IBIAS TAIL vsubs nfet L=0.5U W=2U AS=0.42P AD=0.42P PS=2.42U
+ PD=2.42U
* device instance $13 r0 *1 103.71,1.82 nfet
M$13 TAIL IBIAS OUTP|VSS vsubs nfet L=0.5U W=2U AS=0.42P AD=0.42P PS=2.42U
+ PD=2.42U
* device instance $14 r0 *1 104.63,1.82 nfet
M$14 OUTP|VSS IBIAS TAIL vsubs nfet L=0.5U W=2U AS=0.42P AD=0.42P PS=2.42U
+ PD=2.42U
* device instance $15 r0 *1 105.55,1.82 nfet
M$15 TAIL IBIAS OUTP|VSS vsubs nfet L=0.5U W=2U AS=0.42P AD=0.42P PS=2.42U
+ PD=2.42U
* device instance $16 r0 *1 106.47,1.82 nfet
M$16 OUTP|VSS IBIAS TAIL vsubs nfet L=0.5U W=2U AS=0.42P AD=0.42P PS=2.42U
+ PD=2.42U
* device instance $17 r0 *1 107.39,1.82 nfet
M$17 TAIL IBIAS OUTP|VSS vsubs nfet L=0.5U W=2U AS=0.42P AD=0.42P PS=2.42U
+ PD=2.42U
* device instance $18 r0 *1 108.31,1.82 nfet
M$18 OUTP|VSS IBIAS TAIL vsubs nfet L=0.5U W=2U AS=0.42P AD=0.42P PS=2.42U
+ PD=2.42U
* device instance $19 r0 *1 109.23,1.82 nfet
M$19 TAIL IBIAS OUTP|VSS vsubs nfet L=0.5U W=2U AS=0.42P AD=0.42P PS=2.42U
+ PD=2.42U
* device instance $20 r0 *1 110.15,1.82 nfet
M$20 OUTP|VSS IBIAS TAIL vsubs nfet L=0.5U W=2U AS=0.42P AD=0.42P PS=2.42U
+ PD=2.42U
* device instance $21 r0 *1 111.07,1.82 nfet
M$21 TAIL IBIAS OUTP|VSS vsubs nfet L=0.5U W=2U AS=0.42P AD=0.42P PS=2.42U
+ PD=2.42U
* device instance $22 r0 *1 111.99,1.82 nfet
M$22 OUTP|VSS IBIAS TAIL vsubs nfet L=0.5U W=2U AS=0.42P AD=0.42P PS=2.42U
+ PD=2.42U
* device instance $23 r0 *1 112.91,1.82 nfet
M$23 TAIL IBIAS OUTP|VSS vsubs nfet L=0.5U W=2U AS=0.42P AD=0.42P PS=2.42U
+ PD=2.42U
* device instance $24 r0 *1 113.83,1.82 nfet
M$24 OUTP|VSS IBIAS TAIL vsubs nfet L=0.5U W=2U AS=0.42P AD=0.42P PS=2.42U
+ PD=2.42U
* device instance $25 r0 *1 114.75,1.82 nfet
M$25 TAIL IBIAS OUTP|VSS vsubs nfet L=0.5U W=2U AS=0.42P AD=0.42P PS=2.42U
+ PD=2.42U
* device instance $26 r0 *1 115.67,1.82 nfet
M$26 OUTP|VSS IBIAS TAIL vsubs nfet L=0.5U W=2U AS=0.42P AD=0.42P PS=2.42U
+ PD=2.42U
* device instance $27 r0 *1 116.59,1.82 nfet
M$27 TAIL IBIAS OUTP|VSS vsubs nfet L=0.5U W=2U AS=0.42P AD=0.42P PS=2.42U
+ PD=2.42U
* device instance $28 r0 *1 117.51,1.82 nfet
M$28 OUTP|VSS IBIAS TAIL vsubs nfet L=0.5U W=2U AS=0.42P AD=0.42P PS=2.42U
+ PD=2.42U
* device instance $29 r0 *1 118.43,1.82 nfet
M$29 TAIL IBIAS OUTP|VSS vsubs nfet L=0.5U W=2U AS=0.42P AD=0.42P PS=2.42U
+ PD=2.42U
* device instance $30 r0 *1 119.35,1.82 nfet
M$30 OUTP|VSS IBIAS TAIL vsubs nfet L=0.5U W=2U AS=0.42P AD=0.42P PS=2.42U
+ PD=2.42U
* device instance $31 r0 *1 120.27,1.82 nfet
M$31 TAIL IBIAS OUTP|VSS vsubs nfet L=0.5U W=2U AS=0.42P AD=0.42P PS=2.42U
+ PD=2.42U
* device instance $32 r0 *1 121.19,1.82 nfet
M$32 OUTP|VSS IBIAS TAIL vsubs nfet L=0.5U W=2U AS=0.42P AD=0.42P PS=2.42U
+ PD=2.42U
* device instance $33 r0 *1 122.11,1.82 nfet
M$33 TAIL IBIAS OUTP|VSS vsubs nfet L=0.5U W=2U AS=0.42P AD=0.42P PS=2.42U
+ PD=2.42U
* device instance $34 r0 *1 123.03,1.82 nfet
M$34 OUTP|VSS IBIAS TAIL vsubs nfet L=0.5U W=2U AS=0.42P AD=0.42P PS=2.42U
+ PD=2.42U
* device instance $35 r0 *1 123.95,1.82 nfet
M$35 TAIL IBIAS OUTP|VSS vsubs nfet L=0.5U W=2U AS=0.42P AD=0.42P PS=2.42U
+ PD=2.42U
* device instance $36 r0 *1 124.87,1.82 nfet
M$36 OUTP|VSS IBIAS TAIL vsubs nfet L=0.5U W=2U AS=0.42P AD=0.42P PS=2.42U
+ PD=2.42U
* device instance $37 r0 *1 125.79,1.82 nfet
M$37 TAIL IBIAS OUTP|VSS vsubs nfet L=0.5U W=2U AS=0.42P AD=0.42P PS=2.42U
+ PD=2.42U
* device instance $38 r0 *1 126.71,1.82 nfet
M$38 OUTP|VSS IBIAS TAIL vsubs nfet L=0.5U W=2U AS=0.42P AD=0.42P PS=2.42U
+ PD=2.42U
* device instance $39 r0 *1 127.63,1.82 nfet
M$39 TAIL IBIAS OUTP|VSS vsubs nfet L=0.5U W=2U AS=0.42P AD=0.42P PS=2.42U
+ PD=2.42U
* device instance $40 r0 *1 128.55,1.82 nfet
M$40 OUTP|VSS IBIAS TAIL vsubs nfet L=0.5U W=2U AS=0.42P AD=0.42P PS=2.42U
+ PD=2.42U
* device instance $41 r0 *1 129.47,1.82 nfet
M$41 TAIL IBIAS OUTP|VSS vsubs nfet L=0.5U W=2U AS=0.42P AD=0.42P PS=2.42U
+ PD=2.42U
* device instance $42 r0 *1 130.39,1.82 nfet
M$42 OUTP|VSS IBIAS TAIL vsubs nfet L=0.5U W=2U AS=0.42P AD=0.42P PS=2.42U
+ PD=2.42U
* device instance $43 r0 *1 131.31,1.82 nfet
M$43 TAIL IBIAS OUTP|VSS vsubs nfet L=0.5U W=2U AS=0.42P AD=0.42P PS=2.42U
+ PD=2.42U
* device instance $44 r0 *1 132.23,1.82 nfet
M$44 OUTP|VSS IBIAS TAIL vsubs nfet L=0.5U W=2U AS=0.42P AD=0.42P PS=2.42U
+ PD=2.42U
* device instance $45 r0 *1 133.15,1.82 nfet
M$45 TAIL IBIAS OUTP|VSS vsubs nfet L=0.5U W=2U AS=0.42P AD=0.42P PS=2.42U
+ PD=2.42U
* device instance $46 r0 *1 134.07,1.82 nfet
M$46 OUTP|VSS IBIAS TAIL vsubs nfet L=0.5U W=2U AS=0.42P AD=0.42P PS=2.42U
+ PD=2.42U
* device instance $47 r0 *1 134.99,1.82 nfet
M$47 TAIL IBIAS OUTP|VSS vsubs nfet L=0.5U W=2U AS=0.42P AD=0.42P PS=2.42U
+ PD=2.42U
* device instance $48 r0 *1 135.91,1.82 nfet
M$48 OUTP|VSS IBIAS TAIL vsubs nfet L=0.5U W=2U AS=0.42P AD=0.42P PS=2.42U
+ PD=2.42U
* device instance $49 r0 *1 136.83,1.82 nfet
M$49 TAIL IBIAS OUTP|VSS vsubs nfet L=0.5U W=2U AS=0.42P AD=0.42P PS=2.42U
+ PD=2.42U
* device instance $50 r0 *1 137.75,1.82 nfet
M$50 OUTP|VSS IBIAS TAIL vsubs nfet L=0.5U W=2U AS=0.42P AD=0.42P PS=2.42U
+ PD=2.42U
* device instance $51 r0 *1 138.67,1.82 nfet
M$51 TAIL IBIAS OUTP|VSS vsubs nfet L=0.5U W=2U AS=0.42P AD=0.42P PS=2.42U
+ PD=2.42U
* device instance $52 r0 *1 139.59,1.82 nfet
M$52 OUTP|VSS IBIAS TAIL vsubs nfet L=0.5U W=2U AS=0.42P AD=0.42P PS=2.42U
+ PD=2.42U
* device instance $53 r0 *1 140.51,1.82 nfet
M$53 TAIL IBIAS OUTP|VSS vsubs nfet L=0.5U W=2U AS=0.42P AD=0.42P PS=2.42U
+ PD=2.42U
* device instance $54 r0 *1 141.43,1.82 nfet
M$54 OUTP|VSS IBIAS TAIL vsubs nfet L=0.5U W=2U AS=0.42P AD=0.42P PS=2.42U
+ PD=2.42U
* device instance $55 r0 *1 142.35,1.82 nfet
M$55 TAIL IBIAS OUTP|VSS vsubs nfet L=0.5U W=2U AS=0.42P AD=0.42P PS=2.42U
+ PD=2.42U
* device instance $56 r0 *1 143.27,1.82 nfet
M$56 OUTP|VSS IBIAS TAIL vsubs nfet L=0.5U W=2U AS=0.42P AD=0.42P PS=2.42U
+ PD=2.42U
* device instance $57 r0 *1 144.19,1.82 nfet
M$57 TAIL IBIAS OUTP|VSS vsubs nfet L=0.5U W=2U AS=0.42P AD=0.42P PS=2.42U
+ PD=2.42U
* device instance $58 r0 *1 145.11,1.82 nfet
M$58 OUTP|VSS IBIAS TAIL vsubs nfet L=0.5U W=2U AS=0.42P AD=0.42P PS=2.42U
+ PD=2.42U
* device instance $59 r0 *1 146.03,1.82 nfet
M$59 TAIL IBIAS OUTP|VSS vsubs nfet L=0.5U W=2U AS=0.42P AD=0.42P PS=2.42U
+ PD=2.42U
* device instance $60 r0 *1 146.95,1.82 nfet
M$60 OUTP|VSS IBIAS TAIL vsubs nfet L=0.5U W=2U AS=0.42P AD=0.42P PS=2.42U
+ PD=2.42U
* device instance $61 r0 *1 147.87,1.82 nfet
M$61 TAIL IBIAS OUTP|VSS vsubs nfet L=0.5U W=2U AS=0.42P AD=0.42P PS=2.42U
+ PD=2.42U
* device instance $62 r0 *1 148.79,1.82 nfet
M$62 OUTP|VSS IBIAS TAIL vsubs nfet L=0.5U W=2U AS=0.42P AD=0.42P PS=2.42U
+ PD=2.42U
* device instance $63 r0 *1 149.71,1.82 nfet
M$63 TAIL IBIAS OUTP|VSS vsubs nfet L=0.5U W=2U AS=0.42P AD=0.42P PS=2.42U
+ PD=2.42U
* device instance $64 r0 *1 150.63,1.82 nfet
M$64 OUTP|VSS IBIAS TAIL vsubs nfet L=0.5U W=2U AS=0.42P AD=0.42P PS=2.42U
+ PD=2.42U
* device instance $65 r0 *1 151.55,1.82 nfet
M$65 TAIL IBIAS OUTP|VSS vsubs nfet L=0.5U W=2U AS=0.42P AD=0.42P PS=2.42U
+ PD=2.42U
* device instance $66 r0 *1 152.47,1.82 nfet
M$66 OUTP|VSS IBIAS TAIL vsubs nfet L=0.5U W=2U AS=0.42P AD=0.42P PS=2.42U
+ PD=2.42U
* device instance $67 r0 *1 153.39,1.82 nfet
M$67 TAIL IBIAS OUTP|VSS vsubs nfet L=0.5U W=2U AS=0.42P AD=0.42P PS=2.42U
+ PD=2.42U
* device instance $68 r0 *1 154.31,1.82 nfet
M$68 OUTP|VSS IBIAS TAIL vsubs nfet L=0.5U W=2U AS=0.42P AD=0.42P PS=2.42U
+ PD=2.42U
* device instance $69 r0 *1 155.23,1.82 nfet
M$69 TAIL IBIAS OUTP|VSS vsubs nfet L=0.5U W=2U AS=0.42P AD=0.42P PS=2.42U
+ PD=2.42U
* device instance $70 r0 *1 156.15,1.82 nfet
M$70 OUTP|VSS IBIAS TAIL vsubs nfet L=0.5U W=2U AS=0.42P AD=0.42P PS=2.42U
+ PD=2.42U
* device instance $71 r0 *1 157.07,1.82 nfet
M$71 TAIL IBIAS OUTP|VSS vsubs nfet L=0.5U W=2U AS=0.42P AD=0.42P PS=2.42U
+ PD=2.42U
* device instance $72 r0 *1 157.99,1.82 nfet
M$72 OUTP|VSS IBIAS TAIL vsubs nfet L=0.5U W=2U AS=0.42P AD=0.42P PS=2.42U
+ PD=2.42U
* device instance $73 r0 *1 158.91,1.82 nfet
M$73 TAIL IBIAS OUTP|VSS vsubs nfet L=0.5U W=2U AS=0.42P AD=0.42P PS=2.42U
+ PD=2.42U
* device instance $74 r0 *1 159.83,1.82 nfet
M$74 OUTP|VSS IBIAS TAIL vsubs nfet L=0.5U W=2U AS=0.42P AD=0.42P PS=2.42U
+ PD=2.42U
* device instance $75 r0 *1 160.75,1.82 nfet
M$75 TAIL IBIAS OUTP|VSS vsubs nfet L=0.5U W=2U AS=0.42P AD=0.42P PS=2.42U
+ PD=2.42U
* device instance $76 r0 *1 161.67,1.82 nfet
M$76 OUTP|VSS IBIAS TAIL vsubs nfet L=0.5U W=2U AS=0.42P AD=0.42P PS=2.42U
+ PD=2.42U
* device instance $77 r0 *1 162.59,1.82 nfet
M$77 TAIL IBIAS OUTP|VSS vsubs nfet L=0.5U W=2U AS=0.42P AD=0.42P PS=2.42U
+ PD=2.42U
* device instance $78 r0 *1 163.51,1.82 nfet
M$78 OUTP|VSS IBIAS TAIL vsubs nfet L=0.5U W=2U AS=0.42P AD=0.42P PS=2.42U
+ PD=2.42U
* device instance $79 r0 *1 164.43,1.82 nfet
M$79 TAIL IBIAS OUTP|VSS vsubs nfet L=0.5U W=2U AS=0.42P AD=0.42P PS=2.42U
+ PD=2.42U
* device instance $80 r0 *1 165.35,1.82 nfet
M$80 OUTP|VSS IBIAS TAIL vsubs nfet L=0.5U W=2U AS=0.42P AD=0.42P PS=2.42U
+ PD=2.42U
* device instance $81 r0 *1 166.27,1.82 nfet
M$81 TAIL IBIAS OUTP|VSS vsubs nfet L=0.5U W=2U AS=0.42P AD=0.42P PS=2.42U
+ PD=2.42U
* device instance $82 r0 *1 167.19,1.82 nfet
M$82 OUTP|VSS IBIAS TAIL vsubs nfet L=0.5U W=2U AS=0.42P AD=0.42P PS=2.42U
+ PD=2.42U
* device instance $83 r0 *1 168.11,1.82 nfet
M$83 TAIL IBIAS OUTP|VSS vsubs nfet L=0.5U W=2U AS=0.42P AD=0.42P PS=2.42U
+ PD=2.42U
* device instance $84 r0 *1 169.03,1.82 nfet
M$84 OUTP|VSS IBIAS TAIL vsubs nfet L=0.5U W=2U AS=0.42P AD=0.42P PS=2.42U
+ PD=2.42U
* device instance $85 r0 *1 169.95,1.82 nfet
M$85 TAIL IBIAS OUTP|VSS vsubs nfet L=0.5U W=2U AS=0.42P AD=0.42P PS=2.42U
+ PD=2.42U
* device instance $86 r0 *1 170.87,1.82 nfet
M$86 OUTP|VSS IBIAS TAIL vsubs nfet L=0.5U W=2U AS=0.42P AD=0.42P PS=2.42U
+ PD=2.42U
* device instance $87 r0 *1 171.79,1.82 nfet
M$87 TAIL IBIAS OUTP|VSS vsubs nfet L=0.5U W=2U AS=0.42P AD=0.42P PS=2.42U
+ PD=2.42U
* device instance $88 r0 *1 172.71,1.82 nfet
M$88 OUTP|VSS IBIAS TAIL vsubs nfet L=0.5U W=2U AS=0.42P AD=0.42P PS=2.42U
+ PD=2.42U
* device instance $89 r0 *1 173.63,1.82 nfet
M$89 TAIL IBIAS OUTP|VSS vsubs nfet L=0.5U W=2U AS=0.42P AD=0.42P PS=2.42U
+ PD=2.42U
* device instance $90 r0 *1 174.55,1.82 nfet
M$90 OUTP|VSS IBIAS TAIL vsubs nfet L=0.5U W=2U AS=0.42P AD=0.42P PS=2.42U
+ PD=2.42U
* device instance $91 r0 *1 175.47,1.82 nfet
M$91 TAIL IBIAS OUTP|VSS vsubs nfet L=0.5U W=2U AS=0.42P AD=0.42P PS=2.42U
+ PD=2.42U
* device instance $92 r0 *1 176.39,1.82 nfet
M$92 OUTP|VSS IBIAS TAIL vsubs nfet L=0.5U W=2U AS=0.42P AD=0.42P PS=2.42U
+ PD=2.42U
* device instance $93 r0 *1 177.31,1.82 nfet
M$93 TAIL IBIAS OUTP|VSS vsubs nfet L=0.5U W=2U AS=0.42P AD=0.42P PS=2.42U
+ PD=2.42U
* device instance $94 r0 *1 178.23,1.82 nfet
M$94 OUTP|VSS IBIAS TAIL vsubs nfet L=0.5U W=2U AS=0.42P AD=0.42P PS=2.42U
+ PD=2.42U
* device instance $95 r0 *1 179.15,1.82 nfet
M$95 TAIL IBIAS OUTP|VSS vsubs nfet L=0.5U W=2U AS=0.42P AD=0.42P PS=2.42U
+ PD=2.42U
* device instance $96 r0 *1 180.07,1.82 nfet
M$96 OUTP|VSS IBIAS TAIL vsubs nfet L=0.5U W=2U AS=0.42P AD=0.42P PS=2.42U
+ PD=2.42U
* device instance $97 r0 *1 180.99,1.82 nfet
M$97 TAIL IBIAS OUTP|VSS vsubs nfet L=0.5U W=2U AS=0.42P AD=0.42P PS=2.42U
+ PD=2.42U
* device instance $98 r0 *1 181.91,1.82 nfet
M$98 OUTP|VSS IBIAS TAIL vsubs nfet L=0.5U W=2U AS=0.42P AD=0.42P PS=2.42U
+ PD=2.42U
* device instance $99 r0 *1 182.83,1.82 nfet
M$99 TAIL IBIAS OUTP|VSS vsubs nfet L=0.5U W=2U AS=0.42P AD=0.42P PS=2.42U
+ PD=2.42U
* device instance $100 r0 *1 183.75,1.82 nfet
M$100 OUTP|VSS IBIAS TAIL vsubs nfet L=0.5U W=2U AS=0.42P AD=0.84P PS=2.42U
+ PD=4.84U
* device instance $101 r0 *1 0.67,1.82 nfet
M$101 TAIL IBIAS OUTP|VSS vsubs nfet L=0.5U W=2U AS=0.84P AD=0.42P PS=4.84U
+ PD=2.42U
* device instance $102 r0 *1 1.59,1.82 nfet
M$102 OUTP|VSS IBIAS TAIL vsubs nfet L=0.5U W=2U AS=0.42P AD=0.42P PS=2.42U
+ PD=2.42U
* device instance $103 r0 *1 2.51,1.82 nfet
M$103 TAIL IBIAS OUTP|VSS vsubs nfet L=0.5U W=2U AS=0.42P AD=0.42P PS=2.42U
+ PD=2.42U
* device instance $104 r0 *1 3.43,1.82 nfet
M$104 OUTP|VSS IBIAS TAIL vsubs nfet L=0.5U W=2U AS=0.42P AD=0.42P PS=2.42U
+ PD=2.42U
* device instance $105 r0 *1 4.35,1.82 nfet
M$105 TAIL IBIAS OUTP|VSS vsubs nfet L=0.5U W=2U AS=0.42P AD=0.42P PS=2.42U
+ PD=2.42U
* device instance $106 r0 *1 5.27,1.82 nfet
M$106 OUTP|VSS IBIAS TAIL vsubs nfet L=0.5U W=2U AS=0.42P AD=0.42P PS=2.42U
+ PD=2.42U
* device instance $107 r0 *1 6.19,1.82 nfet
M$107 TAIL IBIAS OUTP|VSS vsubs nfet L=0.5U W=2U AS=0.42P AD=0.42P PS=2.42U
+ PD=2.42U
* device instance $108 r0 *1 7.11,1.82 nfet
M$108 OUTP|VSS IBIAS TAIL vsubs nfet L=0.5U W=2U AS=0.42P AD=0.42P PS=2.42U
+ PD=2.42U
* device instance $109 r0 *1 8.03,1.82 nfet
M$109 TAIL IBIAS OUTP|VSS vsubs nfet L=0.5U W=2U AS=0.42P AD=0.42P PS=2.42U
+ PD=2.42U
* device instance $110 r0 *1 8.95,1.82 nfet
M$110 OUTP|VSS IBIAS TAIL vsubs nfet L=0.5U W=2U AS=0.42P AD=0.42P PS=2.42U
+ PD=2.42U
* device instance $111 r0 *1 9.87,1.82 nfet
M$111 TAIL IBIAS OUTP|VSS vsubs nfet L=0.5U W=2U AS=0.42P AD=0.42P PS=2.42U
+ PD=2.42U
* device instance $112 r0 *1 10.79,1.82 nfet
M$112 OUTP|VSS IBIAS TAIL vsubs nfet L=0.5U W=2U AS=0.42P AD=0.42P PS=2.42U
+ PD=2.42U
* device instance $113 r0 *1 11.71,1.82 nfet
M$113 TAIL IBIAS OUTP|VSS vsubs nfet L=0.5U W=2U AS=0.42P AD=0.42P PS=2.42U
+ PD=2.42U
* device instance $114 r0 *1 12.63,1.82 nfet
M$114 OUTP|VSS IBIAS TAIL vsubs nfet L=0.5U W=2U AS=0.42P AD=0.42P PS=2.42U
+ PD=2.42U
* device instance $115 r0 *1 13.55,1.82 nfet
M$115 TAIL IBIAS OUTP|VSS vsubs nfet L=0.5U W=2U AS=0.42P AD=0.42P PS=2.42U
+ PD=2.42U
* device instance $116 r0 *1 14.47,1.82 nfet
M$116 OUTP|VSS IBIAS TAIL vsubs nfet L=0.5U W=2U AS=0.42P AD=0.42P PS=2.42U
+ PD=2.42U
* device instance $117 r0 *1 15.39,1.82 nfet
M$117 TAIL IBIAS OUTP|VSS vsubs nfet L=0.5U W=2U AS=0.42P AD=0.42P PS=2.42U
+ PD=2.42U
* device instance $118 r0 *1 16.31,1.82 nfet
M$118 OUTP|VSS IBIAS TAIL vsubs nfet L=0.5U W=2U AS=0.42P AD=0.42P PS=2.42U
+ PD=2.42U
* device instance $119 r0 *1 17.23,1.82 nfet
M$119 TAIL IBIAS OUTP|VSS vsubs nfet L=0.5U W=2U AS=0.42P AD=0.42P PS=2.42U
+ PD=2.42U
* device instance $120 r0 *1 18.15,1.82 nfet
M$120 OUTP|VSS IBIAS TAIL vsubs nfet L=0.5U W=2U AS=0.42P AD=0.42P PS=2.42U
+ PD=2.42U
* device instance $121 r0 *1 19.07,1.82 nfet
M$121 TAIL IBIAS OUTP|VSS vsubs nfet L=0.5U W=2U AS=0.42P AD=0.42P PS=2.42U
+ PD=2.42U
* device instance $122 r0 *1 19.99,1.82 nfet
M$122 OUTP|VSS IBIAS TAIL vsubs nfet L=0.5U W=2U AS=0.42P AD=0.42P PS=2.42U
+ PD=2.42U
* device instance $123 r0 *1 20.91,1.82 nfet
M$123 TAIL IBIAS OUTP|VSS vsubs nfet L=0.5U W=2U AS=0.42P AD=0.42P PS=2.42U
+ PD=2.42U
* device instance $124 r0 *1 21.83,1.82 nfet
M$124 OUTP|VSS IBIAS TAIL vsubs nfet L=0.5U W=2U AS=0.42P AD=0.42P PS=2.42U
+ PD=2.42U
* device instance $125 r0 *1 22.75,1.82 nfet
M$125 TAIL IBIAS OUTP|VSS vsubs nfet L=0.5U W=2U AS=0.42P AD=0.42P PS=2.42U
+ PD=2.42U
* device instance $126 r0 *1 23.67,1.82 nfet
M$126 OUTP|VSS IBIAS TAIL vsubs nfet L=0.5U W=2U AS=0.42P AD=0.42P PS=2.42U
+ PD=2.42U
* device instance $127 r0 *1 24.59,1.82 nfet
M$127 TAIL IBIAS OUTP|VSS vsubs nfet L=0.5U W=2U AS=0.42P AD=0.42P PS=2.42U
+ PD=2.42U
* device instance $128 r0 *1 25.51,1.82 nfet
M$128 OUTP|VSS IBIAS TAIL vsubs nfet L=0.5U W=2U AS=0.42P AD=0.42P PS=2.42U
+ PD=2.42U
* device instance $129 r0 *1 26.43,1.82 nfet
M$129 TAIL IBIAS OUTP|VSS vsubs nfet L=0.5U W=2U AS=0.42P AD=0.42P PS=2.42U
+ PD=2.42U
* device instance $130 r0 *1 27.35,1.82 nfet
M$130 OUTP|VSS IBIAS TAIL vsubs nfet L=0.5U W=2U AS=0.42P AD=0.42P PS=2.42U
+ PD=2.42U
* device instance $131 r0 *1 28.27,1.82 nfet
M$131 TAIL IBIAS OUTP|VSS vsubs nfet L=0.5U W=2U AS=0.42P AD=0.42P PS=2.42U
+ PD=2.42U
* device instance $132 r0 *1 29.19,1.82 nfet
M$132 OUTP|VSS IBIAS TAIL vsubs nfet L=0.5U W=2U AS=0.42P AD=0.42P PS=2.42U
+ PD=2.42U
* device instance $133 r0 *1 30.11,1.82 nfet
M$133 TAIL IBIAS OUTP|VSS vsubs nfet L=0.5U W=2U AS=0.42P AD=0.42P PS=2.42U
+ PD=2.42U
* device instance $134 r0 *1 31.03,1.82 nfet
M$134 OUTP|VSS IBIAS TAIL vsubs nfet L=0.5U W=2U AS=0.42P AD=0.42P PS=2.42U
+ PD=2.42U
* device instance $135 r0 *1 31.95,1.82 nfet
M$135 TAIL IBIAS OUTP|VSS vsubs nfet L=0.5U W=2U AS=0.42P AD=0.42P PS=2.42U
+ PD=2.42U
* device instance $136 r0 *1 32.87,1.82 nfet
M$136 OUTP|VSS IBIAS TAIL vsubs nfet L=0.5U W=2U AS=0.42P AD=0.42P PS=2.42U
+ PD=2.42U
* device instance $137 r0 *1 33.79,1.82 nfet
M$137 TAIL IBIAS OUTP|VSS vsubs nfet L=0.5U W=2U AS=0.42P AD=0.42P PS=2.42U
+ PD=2.42U
* device instance $138 r0 *1 34.71,1.82 nfet
M$138 OUTP|VSS IBIAS TAIL vsubs nfet L=0.5U W=2U AS=0.42P AD=0.42P PS=2.42U
+ PD=2.42U
* device instance $139 r0 *1 35.63,1.82 nfet
M$139 TAIL IBIAS OUTP|VSS vsubs nfet L=0.5U W=2U AS=0.42P AD=0.42P PS=2.42U
+ PD=2.42U
* device instance $140 r0 *1 36.55,1.82 nfet
M$140 OUTP|VSS IBIAS TAIL vsubs nfet L=0.5U W=2U AS=0.42P AD=0.42P PS=2.42U
+ PD=2.42U
* device instance $141 r0 *1 37.47,1.82 nfet
M$141 TAIL IBIAS OUTP|VSS vsubs nfet L=0.5U W=2U AS=0.42P AD=0.42P PS=2.42U
+ PD=2.42U
* device instance $142 r0 *1 38.39,1.82 nfet
M$142 OUTP|VSS IBIAS TAIL vsubs nfet L=0.5U W=2U AS=0.42P AD=0.42P PS=2.42U
+ PD=2.42U
* device instance $143 r0 *1 39.31,1.82 nfet
M$143 TAIL IBIAS OUTP|VSS vsubs nfet L=0.5U W=2U AS=0.42P AD=0.42P PS=2.42U
+ PD=2.42U
* device instance $144 r0 *1 40.23,1.82 nfet
M$144 OUTP|VSS IBIAS TAIL vsubs nfet L=0.5U W=2U AS=0.42P AD=0.42P PS=2.42U
+ PD=2.42U
* device instance $145 r0 *1 41.15,1.82 nfet
M$145 TAIL IBIAS OUTP|VSS vsubs nfet L=0.5U W=2U AS=0.42P AD=0.42P PS=2.42U
+ PD=2.42U
* device instance $146 r0 *1 42.07,1.82 nfet
M$146 OUTP|VSS IBIAS TAIL vsubs nfet L=0.5U W=2U AS=0.42P AD=0.42P PS=2.42U
+ PD=2.42U
* device instance $147 r0 *1 42.99,1.82 nfet
M$147 TAIL IBIAS OUTP|VSS vsubs nfet L=0.5U W=2U AS=0.42P AD=0.42P PS=2.42U
+ PD=2.42U
* device instance $148 r0 *1 43.91,1.82 nfet
M$148 OUTP|VSS IBIAS TAIL vsubs nfet L=0.5U W=2U AS=0.42P AD=0.42P PS=2.42U
+ PD=2.42U
* device instance $149 r0 *1 44.83,1.82 nfet
M$149 TAIL IBIAS OUTP|VSS vsubs nfet L=0.5U W=2U AS=0.42P AD=0.42P PS=2.42U
+ PD=2.42U
* device instance $150 r0 *1 45.75,1.82 nfet
M$150 OUTP|VSS IBIAS TAIL vsubs nfet L=0.5U W=2U AS=0.42P AD=0.42P PS=2.42U
+ PD=2.42U
* device instance $151 r0 *1 46.67,1.82 nfet
M$151 TAIL IBIAS OUTP|VSS vsubs nfet L=0.5U W=2U AS=0.42P AD=0.42P PS=2.42U
+ PD=2.42U
* device instance $152 r0 *1 47.59,1.82 nfet
M$152 OUTP|VSS IBIAS TAIL vsubs nfet L=0.5U W=2U AS=0.42P AD=0.42P PS=2.42U
+ PD=2.42U
* device instance $153 r0 *1 48.51,1.82 nfet
M$153 TAIL IBIAS OUTP|VSS vsubs nfet L=0.5U W=2U AS=0.42P AD=0.42P PS=2.42U
+ PD=2.42U
* device instance $154 r0 *1 49.43,1.82 nfet
M$154 OUTP|VSS IBIAS TAIL vsubs nfet L=0.5U W=2U AS=0.42P AD=0.42P PS=2.42U
+ PD=2.42U
* device instance $155 r0 *1 50.35,1.82 nfet
M$155 TAIL IBIAS OUTP|VSS vsubs nfet L=0.5U W=2U AS=0.42P AD=0.42P PS=2.42U
+ PD=2.42U
* device instance $156 r0 *1 51.27,1.82 nfet
M$156 OUTP|VSS IBIAS TAIL vsubs nfet L=0.5U W=2U AS=0.42P AD=0.42P PS=2.42U
+ PD=2.42U
* device instance $157 r0 *1 52.19,1.82 nfet
M$157 TAIL IBIAS OUTP|VSS vsubs nfet L=0.5U W=2U AS=0.42P AD=0.42P PS=2.42U
+ PD=2.42U
* device instance $158 r0 *1 53.11,1.82 nfet
M$158 OUTP|VSS IBIAS TAIL vsubs nfet L=0.5U W=2U AS=0.42P AD=0.42P PS=2.42U
+ PD=2.42U
* device instance $159 r0 *1 54.03,1.82 nfet
M$159 TAIL IBIAS OUTP|VSS vsubs nfet L=0.5U W=2U AS=0.42P AD=0.42P PS=2.42U
+ PD=2.42U
* device instance $160 r0 *1 54.95,1.82 nfet
M$160 OUTP|VSS IBIAS TAIL vsubs nfet L=0.5U W=2U AS=0.42P AD=0.42P PS=2.42U
+ PD=2.42U
* device instance $161 r0 *1 55.87,1.82 nfet
M$161 TAIL IBIAS OUTP|VSS vsubs nfet L=0.5U W=2U AS=0.42P AD=0.42P PS=2.42U
+ PD=2.42U
* device instance $162 r0 *1 56.79,1.82 nfet
M$162 OUTP|VSS IBIAS TAIL vsubs nfet L=0.5U W=2U AS=0.42P AD=0.42P PS=2.42U
+ PD=2.42U
* device instance $163 r0 *1 57.71,1.82 nfet
M$163 TAIL IBIAS OUTP|VSS vsubs nfet L=0.5U W=2U AS=0.42P AD=0.42P PS=2.42U
+ PD=2.42U
* device instance $164 r0 *1 58.63,1.82 nfet
M$164 OUTP|VSS IBIAS TAIL vsubs nfet L=0.5U W=2U AS=0.42P AD=0.42P PS=2.42U
+ PD=2.42U
* device instance $165 r0 *1 59.55,1.82 nfet
M$165 TAIL IBIAS OUTP|VSS vsubs nfet L=0.5U W=2U AS=0.42P AD=0.42P PS=2.42U
+ PD=2.42U
* device instance $166 r0 *1 60.47,1.82 nfet
M$166 OUTP|VSS IBIAS TAIL vsubs nfet L=0.5U W=2U AS=0.42P AD=0.42P PS=2.42U
+ PD=2.42U
* device instance $167 r0 *1 61.39,1.82 nfet
M$167 TAIL IBIAS OUTP|VSS vsubs nfet L=0.5U W=2U AS=0.42P AD=0.42P PS=2.42U
+ PD=2.42U
* device instance $168 r0 *1 62.31,1.82 nfet
M$168 OUTP|VSS IBIAS TAIL vsubs nfet L=0.5U W=2U AS=0.42P AD=0.42P PS=2.42U
+ PD=2.42U
* device instance $169 r0 *1 63.23,1.82 nfet
M$169 TAIL IBIAS OUTP|VSS vsubs nfet L=0.5U W=2U AS=0.42P AD=0.42P PS=2.42U
+ PD=2.42U
* device instance $170 r0 *1 64.15,1.82 nfet
M$170 OUTP|VSS IBIAS TAIL vsubs nfet L=0.5U W=2U AS=0.42P AD=0.42P PS=2.42U
+ PD=2.42U
* device instance $171 r0 *1 65.07,1.82 nfet
M$171 TAIL IBIAS OUTP|VSS vsubs nfet L=0.5U W=2U AS=0.42P AD=0.42P PS=2.42U
+ PD=2.42U
* device instance $172 r0 *1 65.99,1.82 nfet
M$172 OUTP|VSS IBIAS TAIL vsubs nfet L=0.5U W=2U AS=0.42P AD=0.42P PS=2.42U
+ PD=2.42U
* device instance $173 r0 *1 66.91,1.82 nfet
M$173 TAIL IBIAS OUTP|VSS vsubs nfet L=0.5U W=2U AS=0.42P AD=0.42P PS=2.42U
+ PD=2.42U
* device instance $174 r0 *1 67.83,1.82 nfet
M$174 OUTP|VSS IBIAS TAIL vsubs nfet L=0.5U W=2U AS=0.42P AD=0.42P PS=2.42U
+ PD=2.42U
* device instance $175 r0 *1 68.75,1.82 nfet
M$175 TAIL IBIAS OUTP|VSS vsubs nfet L=0.5U W=2U AS=0.42P AD=0.42P PS=2.42U
+ PD=2.42U
* device instance $176 r0 *1 69.67,1.82 nfet
M$176 OUTP|VSS IBIAS TAIL vsubs nfet L=0.5U W=2U AS=0.42P AD=0.42P PS=2.42U
+ PD=2.42U
* device instance $177 r0 *1 70.59,1.82 nfet
M$177 TAIL IBIAS OUTP|VSS vsubs nfet L=0.5U W=2U AS=0.42P AD=0.42P PS=2.42U
+ PD=2.42U
* device instance $178 r0 *1 71.51,1.82 nfet
M$178 OUTP|VSS IBIAS TAIL vsubs nfet L=0.5U W=2U AS=0.42P AD=0.42P PS=2.42U
+ PD=2.42U
* device instance $179 r0 *1 72.43,1.82 nfet
M$179 TAIL IBIAS OUTP|VSS vsubs nfet L=0.5U W=2U AS=0.42P AD=0.42P PS=2.42U
+ PD=2.42U
* device instance $180 r0 *1 73.35,1.82 nfet
M$180 OUTP|VSS IBIAS TAIL vsubs nfet L=0.5U W=2U AS=0.42P AD=0.42P PS=2.42U
+ PD=2.42U
* device instance $181 r0 *1 74.27,1.82 nfet
M$181 TAIL IBIAS OUTP|VSS vsubs nfet L=0.5U W=2U AS=0.42P AD=0.42P PS=2.42U
+ PD=2.42U
* device instance $182 r0 *1 75.19,1.82 nfet
M$182 OUTP|VSS IBIAS TAIL vsubs nfet L=0.5U W=2U AS=0.42P AD=0.42P PS=2.42U
+ PD=2.42U
* device instance $183 r0 *1 76.11,1.82 nfet
M$183 TAIL IBIAS OUTP|VSS vsubs nfet L=0.5U W=2U AS=0.42P AD=0.42P PS=2.42U
+ PD=2.42U
* device instance $184 r0 *1 77.03,1.82 nfet
M$184 OUTP|VSS IBIAS TAIL vsubs nfet L=0.5U W=2U AS=0.42P AD=0.42P PS=2.42U
+ PD=2.42U
* device instance $185 r0 *1 77.95,1.82 nfet
M$185 TAIL IBIAS OUTP|VSS vsubs nfet L=0.5U W=2U AS=0.42P AD=0.42P PS=2.42U
+ PD=2.42U
* device instance $186 r0 *1 78.87,1.82 nfet
M$186 OUTP|VSS IBIAS TAIL vsubs nfet L=0.5U W=2U AS=0.42P AD=0.42P PS=2.42U
+ PD=2.42U
* device instance $187 r0 *1 79.79,1.82 nfet
M$187 TAIL IBIAS OUTP|VSS vsubs nfet L=0.5U W=2U AS=0.42P AD=0.42P PS=2.42U
+ PD=2.42U
* device instance $188 r0 *1 80.71,1.82 nfet
M$188 OUTP|VSS IBIAS TAIL vsubs nfet L=0.5U W=2U AS=0.42P AD=0.42P PS=2.42U
+ PD=2.42U
* device instance $189 r0 *1 81.63,1.82 nfet
M$189 TAIL IBIAS OUTP|VSS vsubs nfet L=0.5U W=2U AS=0.42P AD=0.42P PS=2.42U
+ PD=2.42U
* device instance $190 r0 *1 82.55,1.82 nfet
M$190 OUTP|VSS IBIAS TAIL vsubs nfet L=0.5U W=2U AS=0.42P AD=0.42P PS=2.42U
+ PD=2.42U
* device instance $191 r0 *1 83.47,1.82 nfet
M$191 TAIL IBIAS OUTP|VSS vsubs nfet L=0.5U W=2U AS=0.42P AD=0.42P PS=2.42U
+ PD=2.42U
* device instance $192 r0 *1 84.39,1.82 nfet
M$192 OUTP|VSS IBIAS TAIL vsubs nfet L=0.5U W=2U AS=0.42P AD=0.42P PS=2.42U
+ PD=2.42U
* device instance $193 r0 *1 85.31,1.82 nfet
M$193 TAIL IBIAS OUTP|VSS vsubs nfet L=0.5U W=2U AS=0.42P AD=0.42P PS=2.42U
+ PD=2.42U
* device instance $194 r0 *1 86.23,1.82 nfet
M$194 OUTP|VSS IBIAS TAIL vsubs nfet L=0.5U W=2U AS=0.42P AD=0.42P PS=2.42U
+ PD=2.42U
* device instance $195 r0 *1 87.15,1.82 nfet
M$195 TAIL IBIAS OUTP|VSS vsubs nfet L=0.5U W=2U AS=0.42P AD=0.42P PS=2.42U
+ PD=2.42U
* device instance $196 r0 *1 88.07,1.82 nfet
M$196 OUTP|VSS IBIAS TAIL vsubs nfet L=0.5U W=2U AS=0.42P AD=0.42P PS=2.42U
+ PD=2.42U
* device instance $197 r0 *1 88.99,1.82 nfet
M$197 TAIL IBIAS OUTP|VSS vsubs nfet L=0.5U W=2U AS=0.42P AD=0.42P PS=2.42U
+ PD=2.42U
* device instance $198 r0 *1 89.91,1.82 nfet
M$198 OUTP|VSS IBIAS TAIL vsubs nfet L=0.5U W=2U AS=0.42P AD=0.42P PS=2.42U
+ PD=2.42U
* device instance $199 r0 *1 90.83,1.82 nfet
M$199 TAIL IBIAS OUTP|VSS vsubs nfet L=0.5U W=2U AS=0.42P AD=0.42P PS=2.42U
+ PD=2.42U
* device instance $200 r0 *1 91.75,1.82 nfet
M$200 OUTP|VSS IBIAS TAIL vsubs nfet L=0.5U W=2U AS=0.42P AD=0.42P PS=2.42U
+ PD=2.42U
* device instance $201 r0 *1 189.98,1.82 nfet
M$201 OUTP|VSS INP TAIL vsubs nfet L=0.28U W=2U AS=0.84P AD=0.42P PS=4.84U
+ PD=2.42U
* device instance $202 r0 *1 190.68,1.82 nfet
M$202 TAIL INP OUTP|VSS vsubs nfet L=0.28U W=2U AS=0.42P AD=0.42P PS=2.42U
+ PD=2.42U
* device instance $203 r0 *1 191.38,1.82 nfet
M$203 OUTP|VSS INP TAIL vsubs nfet L=0.28U W=2U AS=0.42P AD=0.42P PS=2.42U
+ PD=2.42U
* device instance $204 r0 *1 192.08,1.82 nfet
M$204 TAIL INP OUTP|VSS vsubs nfet L=0.28U W=2U AS=0.42P AD=0.42P PS=2.42U
+ PD=2.42U
* device instance $205 r0 *1 192.78,1.82 nfet
M$205 OUTP|VSS INP TAIL vsubs nfet L=0.28U W=2U AS=0.42P AD=0.42P PS=2.42U
+ PD=2.42U
* device instance $206 r0 *1 193.48,1.82 nfet
M$206 TAIL INP OUTP|VSS vsubs nfet L=0.28U W=2U AS=0.42P AD=0.42P PS=2.42U
+ PD=2.42U
* device instance $207 r0 *1 194.18,1.82 nfet
M$207 OUTP|VSS INP TAIL vsubs nfet L=0.28U W=2U AS=0.42P AD=0.42P PS=2.42U
+ PD=2.42U
* device instance $208 r0 *1 194.88,1.82 nfet
M$208 TAIL INP OUTP|VSS vsubs nfet L=0.28U W=2U AS=0.42P AD=0.42P PS=2.42U
+ PD=2.42U
* device instance $209 r0 *1 195.58,1.82 nfet
M$209 OUTP|VSS INP TAIL vsubs nfet L=0.28U W=2U AS=0.42P AD=0.42P PS=2.42U
+ PD=2.42U
* device instance $210 r0 *1 196.28,1.82 nfet
M$210 TAIL INP OUTP|VSS vsubs nfet L=0.28U W=2U AS=0.42P AD=0.42P PS=2.42U
+ PD=2.42U
* device instance $211 r0 *1 196.98,1.82 nfet
M$211 OUTP|VSS INP TAIL vsubs nfet L=0.28U W=2U AS=0.42P AD=0.42P PS=2.42U
+ PD=2.42U
* device instance $212 r0 *1 197.68,1.82 nfet
M$212 TAIL INP OUTP|VSS vsubs nfet L=0.28U W=2U AS=0.42P AD=0.42P PS=2.42U
+ PD=2.42U
* device instance $213 r0 *1 198.38,1.82 nfet
M$213 OUTP|VSS INP TAIL vsubs nfet L=0.28U W=2U AS=0.42P AD=0.42P PS=2.42U
+ PD=2.42U
* device instance $214 r0 *1 199.08,1.82 nfet
M$214 TAIL INP OUTP|VSS vsubs nfet L=0.28U W=2U AS=0.42P AD=0.42P PS=2.42U
+ PD=2.42U
* device instance $215 r0 *1 199.78,1.82 nfet
M$215 OUTP|VSS INP TAIL vsubs nfet L=0.28U W=2U AS=0.42P AD=0.42P PS=2.42U
+ PD=2.42U
* device instance $216 r0 *1 200.48,1.82 nfet
M$216 TAIL INP OUTP|VSS vsubs nfet L=0.28U W=2U AS=0.42P AD=0.42P PS=2.42U
+ PD=2.42U
* device instance $217 r0 *1 201.18,1.82 nfet
M$217 OUTP|VSS INP TAIL vsubs nfet L=0.28U W=2U AS=0.42P AD=0.42P PS=2.42U
+ PD=2.42U
* device instance $218 r0 *1 201.88,1.82 nfet
M$218 TAIL INP OUTP|VSS vsubs nfet L=0.28U W=2U AS=0.42P AD=0.42P PS=2.42U
+ PD=2.42U
* device instance $219 r0 *1 202.58,1.82 nfet
M$219 OUTP|VSS INP TAIL vsubs nfet L=0.28U W=2U AS=0.42P AD=0.42P PS=2.42U
+ PD=2.42U
* device instance $220 r0 *1 203.28,1.82 nfet
M$220 TAIL INP OUTP|VSS vsubs nfet L=0.28U W=2U AS=0.42P AD=0.42P PS=2.42U
+ PD=2.42U
* device instance $221 r0 *1 203.98,1.82 nfet
M$221 OUTP|VSS INP TAIL vsubs nfet L=0.28U W=2U AS=0.42P AD=0.42P PS=2.42U
+ PD=2.42U
* device instance $222 r0 *1 204.68,1.82 nfet
M$222 TAIL INP OUTP|VSS vsubs nfet L=0.28U W=2U AS=0.42P AD=0.42P PS=2.42U
+ PD=2.42U
* device instance $223 r0 *1 205.38,1.82 nfet
M$223 OUTP|VSS INP TAIL vsubs nfet L=0.28U W=2U AS=0.42P AD=0.42P PS=2.42U
+ PD=2.42U
* device instance $224 r0 *1 206.08,1.82 nfet
M$224 TAIL INP OUTP|VSS vsubs nfet L=0.28U W=2U AS=0.42P AD=0.42P PS=2.42U
+ PD=2.42U
* device instance $225 r0 *1 206.78,1.82 nfet
M$225 OUTP|VSS INP TAIL vsubs nfet L=0.28U W=2U AS=0.42P AD=0.42P PS=2.42U
+ PD=2.42U
* device instance $226 r0 *1 207.48,1.82 nfet
M$226 TAIL INP OUTP|VSS vsubs nfet L=0.28U W=2U AS=0.42P AD=0.42P PS=2.42U
+ PD=2.42U
* device instance $227 r0 *1 208.18,1.82 nfet
M$227 OUTP|VSS INP TAIL vsubs nfet L=0.28U W=2U AS=0.42P AD=0.42P PS=2.42U
+ PD=2.42U
* device instance $228 r0 *1 208.88,1.82 nfet
M$228 TAIL INP OUTP|VSS vsubs nfet L=0.28U W=2U AS=0.42P AD=0.42P PS=2.42U
+ PD=2.42U
* device instance $229 r0 *1 209.58,1.82 nfet
M$229 OUTP|VSS INP TAIL vsubs nfet L=0.28U W=2U AS=0.42P AD=0.42P PS=2.42U
+ PD=2.42U
* device instance $230 r0 *1 210.28,1.82 nfet
M$230 TAIL INP OUTP|VSS vsubs nfet L=0.28U W=2U AS=0.42P AD=0.42P PS=2.42U
+ PD=2.42U
* device instance $231 r0 *1 210.98,1.82 nfet
M$231 OUTP|VSS INP TAIL vsubs nfet L=0.28U W=2U AS=0.42P AD=0.42P PS=2.42U
+ PD=2.42U
* device instance $232 r0 *1 211.68,1.82 nfet
M$232 TAIL INP OUTP|VSS vsubs nfet L=0.28U W=2U AS=0.42P AD=0.42P PS=2.42U
+ PD=2.42U
* device instance $233 r0 *1 212.38,1.82 nfet
M$233 OUTP|VSS INP TAIL vsubs nfet L=0.28U W=2U AS=0.42P AD=0.42P PS=2.42U
+ PD=2.42U
* device instance $234 r0 *1 213.08,1.82 nfet
M$234 TAIL INP OUTP|VSS vsubs nfet L=0.28U W=2U AS=0.42P AD=0.42P PS=2.42U
+ PD=2.42U
* device instance $235 r0 *1 213.78,1.82 nfet
M$235 OUTP|VSS INP TAIL vsubs nfet L=0.28U W=2U AS=0.42P AD=0.42P PS=2.42U
+ PD=2.42U
* device instance $236 r0 *1 214.48,1.82 nfet
M$236 TAIL INP OUTP|VSS vsubs nfet L=0.28U W=2U AS=0.42P AD=0.42P PS=2.42U
+ PD=2.42U
* device instance $237 r0 *1 215.18,1.82 nfet
M$237 OUTP|VSS INP TAIL vsubs nfet L=0.28U W=2U AS=0.42P AD=0.42P PS=2.42U
+ PD=2.42U
* device instance $238 r0 *1 215.88,1.82 nfet
M$238 TAIL INP OUTP|VSS vsubs nfet L=0.28U W=2U AS=0.42P AD=0.42P PS=2.42U
+ PD=2.42U
* device instance $239 r0 *1 216.58,1.82 nfet
M$239 OUTP|VSS INP TAIL vsubs nfet L=0.28U W=2U AS=0.42P AD=0.42P PS=2.42U
+ PD=2.42U
* device instance $240 r0 *1 217.28,1.82 nfet
M$240 TAIL INP OUTP|VSS vsubs nfet L=0.28U W=2U AS=0.42P AD=0.42P PS=2.42U
+ PD=2.42U
* device instance $241 r0 *1 217.98,1.82 nfet
M$241 OUTP|VSS INP TAIL vsubs nfet L=0.28U W=2U AS=0.42P AD=0.42P PS=2.42U
+ PD=2.42U
* device instance $242 r0 *1 218.68,1.82 nfet
M$242 TAIL INP OUTP|VSS vsubs nfet L=0.28U W=2U AS=0.42P AD=0.42P PS=2.42U
+ PD=2.42U
* device instance $243 r0 *1 219.38,1.82 nfet
M$243 OUTP|VSS INP TAIL vsubs nfet L=0.28U W=2U AS=0.42P AD=0.42P PS=2.42U
+ PD=2.42U
* device instance $244 r0 *1 220.08,1.82 nfet
M$244 TAIL INP OUTP|VSS vsubs nfet L=0.28U W=2U AS=0.42P AD=0.42P PS=2.42U
+ PD=2.42U
* device instance $245 r0 *1 220.78,1.82 nfet
M$245 OUTP|VSS INP TAIL vsubs nfet L=0.28U W=2U AS=0.42P AD=0.42P PS=2.42U
+ PD=2.42U
* device instance $246 r0 *1 221.48,1.82 nfet
M$246 TAIL INP OUTP|VSS vsubs nfet L=0.28U W=2U AS=0.42P AD=0.42P PS=2.42U
+ PD=2.42U
* device instance $247 r0 *1 222.18,1.82 nfet
M$247 OUTP|VSS INP TAIL vsubs nfet L=0.28U W=2U AS=0.42P AD=0.42P PS=2.42U
+ PD=2.42U
* device instance $248 r0 *1 222.88,1.82 nfet
M$248 TAIL INP OUTP|VSS vsubs nfet L=0.28U W=2U AS=0.42P AD=0.42P PS=2.42U
+ PD=2.42U
* device instance $249 r0 *1 223.58,1.82 nfet
M$249 OUTP|VSS INP TAIL vsubs nfet L=0.28U W=2U AS=0.42P AD=0.42P PS=2.42U
+ PD=2.42U
* device instance $250 r0 *1 224.28,1.82 nfet
M$250 TAIL INP OUTP|VSS vsubs nfet L=0.28U W=2U AS=0.42P AD=0.42P PS=2.42U
+ PD=2.42U
* device instance $251 r0 *1 224.98,1.82 nfet
M$251 OUTP|VSS INP TAIL vsubs nfet L=0.28U W=2U AS=0.42P AD=0.42P PS=2.42U
+ PD=2.42U
* device instance $252 r0 *1 225.68,1.82 nfet
M$252 TAIL INP OUTP|VSS vsubs nfet L=0.28U W=2U AS=0.42P AD=0.42P PS=2.42U
+ PD=2.42U
* device instance $253 r0 *1 226.38,1.82 nfet
M$253 OUTP|VSS INP TAIL vsubs nfet L=0.28U W=2U AS=0.42P AD=0.42P PS=2.42U
+ PD=2.42U
* device instance $254 r0 *1 227.08,1.82 nfet
M$254 TAIL INP OUTP|VSS vsubs nfet L=0.28U W=2U AS=0.42P AD=0.42P PS=2.42U
+ PD=2.42U
* device instance $255 r0 *1 227.78,1.82 nfet
M$255 OUTP|VSS INP TAIL vsubs nfet L=0.28U W=2U AS=0.42P AD=0.42P PS=2.42U
+ PD=2.42U
* device instance $256 r0 *1 228.48,1.82 nfet
M$256 TAIL INP OUTP|VSS vsubs nfet L=0.28U W=2U AS=0.42P AD=0.42P PS=2.42U
+ PD=2.42U
* device instance $257 r0 *1 229.18,1.82 nfet
M$257 OUTP|VSS INP TAIL vsubs nfet L=0.28U W=2U AS=0.42P AD=0.42P PS=2.42U
+ PD=2.42U
* device instance $258 r0 *1 229.88,1.82 nfet
M$258 TAIL INP OUTP|VSS vsubs nfet L=0.28U W=2U AS=0.42P AD=0.42P PS=2.42U
+ PD=2.42U
* device instance $259 r0 *1 230.58,1.82 nfet
M$259 OUTP|VSS INP TAIL vsubs nfet L=0.28U W=2U AS=0.42P AD=0.42P PS=2.42U
+ PD=2.42U
* device instance $260 r0 *1 231.28,1.82 nfet
M$260 TAIL INP OUTP|VSS vsubs nfet L=0.28U W=2U AS=0.42P AD=0.42P PS=2.42U
+ PD=2.42U
* device instance $261 r0 *1 231.98,1.82 nfet
M$261 OUTP|VSS INP TAIL vsubs nfet L=0.28U W=2U AS=0.42P AD=0.42P PS=2.42U
+ PD=2.42U
* device instance $262 r0 *1 232.68,1.82 nfet
M$262 TAIL INP OUTP|VSS vsubs nfet L=0.28U W=2U AS=0.42P AD=0.42P PS=2.42U
+ PD=2.42U
* device instance $263 r0 *1 233.38,1.82 nfet
M$263 OUTP|VSS INP TAIL vsubs nfet L=0.28U W=2U AS=0.42P AD=0.42P PS=2.42U
+ PD=2.42U
* device instance $264 r0 *1 234.08,1.82 nfet
M$264 TAIL INP OUTP|VSS vsubs nfet L=0.28U W=2U AS=0.42P AD=0.84P PS=2.42U
+ PD=4.84U
* device instance $265 r0 *1 0.67,11.28 nfet
M$265 IBIAS IBIAS OUTP|VSS vsubs nfet L=0.5U W=2U AS=0.84P AD=0.42P PS=4.84U
+ PD=2.42U
* device instance $266 r0 *1 1.59,11.28 nfet
M$266 OUTP|VSS IBIAS IBIAS vsubs nfet L=0.5U W=2U AS=0.42P AD=0.42P PS=2.42U
+ PD=2.42U
* device instance $267 r0 *1 2.51,11.28 nfet
M$267 IBIAS IBIAS OUTP|VSS vsubs nfet L=0.5U W=2U AS=0.42P AD=0.42P PS=2.42U
+ PD=2.42U
* device instance $268 r0 *1 3.43,11.28 nfet
M$268 OUTP|VSS IBIAS IBIAS vsubs nfet L=0.5U W=2U AS=0.42P AD=0.42P PS=2.42U
+ PD=2.42U
* device instance $269 r0 *1 4.35,11.28 nfet
M$269 IBIAS IBIAS OUTP|VSS vsubs nfet L=0.5U W=2U AS=0.42P AD=0.42P PS=2.42U
+ PD=2.42U
* device instance $270 r0 *1 5.27,11.28 nfet
M$270 OUTP|VSS IBIAS IBIAS vsubs nfet L=0.5U W=2U AS=0.42P AD=0.42P PS=2.42U
+ PD=2.42U
* device instance $271 r0 *1 6.19,11.28 nfet
M$271 IBIAS IBIAS OUTP|VSS vsubs nfet L=0.5U W=2U AS=0.42P AD=0.42P PS=2.42U
+ PD=2.42U
* device instance $272 r0 *1 7.11,11.28 nfet
M$272 OUTP|VSS IBIAS IBIAS vsubs nfet L=0.5U W=2U AS=0.42P AD=0.42P PS=2.42U
+ PD=2.42U
* device instance $273 r0 *1 8.03,11.28 nfet
M$273 IBIAS IBIAS OUTP|VSS vsubs nfet L=0.5U W=2U AS=0.42P AD=0.42P PS=2.42U
+ PD=2.42U
* device instance $274 r0 *1 8.95,11.28 nfet
M$274 OUTP|VSS IBIAS IBIAS vsubs nfet L=0.5U W=2U AS=0.42P AD=0.84P PS=2.42U
+ PD=4.84U
* device instance $275 r0 *1 189.98,11.28 nfet
M$275 OUTN INN TAIL vsubs nfet L=0.28U W=2U AS=0.84P AD=0.42P PS=4.84U PD=2.42U
* device instance $276 r0 *1 190.68,11.28 nfet
M$276 TAIL INN OUTN vsubs nfet L=0.28U W=2U AS=0.42P AD=0.42P PS=2.42U PD=2.42U
* device instance $277 r0 *1 191.38,11.28 nfet
M$277 OUTN INN TAIL vsubs nfet L=0.28U W=2U AS=0.42P AD=0.42P PS=2.42U PD=2.42U
* device instance $278 r0 *1 192.08,11.28 nfet
M$278 TAIL INN OUTN vsubs nfet L=0.28U W=2U AS=0.42P AD=0.42P PS=2.42U PD=2.42U
* device instance $279 r0 *1 192.78,11.28 nfet
M$279 OUTN INN TAIL vsubs nfet L=0.28U W=2U AS=0.42P AD=0.42P PS=2.42U PD=2.42U
* device instance $280 r0 *1 193.48,11.28 nfet
M$280 TAIL INN OUTN vsubs nfet L=0.28U W=2U AS=0.42P AD=0.42P PS=2.42U PD=2.42U
* device instance $281 r0 *1 194.18,11.28 nfet
M$281 OUTN INN TAIL vsubs nfet L=0.28U W=2U AS=0.42P AD=0.42P PS=2.42U PD=2.42U
* device instance $282 r0 *1 194.88,11.28 nfet
M$282 TAIL INN OUTN vsubs nfet L=0.28U W=2U AS=0.42P AD=0.42P PS=2.42U PD=2.42U
* device instance $283 r0 *1 195.58,11.28 nfet
M$283 OUTN INN TAIL vsubs nfet L=0.28U W=2U AS=0.42P AD=0.42P PS=2.42U PD=2.42U
* device instance $284 r0 *1 196.28,11.28 nfet
M$284 TAIL INN OUTN vsubs nfet L=0.28U W=2U AS=0.42P AD=0.42P PS=2.42U PD=2.42U
* device instance $285 r0 *1 196.98,11.28 nfet
M$285 OUTN INN TAIL vsubs nfet L=0.28U W=2U AS=0.42P AD=0.42P PS=2.42U PD=2.42U
* device instance $286 r0 *1 197.68,11.28 nfet
M$286 TAIL INN OUTN vsubs nfet L=0.28U W=2U AS=0.42P AD=0.42P PS=2.42U PD=2.42U
* device instance $287 r0 *1 198.38,11.28 nfet
M$287 OUTN INN TAIL vsubs nfet L=0.28U W=2U AS=0.42P AD=0.42P PS=2.42U PD=2.42U
* device instance $288 r0 *1 199.08,11.28 nfet
M$288 TAIL INN OUTN vsubs nfet L=0.28U W=2U AS=0.42P AD=0.42P PS=2.42U PD=2.42U
* device instance $289 r0 *1 199.78,11.28 nfet
M$289 OUTN INN TAIL vsubs nfet L=0.28U W=2U AS=0.42P AD=0.42P PS=2.42U PD=2.42U
* device instance $290 r0 *1 200.48,11.28 nfet
M$290 TAIL INN OUTN vsubs nfet L=0.28U W=2U AS=0.42P AD=0.42P PS=2.42U PD=2.42U
* device instance $291 r0 *1 201.18,11.28 nfet
M$291 OUTN INN TAIL vsubs nfet L=0.28U W=2U AS=0.42P AD=0.42P PS=2.42U PD=2.42U
* device instance $292 r0 *1 201.88,11.28 nfet
M$292 TAIL INN OUTN vsubs nfet L=0.28U W=2U AS=0.42P AD=0.42P PS=2.42U PD=2.42U
* device instance $293 r0 *1 202.58,11.28 nfet
M$293 OUTN INN TAIL vsubs nfet L=0.28U W=2U AS=0.42P AD=0.42P PS=2.42U PD=2.42U
* device instance $294 r0 *1 203.28,11.28 nfet
M$294 TAIL INN OUTN vsubs nfet L=0.28U W=2U AS=0.42P AD=0.42P PS=2.42U PD=2.42U
* device instance $295 r0 *1 203.98,11.28 nfet
M$295 OUTN INN TAIL vsubs nfet L=0.28U W=2U AS=0.42P AD=0.42P PS=2.42U PD=2.42U
* device instance $296 r0 *1 204.68,11.28 nfet
M$296 TAIL INN OUTN vsubs nfet L=0.28U W=2U AS=0.42P AD=0.42P PS=2.42U PD=2.42U
* device instance $297 r0 *1 205.38,11.28 nfet
M$297 OUTN INN TAIL vsubs nfet L=0.28U W=2U AS=0.42P AD=0.42P PS=2.42U PD=2.42U
* device instance $298 r0 *1 206.08,11.28 nfet
M$298 TAIL INN OUTN vsubs nfet L=0.28U W=2U AS=0.42P AD=0.42P PS=2.42U PD=2.42U
* device instance $299 r0 *1 206.78,11.28 nfet
M$299 OUTN INN TAIL vsubs nfet L=0.28U W=2U AS=0.42P AD=0.42P PS=2.42U PD=2.42U
* device instance $300 r0 *1 207.48,11.28 nfet
M$300 TAIL INN OUTN vsubs nfet L=0.28U W=2U AS=0.42P AD=0.42P PS=2.42U PD=2.42U
* device instance $301 r0 *1 208.18,11.28 nfet
M$301 OUTN INN TAIL vsubs nfet L=0.28U W=2U AS=0.42P AD=0.42P PS=2.42U PD=2.42U
* device instance $302 r0 *1 208.88,11.28 nfet
M$302 TAIL INN OUTN vsubs nfet L=0.28U W=2U AS=0.42P AD=0.42P PS=2.42U PD=2.42U
* device instance $303 r0 *1 209.58,11.28 nfet
M$303 OUTN INN TAIL vsubs nfet L=0.28U W=2U AS=0.42P AD=0.42P PS=2.42U PD=2.42U
* device instance $304 r0 *1 210.28,11.28 nfet
M$304 TAIL INN OUTN vsubs nfet L=0.28U W=2U AS=0.42P AD=0.42P PS=2.42U PD=2.42U
* device instance $305 r0 *1 210.98,11.28 nfet
M$305 OUTN INN TAIL vsubs nfet L=0.28U W=2U AS=0.42P AD=0.42P PS=2.42U PD=2.42U
* device instance $306 r0 *1 211.68,11.28 nfet
M$306 TAIL INN OUTN vsubs nfet L=0.28U W=2U AS=0.42P AD=0.42P PS=2.42U PD=2.42U
* device instance $307 r0 *1 212.38,11.28 nfet
M$307 OUTN INN TAIL vsubs nfet L=0.28U W=2U AS=0.42P AD=0.42P PS=2.42U PD=2.42U
* device instance $308 r0 *1 213.08,11.28 nfet
M$308 TAIL INN OUTN vsubs nfet L=0.28U W=2U AS=0.42P AD=0.42P PS=2.42U PD=2.42U
* device instance $309 r0 *1 213.78,11.28 nfet
M$309 OUTN INN TAIL vsubs nfet L=0.28U W=2U AS=0.42P AD=0.42P PS=2.42U PD=2.42U
* device instance $310 r0 *1 214.48,11.28 nfet
M$310 TAIL INN OUTN vsubs nfet L=0.28U W=2U AS=0.42P AD=0.42P PS=2.42U PD=2.42U
* device instance $311 r0 *1 215.18,11.28 nfet
M$311 OUTN INN TAIL vsubs nfet L=0.28U W=2U AS=0.42P AD=0.42P PS=2.42U PD=2.42U
* device instance $312 r0 *1 215.88,11.28 nfet
M$312 TAIL INN OUTN vsubs nfet L=0.28U W=2U AS=0.42P AD=0.42P PS=2.42U PD=2.42U
* device instance $313 r0 *1 216.58,11.28 nfet
M$313 OUTN INN TAIL vsubs nfet L=0.28U W=2U AS=0.42P AD=0.42P PS=2.42U PD=2.42U
* device instance $314 r0 *1 217.28,11.28 nfet
M$314 TAIL INN OUTN vsubs nfet L=0.28U W=2U AS=0.42P AD=0.42P PS=2.42U PD=2.42U
* device instance $315 r0 *1 217.98,11.28 nfet
M$315 OUTN INN TAIL vsubs nfet L=0.28U W=2U AS=0.42P AD=0.42P PS=2.42U PD=2.42U
* device instance $316 r0 *1 218.68,11.28 nfet
M$316 TAIL INN OUTN vsubs nfet L=0.28U W=2U AS=0.42P AD=0.42P PS=2.42U PD=2.42U
* device instance $317 r0 *1 219.38,11.28 nfet
M$317 OUTN INN TAIL vsubs nfet L=0.28U W=2U AS=0.42P AD=0.42P PS=2.42U PD=2.42U
* device instance $318 r0 *1 220.08,11.28 nfet
M$318 TAIL INN OUTN vsubs nfet L=0.28U W=2U AS=0.42P AD=0.42P PS=2.42U PD=2.42U
* device instance $319 r0 *1 220.78,11.28 nfet
M$319 OUTN INN TAIL vsubs nfet L=0.28U W=2U AS=0.42P AD=0.42P PS=2.42U PD=2.42U
* device instance $320 r0 *1 221.48,11.28 nfet
M$320 TAIL INN OUTN vsubs nfet L=0.28U W=2U AS=0.42P AD=0.42P PS=2.42U PD=2.42U
* device instance $321 r0 *1 222.18,11.28 nfet
M$321 OUTN INN TAIL vsubs nfet L=0.28U W=2U AS=0.42P AD=0.42P PS=2.42U PD=2.42U
* device instance $322 r0 *1 222.88,11.28 nfet
M$322 TAIL INN OUTN vsubs nfet L=0.28U W=2U AS=0.42P AD=0.42P PS=2.42U PD=2.42U
* device instance $323 r0 *1 223.58,11.28 nfet
M$323 OUTN INN TAIL vsubs nfet L=0.28U W=2U AS=0.42P AD=0.42P PS=2.42U PD=2.42U
* device instance $324 r0 *1 224.28,11.28 nfet
M$324 TAIL INN OUTN vsubs nfet L=0.28U W=2U AS=0.42P AD=0.42P PS=2.42U PD=2.42U
* device instance $325 r0 *1 224.98,11.28 nfet
M$325 OUTN INN TAIL vsubs nfet L=0.28U W=2U AS=0.42P AD=0.42P PS=2.42U PD=2.42U
* device instance $326 r0 *1 225.68,11.28 nfet
M$326 TAIL INN OUTN vsubs nfet L=0.28U W=2U AS=0.42P AD=0.42P PS=2.42U PD=2.42U
* device instance $327 r0 *1 226.38,11.28 nfet
M$327 OUTN INN TAIL vsubs nfet L=0.28U W=2U AS=0.42P AD=0.42P PS=2.42U PD=2.42U
* device instance $328 r0 *1 227.08,11.28 nfet
M$328 TAIL INN OUTN vsubs nfet L=0.28U W=2U AS=0.42P AD=0.42P PS=2.42U PD=2.42U
* device instance $329 r0 *1 227.78,11.28 nfet
M$329 OUTN INN TAIL vsubs nfet L=0.28U W=2U AS=0.42P AD=0.42P PS=2.42U PD=2.42U
* device instance $330 r0 *1 228.48,11.28 nfet
M$330 TAIL INN OUTN vsubs nfet L=0.28U W=2U AS=0.42P AD=0.42P PS=2.42U PD=2.42U
* device instance $331 r0 *1 229.18,11.28 nfet
M$331 OUTN INN TAIL vsubs nfet L=0.28U W=2U AS=0.42P AD=0.42P PS=2.42U PD=2.42U
* device instance $332 r0 *1 229.88,11.28 nfet
M$332 TAIL INN OUTN vsubs nfet L=0.28U W=2U AS=0.42P AD=0.42P PS=2.42U PD=2.42U
* device instance $333 r0 *1 230.58,11.28 nfet
M$333 OUTN INN TAIL vsubs nfet L=0.28U W=2U AS=0.42P AD=0.42P PS=2.42U PD=2.42U
* device instance $334 r0 *1 231.28,11.28 nfet
M$334 TAIL INN OUTN vsubs nfet L=0.28U W=2U AS=0.42P AD=0.42P PS=2.42U PD=2.42U
* device instance $335 r0 *1 231.98,11.28 nfet
M$335 OUTN INN TAIL vsubs nfet L=0.28U W=2U AS=0.42P AD=0.42P PS=2.42U PD=2.42U
* device instance $336 r0 *1 232.68,11.28 nfet
M$336 TAIL INN OUTN vsubs nfet L=0.28U W=2U AS=0.42P AD=0.42P PS=2.42U PD=2.42U
* device instance $337 r0 *1 233.38,11.28 nfet
M$337 OUTN INN TAIL vsubs nfet L=0.28U W=2U AS=0.42P AD=0.42P PS=2.42U PD=2.42U
* device instance $338 r0 *1 234.08,11.28 nfet
M$338 TAIL INN OUTN vsubs nfet L=0.28U W=2U AS=0.42P AD=0.84P PS=2.42U PD=4.84U
.ENDS cml_driver_core_shorted
