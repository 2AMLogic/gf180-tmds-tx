* extracted by klt extract --deck gf180mcu

* cell gf180_tmds_pad_min
* pin PAD
* pin VSS
* pin vsubs
.SUBCKT gf180_tmds_pad_min PAD VSS vsubs
* device instance $1 r0 *1 1.2,1 nfet
M$1 PAD VSS VSS vsubs nfet L=0.4U W=2U AS=2P AD=2P PS=6U PD=6U
.ENDS gf180_tmds_pad_min
