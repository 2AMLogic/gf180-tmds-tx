* extracted by klt extract --deck gf180mcu

* cell tmds_encoder
* pin VDD
* pin VSS
* pin clk
* pin ctrl[0]
* pin ctrl[1]
* pin data[0]
* pin data[1]
* pin data[2]
* pin data[3]
* pin data[4]
* pin data[5]
* pin data[6]
* pin data[7]
* pin de
* pin rst
* pin tmds[0]
* pin tmds[1]
* pin tmds[2]
* pin tmds[3]
* pin tmds[4]
* pin tmds[5]
* pin tmds[6]
* pin tmds[7]
* pin tmds[8]
* pin tmds[9]
.SUBCKT tmds_encoder VDD VSS clk ctrl[0] ctrl[1] data[0] data[1] data[2]
+ data[3] data[4] data[5] data[6] data[7] de rst tmds[0] tmds[1] tmds[2]
+ tmds[3] tmds[4] tmds[5] tmds[6] tmds[7] tmds[8] tmds[9]
* cell instance gf180mcu_fd_sc_mcu9t5v0__and2_1_0 r0 *1 0,0
Xgf180mcu_fd_sc_mcu9t5v0__and2_1_0 \$487 \$605 VDD VSS \$675
+ gf180mcu_fd_sc_mcu9t5v0__and2_1
* cell instance gf180mcu_fd_sc_mcu9t5v0__and2_1_1 r0 *1 0,0
Xgf180mcu_fd_sc_mcu9t5v0__and2_1_1 \$256 \$47 VDD VSS \$278
+ gf180mcu_fd_sc_mcu9t5v0__and2_1
* cell instance gf180mcu_fd_sc_mcu9t5v0__and2_1_2 r0 *1 0,0
Xgf180mcu_fd_sc_mcu9t5v0__and2_1_2 \$47 \$143 VDD VSS \$269
+ gf180mcu_fd_sc_mcu9t5v0__and2_1
* cell instance gf180mcu_fd_sc_mcu9t5v0__and2_1_3 r0 *1 0,0
Xgf180mcu_fd_sc_mcu9t5v0__and2_1_3 \$425 \$743 VDD VSS \$749
+ gf180mcu_fd_sc_mcu9t5v0__and2_1
* cell instance gf180mcu_fd_sc_mcu9t5v0__and2_1_4 r0 *1 0,0
Xgf180mcu_fd_sc_mcu9t5v0__and2_1_4 \$364 \$343 VDD VSS \$566
+ gf180mcu_fd_sc_mcu9t5v0__and2_1
* cell instance gf180mcu_fd_sc_mcu9t5v0__and2_1_5 r0 *1 0,0
Xgf180mcu_fd_sc_mcu9t5v0__and2_1_5 \$551 \$550 VDD VSS \$500
+ gf180mcu_fd_sc_mcu9t5v0__and2_1
* cell instance gf180mcu_fd_sc_mcu9t5v0__and2_1_6 r0 *1 0,0
Xgf180mcu_fd_sc_mcu9t5v0__and2_1_6 \$47 \$48 VDD VSS \$55
+ gf180mcu_fd_sc_mcu9t5v0__and2_1
* cell instance gf180mcu_fd_sc_mcu9t5v0__and2_1_7 r0 *1 0,0
Xgf180mcu_fd_sc_mcu9t5v0__and2_1_7 \$47 \$49 VDD VSS \$26
+ gf180mcu_fd_sc_mcu9t5v0__and2_1
* cell instance gf180mcu_fd_sc_mcu9t5v0__and2_1_8 r0 *1 0,0
Xgf180mcu_fd_sc_mcu9t5v0__and2_1_8 \$342 \$740 VDD VSS \$827
+ gf180mcu_fd_sc_mcu9t5v0__and2_1
* cell instance gf180mcu_fd_sc_mcu9t5v0__and2_1_9 r0 *1 0,0
Xgf180mcu_fd_sc_mcu9t5v0__and2_1_9 \$47 \$31 VDD VSS \$107
+ gf180mcu_fd_sc_mcu9t5v0__and2_1
* cell instance gf180mcu_fd_sc_mcu9t5v0__and2_1_10 r0 *1 0,0
Xgf180mcu_fd_sc_mcu9t5v0__and2_1_10 \$512 \$260 VDD VSS \$370
+ gf180mcu_fd_sc_mcu9t5v0__and2_1
* cell instance gf180mcu_fd_sc_mcu9t5v0__and2_1_11 r0 *1 0,0
Xgf180mcu_fd_sc_mcu9t5v0__and2_1_11 \$506 \$504 VDD VSS \$602
+ gf180mcu_fd_sc_mcu9t5v0__and2_1
* cell instance gf180mcu_fd_sc_mcu9t5v0__and2_1_12 r0 *1 0,0
Xgf180mcu_fd_sc_mcu9t5v0__and2_1_12 \$259 \$260 VDD VSS \$272
+ gf180mcu_fd_sc_mcu9t5v0__and2_1
* cell instance gf180mcu_fd_sc_mcu9t5v0__and3_1_0 r0 *1 0,0
Xgf180mcu_fd_sc_mcu9t5v0__and3_1_0 \$564 \$303 \$566 VDD VSS \$614
+ gf180mcu_fd_sc_mcu9t5v0__and3_1
* cell instance gf180mcu_fd_sc_mcu9t5v0__and3_1_1 r0 *1 0,0
Xgf180mcu_fd_sc_mcu9t5v0__and3_1_1 \$742 \$711 \$778 VDD VSS \$674
+ gf180mcu_fd_sc_mcu9t5v0__and3_1
* cell instance gf180mcu_fd_sc_mcu9t5v0__aoi211_1_0 r0 *1 0,0
Xgf180mcu_fd_sc_mcu9t5v0__aoi211_1_0 \$51 \$110 \$181 \$222 VDD VSS \$310
+ gf180mcu_fd_sc_mcu9t5v0__aoi211_1
* cell instance gf180mcu_fd_sc_mcu9t5v0__aoi211_1_1 r0 *1 0,0
Xgf180mcu_fd_sc_mcu9t5v0__aoi211_1_1 \$467 \$534 \$468 \$208 VDD VSS \$466
+ gf180mcu_fd_sc_mcu9t5v0__aoi211_1
* cell instance gf180mcu_fd_sc_mcu9t5v0__aoi211_1_2 r0 *1 0,0
Xgf180mcu_fd_sc_mcu9t5v0__aoi211_1_2 \$506 \$592 \$573 \$208 VDD VSS \$572
+ gf180mcu_fd_sc_mcu9t5v0__aoi211_1
* cell instance gf180mcu_fd_sc_mcu9t5v0__aoi211_1_3 r0 *1 0,0
Xgf180mcu_fd_sc_mcu9t5v0__aoi211_1_3 \$212 \$223 \$297 \$213 VDD VSS \$211
+ gf180mcu_fd_sc_mcu9t5v0__aoi211_1
* cell instance gf180mcu_fd_sc_mcu9t5v0__aoi211_1_4 r0 *1 0,0
Xgf180mcu_fd_sc_mcu9t5v0__aoi211_1_4 \$467 \$251 \$214 \$208 VDD VSS \$252
+ gf180mcu_fd_sc_mcu9t5v0__aoi211_1
* cell instance gf180mcu_fd_sc_mcu9t5v0__aoi211_1_5 r0 *1 0,0
Xgf180mcu_fd_sc_mcu9t5v0__aoi211_1_5 \$764 \$787 \$799 \$842 VDD VSS \$715
+ gf180mcu_fd_sc_mcu9t5v0__aoi211_1
* cell instance gf180mcu_fd_sc_mcu9t5v0__aoi21_1_0 r0 *1 0,0
Xgf180mcu_fd_sc_mcu9t5v0__aoi21_1_0 \$98 \$363 \$347 VDD VSS \$559
+ gf180mcu_fd_sc_mcu9t5v0__aoi21_1
* cell instance gf180mcu_fd_sc_mcu9t5v0__aoi21_1_1 r0 *1 0,0
Xgf180mcu_fd_sc_mcu9t5v0__aoi21_1_1 \$145 \$363 \$349 VDD VSS \$375
+ gf180mcu_fd_sc_mcu9t5v0__aoi21_1
* cell instance gf180mcu_fd_sc_mcu9t5v0__aoi21_1_2 r0 *1 0,0
Xgf180mcu_fd_sc_mcu9t5v0__aoi21_1_2 \$637 \$698 \$665 VDD VSS \$699
+ gf180mcu_fd_sc_mcu9t5v0__aoi21_1
* cell instance gf180mcu_fd_sc_mcu9t5v0__aoi21_1_3 r0 *1 0,0
Xgf180mcu_fd_sc_mcu9t5v0__aoi21_1_3 \$612 \$653 \$614 VDD VSS \$665
+ gf180mcu_fd_sc_mcu9t5v0__aoi21_1
* cell instance gf180mcu_fd_sc_mcu9t5v0__aoi21_1_4 r0 *1 0,0
Xgf180mcu_fd_sc_mcu9t5v0__aoi21_1_4 \$303 \$581 \$566 VDD VSS \$653
+ gf180mcu_fd_sc_mcu9t5v0__aoi21_1
* cell instance gf180mcu_fd_sc_mcu9t5v0__aoi21_1_5 r0 *1 0,0
Xgf180mcu_fd_sc_mcu9t5v0__aoi21_1_5 \$257 \$569 \$258 VDD VSS \$397
+ gf180mcu_fd_sc_mcu9t5v0__aoi21_1
* cell instance gf180mcu_fd_sc_mcu9t5v0__aoi21_1_6 r0 *1 0,0
Xgf180mcu_fd_sc_mcu9t5v0__aoi21_1_6 \$257 \$450 \$258 VDD VSS \$439
+ gf180mcu_fd_sc_mcu9t5v0__aoi21_1
* cell instance gf180mcu_fd_sc_mcu9t5v0__aoi21_1_7 r0 *1 0,0
Xgf180mcu_fd_sc_mcu9t5v0__aoi21_1_7 \$257 \$344 \$258 VDD VSS \$325
+ gf180mcu_fd_sc_mcu9t5v0__aoi21_1
* cell instance gf180mcu_fd_sc_mcu9t5v0__aoi21_1_8 r0 *1 0,0
Xgf180mcu_fd_sc_mcu9t5v0__aoi21_1_8 \$257 \$232 \$258 VDD VSS \$248
+ gf180mcu_fd_sc_mcu9t5v0__aoi21_1
* cell instance gf180mcu_fd_sc_mcu9t5v0__aoi21_1_9 r0 *1 0,0
Xgf180mcu_fd_sc_mcu9t5v0__aoi21_1_9 \$257 \$529 \$258 VDD VSS \$465
+ gf180mcu_fd_sc_mcu9t5v0__aoi21_1
* cell instance gf180mcu_fd_sc_mcu9t5v0__aoi21_1_10 r0 *1 0,0
Xgf180mcu_fd_sc_mcu9t5v0__aoi21_1_10 \$737 \$726 \$551 VDD VSS \$739
+ gf180mcu_fd_sc_mcu9t5v0__aoi21_1
* cell instance gf180mcu_fd_sc_mcu9t5v0__aoi21_1_11 r0 *1 0,0
Xgf180mcu_fd_sc_mcu9t5v0__aoi21_1_11 \$501 \$498 \$500 VDD VSS \$223
+ gf180mcu_fd_sc_mcu9t5v0__aoi21_1
* cell instance gf180mcu_fd_sc_mcu9t5v0__aoi21_1_12 r0 *1 0,0
Xgf180mcu_fd_sc_mcu9t5v0__aoi21_1_12 \$835 \$763 \$825 VDD VSS \$834
+ gf180mcu_fd_sc_mcu9t5v0__aoi21_1
* cell instance gf180mcu_fd_sc_mcu9t5v0__aoi21_1_13 r0 *1 0,0
Xgf180mcu_fd_sc_mcu9t5v0__aoi21_1_13 \$504 \$757 \$467 VDD VSS \$457
+ gf180mcu_fd_sc_mcu9t5v0__aoi21_1
* cell instance gf180mcu_fd_sc_mcu9t5v0__aoi21_1_14 r0 *1 0,0
Xgf180mcu_fd_sc_mcu9t5v0__aoi21_1_14 \$838 \$728 \$827 VDD VSS \$837
+ gf180mcu_fd_sc_mcu9t5v0__aoi21_1
* cell instance gf180mcu_fd_sc_mcu9t5v0__aoi21_1_15 r0 *1 0,0
Xgf180mcu_fd_sc_mcu9t5v0__aoi21_1_15 \$212 \$223 \$297 VDD VSS \$296
+ gf180mcu_fd_sc_mcu9t5v0__aoi21_1
* cell instance gf180mcu_fd_sc_mcu9t5v0__aoi21_1_16 r0 *1 0,0
Xgf180mcu_fd_sc_mcu9t5v0__aoi21_1_16 \$814 \$670 \$630 VDD VSS \$671
+ gf180mcu_fd_sc_mcu9t5v0__aoi21_1
* cell instance gf180mcu_fd_sc_mcu9t5v0__aoi21_1_17 r0 *1 0,0
Xgf180mcu_fd_sc_mcu9t5v0__aoi21_1_17 \$429 \$392 \$208 VDD VSS \$418
+ gf180mcu_fd_sc_mcu9t5v0__aoi21_1
* cell instance gf180mcu_fd_sc_mcu9t5v0__aoi21_1_18 r0 *1 0,0
Xgf180mcu_fd_sc_mcu9t5v0__aoi21_1_18 \$262 \$261 \$208 VDD VSS \$215
+ gf180mcu_fd_sc_mcu9t5v0__aoi21_1
* cell instance gf180mcu_fd_sc_mcu9t5v0__aoi21_1_19 r0 *1 0,0
Xgf180mcu_fd_sc_mcu9t5v0__aoi21_1_19 \$630 \$508 \$467 VDD VSS \$459
+ gf180mcu_fd_sc_mcu9t5v0__aoi21_1
* cell instance gf180mcu_fd_sc_mcu9t5v0__aoi21_1_20 r0 *1 0,0
Xgf180mcu_fd_sc_mcu9t5v0__aoi21_1_20 \$628 \$621 \$602 VDD VSS \$615
+ gf180mcu_fd_sc_mcu9t5v0__aoi21_1
* cell instance gf180mcu_fd_sc_mcu9t5v0__aoi21_1_21 r0 *1 0,0
Xgf180mcu_fd_sc_mcu9t5v0__aoi21_1_21 \$264 \$263 \$362 VDD VSS \$361
+ gf180mcu_fd_sc_mcu9t5v0__aoi21_1
* cell instance gf180mcu_fd_sc_mcu9t5v0__aoi21_1_22 r0 *1 0,0
Xgf180mcu_fd_sc_mcu9t5v0__aoi21_1_22 \$742 \$778 \$711 VDD VSS \$673
+ gf180mcu_fd_sc_mcu9t5v0__aoi21_1
* cell instance gf180mcu_fd_sc_mcu9t5v0__aoi21_1_23 r0 *1 0,0
Xgf180mcu_fd_sc_mcu9t5v0__aoi21_1_23 \$512 \$553 \$674 VDD VSS \$616
+ gf180mcu_fd_sc_mcu9t5v0__aoi21_1
* cell instance gf180mcu_fd_sc_mcu9t5v0__aoi221_2_0 r0 *1 0,0
Xgf180mcu_fd_sc_mcu9t5v0__aoi221_2_0 \$467 \$398 \$459 \$454 \$208 VDD VSS
+ \$458 gf180mcu_fd_sc_mcu9t5v0__aoi221_2
* cell instance gf180mcu_fd_sc_mcu9t5v0__aoi22_1_0 r0 *1 0,0
Xgf180mcu_fd_sc_mcu9t5v0__aoi22_1_0 data[1] data[0] data[3] \$143 VDD VSS \$99
+ gf180mcu_fd_sc_mcu9t5v0__aoi22_1
* cell instance gf180mcu_fd_sc_mcu9t5v0__aoi22_1_1 r0 *1 0,0
Xgf180mcu_fd_sc_mcu9t5v0__aoi22_1_1 \$637 \$698 \$653 \$612 VDD VSS \$689
+ gf180mcu_fd_sc_mcu9t5v0__aoi22_1
* cell instance gf180mcu_fd_sc_mcu9t5v0__aoi22_1_2 r0 *1 0,0
Xgf180mcu_fd_sc_mcu9t5v0__aoi22_1_2 \$630 \$625 \$773 \$504 VDD VSS \$502
+ gf180mcu_fd_sc_mcu9t5v0__aoi22_1
* cell instance gf180mcu_fd_sc_mcu9t5v0__aoi22_1_3 r0 *1 0,0
Xgf180mcu_fd_sc_mcu9t5v0__aoi22_1_3 \$456 \$457 \$443 \$467 VDD VSS \$424
+ gf180mcu_fd_sc_mcu9t5v0__aoi22_1
* cell instance gf180mcu_fd_sc_mcu9t5v0__aoi22_1_4 r0 *1 0,0
Xgf180mcu_fd_sc_mcu9t5v0__aoi22_1_4 \$630 \$619 \$632 \$504 VDD VSS \$224
+ gf180mcu_fd_sc_mcu9t5v0__aoi22_1
* cell instance gf180mcu_fd_sc_mcu9t5v0__aoi22_4_0 r0 *1 0,0
Xgf180mcu_fd_sc_mcu9t5v0__aoi22_4_0 \$765 \$702 \$780 \$725 VDD VSS \$790
+ gf180mcu_fd_sc_mcu9t5v0__aoi22_4
* cell instance gf180mcu_fd_sc_mcu9t5v0__buf_1_0 r0 *1 0,0
Xgf180mcu_fd_sc_mcu9t5v0__buf_1_0 \$494 VDD VSS \$510
+ gf180mcu_fd_sc_mcu9t5v0__buf_1
* cell instance gf180mcu_fd_sc_mcu9t5v0__buf_1_1 r0 *1 0,0
Xgf180mcu_fd_sc_mcu9t5v0__buf_1_1 \$266 VDD VSS \$47
+ gf180mcu_fd_sc_mcu9t5v0__buf_1
* cell instance gf180mcu_fd_sc_mcu9t5v0__buf_1_2 r0 *1 0,0
Xgf180mcu_fd_sc_mcu9t5v0__buf_1_2 \$150 VDD VSS \$257
+ gf180mcu_fd_sc_mcu9t5v0__buf_1
* cell instance gf180mcu_fd_sc_mcu9t5v0__buf_2_0 r0 *1 0,0
Xgf180mcu_fd_sc_mcu9t5v0__buf_2_0 \$102 VDD VSS \$259
+ gf180mcu_fd_sc_mcu9t5v0__buf_2
* cell instance gf180mcu_fd_sc_mcu9t5v0__clkbuf_1_0 r0 *1 0,0
Xgf180mcu_fd_sc_mcu9t5v0__clkbuf_1_0 \$210 VDD VSS \$449
+ gf180mcu_fd_sc_mcu9t5v0__clkbuf_1
* cell instance gf180mcu_fd_sc_mcu9t5v0__clkbuf_1_1 r0 *1 0,0
Xgf180mcu_fd_sc_mcu9t5v0__clkbuf_1_1 \$210 VDD VSS \$165
+ gf180mcu_fd_sc_mcu9t5v0__clkbuf_1
* cell instance gf180mcu_fd_sc_mcu9t5v0__clkbuf_1_2 r0 *1 0,0
Xgf180mcu_fd_sc_mcu9t5v0__clkbuf_1_2 clk VDD VSS \$210
+ gf180mcu_fd_sc_mcu9t5v0__clkbuf_1
* cell instance gf180mcu_fd_sc_mcu9t5v0__clkbuf_1_3 r0 *1 0,0
Xgf180mcu_fd_sc_mcu9t5v0__clkbuf_1_3 \$210 VDD VSS \$147
+ gf180mcu_fd_sc_mcu9t5v0__clkbuf_1
* cell instance gf180mcu_fd_sc_mcu9t5v0__clkbuf_1_4 r0 *1 0,0
Xgf180mcu_fd_sc_mcu9t5v0__clkbuf_1_4 \$210 VDD VSS \$385
+ gf180mcu_fd_sc_mcu9t5v0__clkbuf_1
* cell instance gf180mcu_fd_sc_mcu9t5v0__clkinv_1_0 r0 *1 0,0
Xgf180mcu_fd_sc_mcu9t5v0__clkinv_1_0 \$103 VDD VSS \$77
+ gf180mcu_fd_sc_mcu9t5v0__clkinv_1
* cell instance gf180mcu_fd_sc_mcu9t5v0__clkinv_1_1 r0 *1 0,0
Xgf180mcu_fd_sc_mcu9t5v0__clkinv_1_1 \$188 VDD VSS \$309
+ gf180mcu_fd_sc_mcu9t5v0__clkinv_1
* cell instance gf180mcu_fd_sc_mcu9t5v0__clkinv_1_2 r0 *1 0,0
Xgf180mcu_fd_sc_mcu9t5v0__clkinv_1_2 \$156 VDD VSS \$155
+ gf180mcu_fd_sc_mcu9t5v0__clkinv_1
* cell instance gf180mcu_fd_sc_mcu9t5v0__clkinv_1_3 r0 *1 0,0
Xgf180mcu_fd_sc_mcu9t5v0__clkinv_1_3 \$275 VDD VSS \$255
+ gf180mcu_fd_sc_mcu9t5v0__clkinv_1
* cell instance gf180mcu_fd_sc_mcu9t5v0__clkinv_1_4 r0 *1 0,0
Xgf180mcu_fd_sc_mcu9t5v0__clkinv_1_4 \$486 VDD VSS \$681
+ gf180mcu_fd_sc_mcu9t5v0__clkinv_1
* cell instance gf180mcu_fd_sc_mcu9t5v0__clkinv_1_5 r0 *1 0,0
Xgf180mcu_fd_sc_mcu9t5v0__clkinv_1_5 \$108 VDD VSS \$98
+ gf180mcu_fd_sc_mcu9t5v0__clkinv_1
* cell instance gf180mcu_fd_sc_mcu9t5v0__clkinv_1_6 r0 *1 0,0
Xgf180mcu_fd_sc_mcu9t5v0__clkinv_1_6 \$449 VDD VSS \$462
+ gf180mcu_fd_sc_mcu9t5v0__clkinv_1
* cell instance gf180mcu_fd_sc_mcu9t5v0__clkinv_1_7 r0 *1 0,0
Xgf180mcu_fd_sc_mcu9t5v0__clkinv_1_7 \$525 VDD VSS \$526
+ gf180mcu_fd_sc_mcu9t5v0__clkinv_1
* cell instance gf180mcu_fd_sc_mcu9t5v0__clkinv_1_8 r0 *1 0,0
Xgf180mcu_fd_sc_mcu9t5v0__clkinv_1_8 data[5] VDD VSS \$105
+ gf180mcu_fd_sc_mcu9t5v0__clkinv_1
* cell instance gf180mcu_fd_sc_mcu9t5v0__clkinv_1_9 r0 *1 0,0
Xgf180mcu_fd_sc_mcu9t5v0__clkinv_1_9 \$623 VDD VSS \$501
+ gf180mcu_fd_sc_mcu9t5v0__clkinv_1
* cell instance gf180mcu_fd_sc_mcu9t5v0__clkinv_1_10 r0 *1 0,0
Xgf180mcu_fd_sc_mcu9t5v0__clkinv_1_10 \$655 VDD VSS \$598
+ gf180mcu_fd_sc_mcu9t5v0__clkinv_1
* cell instance gf180mcu_fd_sc_mcu9t5v0__clkinv_1_11 r0 *1 0,0
Xgf180mcu_fd_sc_mcu9t5v0__clkinv_1_11 \$622 VDD VSS \$718
+ gf180mcu_fd_sc_mcu9t5v0__clkinv_1
* cell instance gf180mcu_fd_sc_mcu9t5v0__clkinv_1_12 r0 *1 0,0
Xgf180mcu_fd_sc_mcu9t5v0__clkinv_1_12 \$455 VDD VSS \$266
+ gf180mcu_fd_sc_mcu9t5v0__clkinv_1
* cell instance gf180mcu_fd_sc_mcu9t5v0__clkinv_1_13 r0 *1 0,0
Xgf180mcu_fd_sc_mcu9t5v0__clkinv_1_13 \$510 VDD VSS \$712
+ gf180mcu_fd_sc_mcu9t5v0__clkinv_1
* cell instance gf180mcu_fd_sc_mcu9t5v0__clkinv_1_14 r0 *1 0,0
Xgf180mcu_fd_sc_mcu9t5v0__clkinv_1_14 \$342 VDD VSS \$797
+ gf180mcu_fd_sc_mcu9t5v0__clkinv_1
* cell instance gf180mcu_fd_sc_mcu9t5v0__clkinv_1_15 r0 *1 0,0
Xgf180mcu_fd_sc_mcu9t5v0__clkinv_1_15 \$212 VDD VSS \$365
+ gf180mcu_fd_sc_mcu9t5v0__clkinv_1
* cell instance gf180mcu_fd_sc_mcu9t5v0__dffq_1_0 r0 *1 0,0
Xgf180mcu_fd_sc_mcu9t5v0__dffq_1_0 \$449 \$509 \$486 VDD VSS
+ gf180mcu_fd_sc_mcu9t5v0__dffq_1
* cell instance gf180mcu_fd_sc_mcu9t5v0__dffq_1_1 r0 *1 0,0
Xgf180mcu_fd_sc_mcu9t5v0__dffq_1_1 \$449 \$372 \$425 VDD VSS
+ gf180mcu_fd_sc_mcu9t5v0__dffq_1
* cell instance gf180mcu_fd_sc_mcu9t5v0__dffq_1_2 r0 *1 0,0
Xgf180mcu_fd_sc_mcu9t5v0__dffq_1_2 \$449 \$431 \$487 VDD VSS
+ gf180mcu_fd_sc_mcu9t5v0__dffq_1
* cell instance gf180mcu_fd_sc_mcu9t5v0__dffq_1_3 r0 *1 0,0
Xgf180mcu_fd_sc_mcu9t5v0__dffq_1_3 \$449 \$559 \$564 VDD VSS
+ gf180mcu_fd_sc_mcu9t5v0__dffq_1
* cell instance gf180mcu_fd_sc_mcu9t5v0__dffq_1_4 r0 *1 0,0
Xgf180mcu_fd_sc_mcu9t5v0__dffq_1_4 \$449 \$437 \$525 VDD VSS
+ gf180mcu_fd_sc_mcu9t5v0__dffq_1
* cell instance gf180mcu_fd_sc_mcu9t5v0__dffq_1_5 r0 *1 0,0
Xgf180mcu_fd_sc_mcu9t5v0__dffq_1_5 \$165 \$278 \$343 VDD VSS
+ gf180mcu_fd_sc_mcu9t5v0__dffq_1
* cell instance gf180mcu_fd_sc_mcu9t5v0__dffq_1_6 r0 *1 0,0
Xgf180mcu_fd_sc_mcu9t5v0__dffq_1_6 \$449 \$375 \$364 VDD VSS
+ gf180mcu_fd_sc_mcu9t5v0__dffq_1
* cell instance gf180mcu_fd_sc_mcu9t5v0__dffq_1_7 r0 *1 0,0
Xgf180mcu_fd_sc_mcu9t5v0__dffq_1_7 \$449 \$432 \$494 VDD VSS
+ gf180mcu_fd_sc_mcu9t5v0__dffq_1
* cell instance gf180mcu_fd_sc_mcu9t5v0__dffq_1_8 r0 *1 0,0
Xgf180mcu_fd_sc_mcu9t5v0__dffq_1_8 \$165 \$269 \$303 VDD VSS
+ gf180mcu_fd_sc_mcu9t5v0__dffq_1
* cell instance gf180mcu_fd_sc_mcu9t5v0__dffq_1_9 r0 *1 0,0
Xgf180mcu_fd_sc_mcu9t5v0__dffq_1_9 \$165 \$397 tmds[5] VDD VSS
+ gf180mcu_fd_sc_mcu9t5v0__dffq_1
* cell instance gf180mcu_fd_sc_mcu9t5v0__dffq_1_10 r0 *1 0,0
Xgf180mcu_fd_sc_mcu9t5v0__dffq_1_10 \$165 \$439 tmds[7] VDD VSS
+ gf180mcu_fd_sc_mcu9t5v0__dffq_1
* cell instance gf180mcu_fd_sc_mcu9t5v0__dffq_1_11 r0 *1 0,0
Xgf180mcu_fd_sc_mcu9t5v0__dffq_1_11 \$165 \$325 tmds[1] VDD VSS
+ gf180mcu_fd_sc_mcu9t5v0__dffq_1
* cell instance gf180mcu_fd_sc_mcu9t5v0__dffq_1_12 r0 *1 0,0
Xgf180mcu_fd_sc_mcu9t5v0__dffq_1_12 \$165 \$248 tmds[0] VDD VSS
+ gf180mcu_fd_sc_mcu9t5v0__dffq_1
* cell instance gf180mcu_fd_sc_mcu9t5v0__dffq_1_13 r0 *1 0,0
Xgf180mcu_fd_sc_mcu9t5v0__dffq_1_13 \$449 \$465 tmds[3] VDD VSS
+ gf180mcu_fd_sc_mcu9t5v0__dffq_1
* cell instance gf180mcu_fd_sc_mcu9t5v0__dffq_1_14 r0 *1 0,0
Xgf180mcu_fd_sc_mcu9t5v0__dffq_1_14 \$147 \$203 tmds[2] VDD VSS
+ gf180mcu_fd_sc_mcu9t5v0__dffq_1
* cell instance gf180mcu_fd_sc_mcu9t5v0__dffq_1_15 r0 *1 0,0
Xgf180mcu_fd_sc_mcu9t5v0__dffq_1_15 \$147 \$106 tmds[4] VDD VSS
+ gf180mcu_fd_sc_mcu9t5v0__dffq_1
* cell instance gf180mcu_fd_sc_mcu9t5v0__dffq_1_16 r0 *1 0,0
Xgf180mcu_fd_sc_mcu9t5v0__dffq_1_16 \$147 \$289 tmds[6] VDD VSS
+ gf180mcu_fd_sc_mcu9t5v0__dffq_1
* cell instance gf180mcu_fd_sc_mcu9t5v0__dffq_1_17 r0 *1 0,0
Xgf180mcu_fd_sc_mcu9t5v0__dffq_1_17 \$147 \$55 \$150 VDD VSS
+ gf180mcu_fd_sc_mcu9t5v0__dffq_1
* cell instance gf180mcu_fd_sc_mcu9t5v0__dffq_1_18 r0 *1 0,0
Xgf180mcu_fd_sc_mcu9t5v0__dffq_1_18 \$385 \$466 \$551 VDD VSS
+ gf180mcu_fd_sc_mcu9t5v0__dffq_1
* cell instance gf180mcu_fd_sc_mcu9t5v0__dffq_1_19 r0 *1 0,0
Xgf180mcu_fd_sc_mcu9t5v0__dffq_1_19 \$385 \$368 tmds[8] VDD VSS
+ gf180mcu_fd_sc_mcu9t5v0__dffq_1
* cell instance gf180mcu_fd_sc_mcu9t5v0__dffq_1_20 r0 *1 0,0
Xgf180mcu_fd_sc_mcu9t5v0__dffq_1_20 \$385 \$345 \$342 VDD VSS
+ gf180mcu_fd_sc_mcu9t5v0__dffq_1
* cell instance gf180mcu_fd_sc_mcu9t5v0__dffq_1_21 r0 *1 0,0
Xgf180mcu_fd_sc_mcu9t5v0__dffq_1_21 \$147 \$26 \$101 VDD VSS
+ gf180mcu_fd_sc_mcu9t5v0__dffq_1
* cell instance gf180mcu_fd_sc_mcu9t5v0__dffq_1_22 r0 *1 0,0
Xgf180mcu_fd_sc_mcu9t5v0__dffq_1_22 \$385 \$572 \$552 VDD VSS
+ gf180mcu_fd_sc_mcu9t5v0__dffq_1
* cell instance gf180mcu_fd_sc_mcu9t5v0__dffq_1_23 r0 *1 0,0
Xgf180mcu_fd_sc_mcu9t5v0__dffq_1_23 \$147 \$133 tmds[9] VDD VSS
+ gf180mcu_fd_sc_mcu9t5v0__dffq_1
* cell instance gf180mcu_fd_sc_mcu9t5v0__dffq_1_24 r0 *1 0,0
Xgf180mcu_fd_sc_mcu9t5v0__dffq_1_24 \$147 \$107 \$148 VDD VSS
+ gf180mcu_fd_sc_mcu9t5v0__dffq_1
* cell instance gf180mcu_fd_sc_mcu9t5v0__dffq_1_25 r0 *1 0,0
Xgf180mcu_fd_sc_mcu9t5v0__dffq_1_25 \$385 \$418 \$453 VDD VSS
+ gf180mcu_fd_sc_mcu9t5v0__dffq_1
* cell instance gf180mcu_fd_sc_mcu9t5v0__dffq_1_26 r0 *1 0,0
Xgf180mcu_fd_sc_mcu9t5v0__dffq_1_26 \$147 \$252 \$102 VDD VSS
+ gf180mcu_fd_sc_mcu9t5v0__dffq_1
* cell instance gf180mcu_fd_sc_mcu9t5v0__dffq_1_27 r0 *1 0,0
Xgf180mcu_fd_sc_mcu9t5v0__dffq_1_27 \$147 \$215 \$250 VDD VSS
+ gf180mcu_fd_sc_mcu9t5v0__dffq_1
* cell instance gf180mcu_fd_sc_mcu9t5v0__dffq_1_28 r0 *1 0,0
Xgf180mcu_fd_sc_mcu9t5v0__dffq_1_28 \$385 \$458 \$512 VDD VSS
+ gf180mcu_fd_sc_mcu9t5v0__dffq_1
* cell instance gf180mcu_fd_sc_mcu9t5v0__dlyc_1_0 r0 *1 0,0
Xgf180mcu_fd_sc_mcu9t5v0__dlyc_1_0 \$430 VDD VSS \$509
+ gf180mcu_fd_sc_mcu9t5v0__dlyc_1
* cell instance gf180mcu_fd_sc_mcu9t5v0__dlyc_1_1 r0 *1 0,0
Xgf180mcu_fd_sc_mcu9t5v0__dlyc_1_1 \$275 VDD VSS \$316
+ gf180mcu_fd_sc_mcu9t5v0__dlyc_1
* cell instance gf180mcu_fd_sc_mcu9t5v0__dlyc_1_2 r0 *1 0,0
Xgf180mcu_fd_sc_mcu9t5v0__dlyc_1_2 \$78 VDD VSS \$448
+ gf180mcu_fd_sc_mcu9t5v0__dlyc_1
* cell instance gf180mcu_fd_sc_mcu9t5v0__dlyc_1_3 r0 *1 0,0
Xgf180mcu_fd_sc_mcu9t5v0__dlyc_1_3 \$182 VDD VSS \$228
+ gf180mcu_fd_sc_mcu9t5v0__dlyc_1
* cell instance gf180mcu_fd_sc_mcu9t5v0__dlyc_1_4 r0 *1 0,0
Xgf180mcu_fd_sc_mcu9t5v0__dlyc_1_4 \$45 VDD VSS \$108
+ gf180mcu_fd_sc_mcu9t5v0__dlyc_1
* cell instance gf180mcu_fd_sc_mcu9t5v0__dlyc_1_5 r0 *1 0,0
Xgf180mcu_fd_sc_mcu9t5v0__dlyc_1_5 rst VDD VSS \$455
+ gf180mcu_fd_sc_mcu9t5v0__dlyc_1
* cell instance gf180mcu_fd_sc_mcu9t5v0__dlyc_1_6 r0 *1 0,0
Xgf180mcu_fd_sc_mcu9t5v0__dlyc_1_6 data[6] VDD VSS \$60
+ gf180mcu_fd_sc_mcu9t5v0__dlyc_1
* cell instance gf180mcu_fd_sc_mcu9t5v0__dlyc_1_7 r0 *1 0,0
Xgf180mcu_fd_sc_mcu9t5v0__dlyc_1_7 data[7] VDD VSS \$167
+ gf180mcu_fd_sc_mcu9t5v0__dlyc_1
* cell instance gf180mcu_fd_sc_mcu9t5v0__dlyc_1_8 r0 *1 0,0
Xgf180mcu_fd_sc_mcu9t5v0__dlyc_1_8 data[4] VDD VSS \$14
+ gf180mcu_fd_sc_mcu9t5v0__dlyc_1
* cell instance gf180mcu_fd_sc_mcu9t5v0__dlyc_1_9 r0 *1 0,0
Xgf180mcu_fd_sc_mcu9t5v0__dlyc_1_9 data[0] VDD VSS \$256
+ gf180mcu_fd_sc_mcu9t5v0__dlyc_1
* cell instance gf180mcu_fd_sc_mcu9t5v0__dlyc_1_10 r0 *1 0,0
Xgf180mcu_fd_sc_mcu9t5v0__dlyc_1_10 data[2] VDD VSS \$62
+ gf180mcu_fd_sc_mcu9t5v0__dlyc_1
* cell instance gf180mcu_fd_sc_mcu9t5v0__dlyc_1_11 r0 *1 0,0
Xgf180mcu_fd_sc_mcu9t5v0__dlyc_1_11 data[1] VDD VSS \$25
+ gf180mcu_fd_sc_mcu9t5v0__dlyc_1
* cell instance gf180mcu_fd_sc_mcu9t5v0__dlyc_1_12 r0 *1 0,0
Xgf180mcu_fd_sc_mcu9t5v0__dlyc_1_12 data[3] VDD VSS \$144
+ gf180mcu_fd_sc_mcu9t5v0__dlyc_1
* cell instance gf180mcu_fd_sc_mcu9t5v0__dlyc_1_13 r0 *1 0,0
Xgf180mcu_fd_sc_mcu9t5v0__dlyc_1_13 de VDD VSS \$48
+ gf180mcu_fd_sc_mcu9t5v0__dlyc_1
* cell instance gf180mcu_fd_sc_mcu9t5v0__dlyc_1_14 r0 *1 0,0
Xgf180mcu_fd_sc_mcu9t5v0__dlyc_1_14 ctrl[0] VDD VSS \$49
+ gf180mcu_fd_sc_mcu9t5v0__dlyc_1
* cell instance gf180mcu_fd_sc_mcu9t5v0__dlyc_1_15 r0 *1 0,0
Xgf180mcu_fd_sc_mcu9t5v0__dlyc_1_15 ctrl[1] VDD VSS \$31
+ gf180mcu_fd_sc_mcu9t5v0__dlyc_1
* cell instance gf180mcu_fd_sc_mcu9t5v0__endcap_0 r0 *1 0,0
Xgf180mcu_fd_sc_mcu9t5v0__endcap_0 VDD VSS gf180mcu_fd_sc_mcu9t5v0__endcap
* cell instance gf180mcu_fd_sc_mcu9t5v0__endcap_1 r0 *1 0,0
Xgf180mcu_fd_sc_mcu9t5v0__endcap_1 VDD VSS gf180mcu_fd_sc_mcu9t5v0__endcap
* cell instance gf180mcu_fd_sc_mcu9t5v0__endcap_2 r0 *1 0,0
Xgf180mcu_fd_sc_mcu9t5v0__endcap_2 VDD VSS gf180mcu_fd_sc_mcu9t5v0__endcap
* cell instance gf180mcu_fd_sc_mcu9t5v0__endcap_3 r0 *1 0,0
Xgf180mcu_fd_sc_mcu9t5v0__endcap_3 VDD VSS gf180mcu_fd_sc_mcu9t5v0__endcap
* cell instance gf180mcu_fd_sc_mcu9t5v0__endcap_4 r0 *1 0,0
Xgf180mcu_fd_sc_mcu9t5v0__endcap_4 VDD VSS gf180mcu_fd_sc_mcu9t5v0__endcap
* cell instance gf180mcu_fd_sc_mcu9t5v0__endcap_5 r0 *1 0,0
Xgf180mcu_fd_sc_mcu9t5v0__endcap_5 VDD VSS gf180mcu_fd_sc_mcu9t5v0__endcap
* cell instance gf180mcu_fd_sc_mcu9t5v0__endcap_6 r0 *1 0,0
Xgf180mcu_fd_sc_mcu9t5v0__endcap_6 VDD VSS gf180mcu_fd_sc_mcu9t5v0__endcap
* cell instance gf180mcu_fd_sc_mcu9t5v0__endcap_7 r0 *1 0,0
Xgf180mcu_fd_sc_mcu9t5v0__endcap_7 VDD VSS gf180mcu_fd_sc_mcu9t5v0__endcap
* cell instance gf180mcu_fd_sc_mcu9t5v0__endcap_8 r0 *1 0,0
Xgf180mcu_fd_sc_mcu9t5v0__endcap_8 VDD VSS gf180mcu_fd_sc_mcu9t5v0__endcap
* cell instance gf180mcu_fd_sc_mcu9t5v0__endcap_9 r0 *1 0,0
Xgf180mcu_fd_sc_mcu9t5v0__endcap_9 VDD VSS gf180mcu_fd_sc_mcu9t5v0__endcap
* cell instance gf180mcu_fd_sc_mcu9t5v0__endcap_10 r0 *1 0,0
Xgf180mcu_fd_sc_mcu9t5v0__endcap_10 VDD VSS gf180mcu_fd_sc_mcu9t5v0__endcap
* cell instance gf180mcu_fd_sc_mcu9t5v0__endcap_11 r0 *1 0,0
Xgf180mcu_fd_sc_mcu9t5v0__endcap_11 VDD VSS gf180mcu_fd_sc_mcu9t5v0__endcap
* cell instance gf180mcu_fd_sc_mcu9t5v0__endcap_12 r0 *1 0,0
Xgf180mcu_fd_sc_mcu9t5v0__endcap_12 VDD VSS gf180mcu_fd_sc_mcu9t5v0__endcap
* cell instance gf180mcu_fd_sc_mcu9t5v0__endcap_13 r0 *1 0,0
Xgf180mcu_fd_sc_mcu9t5v0__endcap_13 VDD VSS gf180mcu_fd_sc_mcu9t5v0__endcap
* cell instance gf180mcu_fd_sc_mcu9t5v0__endcap_14 r0 *1 0,0
Xgf180mcu_fd_sc_mcu9t5v0__endcap_14 VDD VSS gf180mcu_fd_sc_mcu9t5v0__endcap
* cell instance gf180mcu_fd_sc_mcu9t5v0__endcap_15 r0 *1 0,0
Xgf180mcu_fd_sc_mcu9t5v0__endcap_15 VDD VSS gf180mcu_fd_sc_mcu9t5v0__endcap
* cell instance gf180mcu_fd_sc_mcu9t5v0__endcap_16 r0 *1 0,0
Xgf180mcu_fd_sc_mcu9t5v0__endcap_16 VDD VSS gf180mcu_fd_sc_mcu9t5v0__endcap
* cell instance gf180mcu_fd_sc_mcu9t5v0__endcap_17 r0 *1 0,0
Xgf180mcu_fd_sc_mcu9t5v0__endcap_17 VDD VSS gf180mcu_fd_sc_mcu9t5v0__endcap
* cell instance gf180mcu_fd_sc_mcu9t5v0__endcap_18 r0 *1 0,0
Xgf180mcu_fd_sc_mcu9t5v0__endcap_18 VDD VSS gf180mcu_fd_sc_mcu9t5v0__endcap
* cell instance gf180mcu_fd_sc_mcu9t5v0__endcap_19 r0 *1 0,0
Xgf180mcu_fd_sc_mcu9t5v0__endcap_19 VDD VSS gf180mcu_fd_sc_mcu9t5v0__endcap
* cell instance gf180mcu_fd_sc_mcu9t5v0__endcap_20 r0 *1 0,0
Xgf180mcu_fd_sc_mcu9t5v0__endcap_20 VDD VSS gf180mcu_fd_sc_mcu9t5v0__endcap
* cell instance gf180mcu_fd_sc_mcu9t5v0__endcap_21 r0 *1 0,0
Xgf180mcu_fd_sc_mcu9t5v0__endcap_21 VDD VSS gf180mcu_fd_sc_mcu9t5v0__endcap
* cell instance gf180mcu_fd_sc_mcu9t5v0__endcap_22 r0 *1 0,0
Xgf180mcu_fd_sc_mcu9t5v0__endcap_22 VDD VSS gf180mcu_fd_sc_mcu9t5v0__endcap
* cell instance gf180mcu_fd_sc_mcu9t5v0__endcap_23 r0 *1 0,0
Xgf180mcu_fd_sc_mcu9t5v0__endcap_23 VDD VSS gf180mcu_fd_sc_mcu9t5v0__endcap
* cell instance gf180mcu_fd_sc_mcu9t5v0__endcap_24 r0 *1 0,0
Xgf180mcu_fd_sc_mcu9t5v0__endcap_24 VDD VSS gf180mcu_fd_sc_mcu9t5v0__endcap
* cell instance gf180mcu_fd_sc_mcu9t5v0__endcap_25 r0 *1 0,0
Xgf180mcu_fd_sc_mcu9t5v0__endcap_25 VDD VSS gf180mcu_fd_sc_mcu9t5v0__endcap
* cell instance gf180mcu_fd_sc_mcu9t5v0__endcap_26 r0 *1 0,0
Xgf180mcu_fd_sc_mcu9t5v0__endcap_26 VDD VSS gf180mcu_fd_sc_mcu9t5v0__endcap
* cell instance gf180mcu_fd_sc_mcu9t5v0__endcap_27 r0 *1 0,0
Xgf180mcu_fd_sc_mcu9t5v0__endcap_27 VDD VSS gf180mcu_fd_sc_mcu9t5v0__endcap
* cell instance gf180mcu_fd_sc_mcu9t5v0__endcap_28 r0 *1 0,0
Xgf180mcu_fd_sc_mcu9t5v0__endcap_28 VDD VSS gf180mcu_fd_sc_mcu9t5v0__endcap
* cell instance gf180mcu_fd_sc_mcu9t5v0__endcap_29 r0 *1 0,0
Xgf180mcu_fd_sc_mcu9t5v0__endcap_29 VDD VSS gf180mcu_fd_sc_mcu9t5v0__endcap
* cell instance gf180mcu_fd_sc_mcu9t5v0__endcap_30 r0 *1 0,0
Xgf180mcu_fd_sc_mcu9t5v0__endcap_30 VDD VSS gf180mcu_fd_sc_mcu9t5v0__endcap
* cell instance gf180mcu_fd_sc_mcu9t5v0__endcap_31 r0 *1 0,0
Xgf180mcu_fd_sc_mcu9t5v0__endcap_31 VDD VSS gf180mcu_fd_sc_mcu9t5v0__endcap
* cell instance gf180mcu_fd_sc_mcu9t5v0__endcap_32 r0 *1 0,0
Xgf180mcu_fd_sc_mcu9t5v0__endcap_32 VDD VSS gf180mcu_fd_sc_mcu9t5v0__endcap
* cell instance gf180mcu_fd_sc_mcu9t5v0__endcap_33 r0 *1 0,0
Xgf180mcu_fd_sc_mcu9t5v0__endcap_33 VDD VSS gf180mcu_fd_sc_mcu9t5v0__endcap
* cell instance gf180mcu_fd_sc_mcu9t5v0__endcap_34 r0 *1 0,0
Xgf180mcu_fd_sc_mcu9t5v0__endcap_34 VDD VSS gf180mcu_fd_sc_mcu9t5v0__endcap
* cell instance gf180mcu_fd_sc_mcu9t5v0__endcap_35 r0 *1 0,0
Xgf180mcu_fd_sc_mcu9t5v0__endcap_35 VDD VSS gf180mcu_fd_sc_mcu9t5v0__endcap
* cell instance gf180mcu_fd_sc_mcu9t5v0__endcap_36 r0 *1 0,0
Xgf180mcu_fd_sc_mcu9t5v0__endcap_36 VDD VSS gf180mcu_fd_sc_mcu9t5v0__endcap
* cell instance gf180mcu_fd_sc_mcu9t5v0__endcap_37 r0 *1 0,0
Xgf180mcu_fd_sc_mcu9t5v0__endcap_37 VDD VSS gf180mcu_fd_sc_mcu9t5v0__endcap
* cell instance gf180mcu_fd_sc_mcu9t5v0__endcap_38 r0 *1 0,0
Xgf180mcu_fd_sc_mcu9t5v0__endcap_38 VDD VSS gf180mcu_fd_sc_mcu9t5v0__endcap
* cell instance gf180mcu_fd_sc_mcu9t5v0__endcap_39 r0 *1 0,0
Xgf180mcu_fd_sc_mcu9t5v0__endcap_39 VDD VSS gf180mcu_fd_sc_mcu9t5v0__endcap
* cell instance gf180mcu_fd_sc_mcu9t5v0__endcap_40 r0 *1 0,0
Xgf180mcu_fd_sc_mcu9t5v0__endcap_40 VDD VSS gf180mcu_fd_sc_mcu9t5v0__endcap
* cell instance gf180mcu_fd_sc_mcu9t5v0__endcap_41 r0 *1 0,0
Xgf180mcu_fd_sc_mcu9t5v0__endcap_41 VDD VSS gf180mcu_fd_sc_mcu9t5v0__endcap
* cell instance gf180mcu_fd_sc_mcu9t5v0__endcap_42 r0 *1 0,0
Xgf180mcu_fd_sc_mcu9t5v0__endcap_42 VDD VSS gf180mcu_fd_sc_mcu9t5v0__endcap
* cell instance gf180mcu_fd_sc_mcu9t5v0__endcap_43 r0 *1 0,0
Xgf180mcu_fd_sc_mcu9t5v0__endcap_43 VDD VSS gf180mcu_fd_sc_mcu9t5v0__endcap
* cell instance gf180mcu_fd_sc_mcu9t5v0__endcap_44 r0 *1 0,0
Xgf180mcu_fd_sc_mcu9t5v0__endcap_44 VDD VSS gf180mcu_fd_sc_mcu9t5v0__endcap
* cell instance gf180mcu_fd_sc_mcu9t5v0__endcap_45 r0 *1 0,0
Xgf180mcu_fd_sc_mcu9t5v0__endcap_45 VDD VSS gf180mcu_fd_sc_mcu9t5v0__endcap
* cell instance gf180mcu_fd_sc_mcu9t5v0__endcap_46 r0 *1 0,0
Xgf180mcu_fd_sc_mcu9t5v0__endcap_46 VDD VSS gf180mcu_fd_sc_mcu9t5v0__endcap
* cell instance gf180mcu_fd_sc_mcu9t5v0__endcap_47 r0 *1 0,0
Xgf180mcu_fd_sc_mcu9t5v0__endcap_47 VDD VSS gf180mcu_fd_sc_mcu9t5v0__endcap
* cell instance gf180mcu_fd_sc_mcu9t5v0__endcap_48 r0 *1 0,0
Xgf180mcu_fd_sc_mcu9t5v0__endcap_48 VDD VSS gf180mcu_fd_sc_mcu9t5v0__endcap
* cell instance gf180mcu_fd_sc_mcu9t5v0__endcap_49 r0 *1 0,0
Xgf180mcu_fd_sc_mcu9t5v0__endcap_49 VDD VSS gf180mcu_fd_sc_mcu9t5v0__endcap
* cell instance gf180mcu_fd_sc_mcu9t5v0__endcap_50 r0 *1 0,0
Xgf180mcu_fd_sc_mcu9t5v0__endcap_50 VDD VSS gf180mcu_fd_sc_mcu9t5v0__endcap
* cell instance gf180mcu_fd_sc_mcu9t5v0__endcap_51 r0 *1 0,0
Xgf180mcu_fd_sc_mcu9t5v0__endcap_51 VDD VSS gf180mcu_fd_sc_mcu9t5v0__endcap
* cell instance gf180mcu_fd_sc_mcu9t5v0__endcap_52 r0 *1 0,0
Xgf180mcu_fd_sc_mcu9t5v0__endcap_52 VDD VSS gf180mcu_fd_sc_mcu9t5v0__endcap
* cell instance gf180mcu_fd_sc_mcu9t5v0__endcap_53 r0 *1 0,0
Xgf180mcu_fd_sc_mcu9t5v0__endcap_53 VDD VSS gf180mcu_fd_sc_mcu9t5v0__endcap
* cell instance gf180mcu_fd_sc_mcu9t5v0__endcap_54 r0 *1 0,0
Xgf180mcu_fd_sc_mcu9t5v0__endcap_54 VDD VSS gf180mcu_fd_sc_mcu9t5v0__endcap
* cell instance gf180mcu_fd_sc_mcu9t5v0__endcap_55 r0 *1 0,0
Xgf180mcu_fd_sc_mcu9t5v0__endcap_55 VDD VSS gf180mcu_fd_sc_mcu9t5v0__endcap
* cell instance gf180mcu_fd_sc_mcu9t5v0__endcap_56 r0 *1 0,0
Xgf180mcu_fd_sc_mcu9t5v0__endcap_56 VDD VSS gf180mcu_fd_sc_mcu9t5v0__endcap
* cell instance gf180mcu_fd_sc_mcu9t5v0__endcap_57 r0 *1 0,0
Xgf180mcu_fd_sc_mcu9t5v0__endcap_57 VDD VSS gf180mcu_fd_sc_mcu9t5v0__endcap
* cell instance gf180mcu_fd_sc_mcu9t5v0__endcap_58 r0 *1 0,0
Xgf180mcu_fd_sc_mcu9t5v0__endcap_58 VDD VSS gf180mcu_fd_sc_mcu9t5v0__endcap
* cell instance gf180mcu_fd_sc_mcu9t5v0__endcap_59 r0 *1 0,0
Xgf180mcu_fd_sc_mcu9t5v0__endcap_59 VDD VSS gf180mcu_fd_sc_mcu9t5v0__endcap
* cell instance gf180mcu_fd_sc_mcu9t5v0__endcap_60 r0 *1 0,0
Xgf180mcu_fd_sc_mcu9t5v0__endcap_60 VDD VSS gf180mcu_fd_sc_mcu9t5v0__endcap
* cell instance gf180mcu_fd_sc_mcu9t5v0__endcap_61 r0 *1 0,0
Xgf180mcu_fd_sc_mcu9t5v0__endcap_61 VDD VSS gf180mcu_fd_sc_mcu9t5v0__endcap
* cell instance gf180mcu_fd_sc_mcu9t5v0__endcap_62 r0 *1 0,0
Xgf180mcu_fd_sc_mcu9t5v0__endcap_62 VDD VSS gf180mcu_fd_sc_mcu9t5v0__endcap
* cell instance gf180mcu_fd_sc_mcu9t5v0__endcap_63 r0 *1 0,0
Xgf180mcu_fd_sc_mcu9t5v0__endcap_63 VDD VSS gf180mcu_fd_sc_mcu9t5v0__endcap
* cell instance gf180mcu_fd_sc_mcu9t5v0__fill_1_0 r0 *1 0,0
Xgf180mcu_fd_sc_mcu9t5v0__fill_1_0 VDD VSS gf180mcu_fd_sc_mcu9t5v0__fill_1
* cell instance gf180mcu_fd_sc_mcu9t5v0__fill_1_1 r0 *1 0,0
Xgf180mcu_fd_sc_mcu9t5v0__fill_1_1 VDD VSS gf180mcu_fd_sc_mcu9t5v0__fill_1
* cell instance gf180mcu_fd_sc_mcu9t5v0__fill_1_2 r0 *1 0,0
Xgf180mcu_fd_sc_mcu9t5v0__fill_1_2 VDD VSS gf180mcu_fd_sc_mcu9t5v0__fill_1
* cell instance gf180mcu_fd_sc_mcu9t5v0__fill_1_3 r0 *1 0,0
Xgf180mcu_fd_sc_mcu9t5v0__fill_1_3 VDD VSS gf180mcu_fd_sc_mcu9t5v0__fill_1
* cell instance gf180mcu_fd_sc_mcu9t5v0__fill_1_4 r0 *1 0,0
Xgf180mcu_fd_sc_mcu9t5v0__fill_1_4 VDD VSS gf180mcu_fd_sc_mcu9t5v0__fill_1
* cell instance gf180mcu_fd_sc_mcu9t5v0__fill_1_5 r0 *1 0,0
Xgf180mcu_fd_sc_mcu9t5v0__fill_1_5 VDD VSS gf180mcu_fd_sc_mcu9t5v0__fill_1
* cell instance gf180mcu_fd_sc_mcu9t5v0__fill_1_6 r0 *1 0,0
Xgf180mcu_fd_sc_mcu9t5v0__fill_1_6 VDD VSS gf180mcu_fd_sc_mcu9t5v0__fill_1
* cell instance gf180mcu_fd_sc_mcu9t5v0__fill_1_7 r0 *1 0,0
Xgf180mcu_fd_sc_mcu9t5v0__fill_1_7 VDD VSS gf180mcu_fd_sc_mcu9t5v0__fill_1
* cell instance gf180mcu_fd_sc_mcu9t5v0__fill_1_8 r0 *1 0,0
Xgf180mcu_fd_sc_mcu9t5v0__fill_1_8 VDD VSS gf180mcu_fd_sc_mcu9t5v0__fill_1
* cell instance gf180mcu_fd_sc_mcu9t5v0__fill_1_9 r0 *1 0,0
Xgf180mcu_fd_sc_mcu9t5v0__fill_1_9 VDD VSS gf180mcu_fd_sc_mcu9t5v0__fill_1
* cell instance gf180mcu_fd_sc_mcu9t5v0__fill_1_10 r0 *1 0,0
Xgf180mcu_fd_sc_mcu9t5v0__fill_1_10 VDD VSS gf180mcu_fd_sc_mcu9t5v0__fill_1
* cell instance gf180mcu_fd_sc_mcu9t5v0__fill_1_11 r0 *1 0,0
Xgf180mcu_fd_sc_mcu9t5v0__fill_1_11 VDD VSS gf180mcu_fd_sc_mcu9t5v0__fill_1
* cell instance gf180mcu_fd_sc_mcu9t5v0__fill_1_12 r0 *1 0,0
Xgf180mcu_fd_sc_mcu9t5v0__fill_1_12 VDD VSS gf180mcu_fd_sc_mcu9t5v0__fill_1
* cell instance gf180mcu_fd_sc_mcu9t5v0__fill_1_13 r0 *1 0,0
Xgf180mcu_fd_sc_mcu9t5v0__fill_1_13 VDD VSS gf180mcu_fd_sc_mcu9t5v0__fill_1
* cell instance gf180mcu_fd_sc_mcu9t5v0__fill_1_14 r0 *1 0,0
Xgf180mcu_fd_sc_mcu9t5v0__fill_1_14 VDD VSS gf180mcu_fd_sc_mcu9t5v0__fill_1
* cell instance gf180mcu_fd_sc_mcu9t5v0__fill_1_15 r0 *1 0,0
Xgf180mcu_fd_sc_mcu9t5v0__fill_1_15 VDD VSS gf180mcu_fd_sc_mcu9t5v0__fill_1
* cell instance gf180mcu_fd_sc_mcu9t5v0__fill_1_16 r0 *1 0,0
Xgf180mcu_fd_sc_mcu9t5v0__fill_1_16 VDD VSS gf180mcu_fd_sc_mcu9t5v0__fill_1
* cell instance gf180mcu_fd_sc_mcu9t5v0__fill_1_17 r0 *1 0,0
Xgf180mcu_fd_sc_mcu9t5v0__fill_1_17 VDD VSS gf180mcu_fd_sc_mcu9t5v0__fill_1
* cell instance gf180mcu_fd_sc_mcu9t5v0__fill_1_18 r0 *1 0,0
Xgf180mcu_fd_sc_mcu9t5v0__fill_1_18 VDD VSS gf180mcu_fd_sc_mcu9t5v0__fill_1
* cell instance gf180mcu_fd_sc_mcu9t5v0__fill_1_19 r0 *1 0,0
Xgf180mcu_fd_sc_mcu9t5v0__fill_1_19 VDD VSS gf180mcu_fd_sc_mcu9t5v0__fill_1
* cell instance gf180mcu_fd_sc_mcu9t5v0__fill_1_20 r0 *1 0,0
Xgf180mcu_fd_sc_mcu9t5v0__fill_1_20 VDD VSS gf180mcu_fd_sc_mcu9t5v0__fill_1
* cell instance gf180mcu_fd_sc_mcu9t5v0__fill_1_21 r0 *1 0,0
Xgf180mcu_fd_sc_mcu9t5v0__fill_1_21 VDD VSS gf180mcu_fd_sc_mcu9t5v0__fill_1
* cell instance gf180mcu_fd_sc_mcu9t5v0__fill_1_22 r0 *1 0,0
Xgf180mcu_fd_sc_mcu9t5v0__fill_1_22 VDD VSS gf180mcu_fd_sc_mcu9t5v0__fill_1
* cell instance gf180mcu_fd_sc_mcu9t5v0__fill_1_23 r0 *1 0,0
Xgf180mcu_fd_sc_mcu9t5v0__fill_1_23 VDD VSS gf180mcu_fd_sc_mcu9t5v0__fill_1
* cell instance gf180mcu_fd_sc_mcu9t5v0__fill_1_24 r0 *1 0,0
Xgf180mcu_fd_sc_mcu9t5v0__fill_1_24 VDD VSS gf180mcu_fd_sc_mcu9t5v0__fill_1
* cell instance gf180mcu_fd_sc_mcu9t5v0__fill_1_25 r0 *1 0,0
Xgf180mcu_fd_sc_mcu9t5v0__fill_1_25 VDD VSS gf180mcu_fd_sc_mcu9t5v0__fill_1
* cell instance gf180mcu_fd_sc_mcu9t5v0__fill_1_26 r0 *1 0,0
Xgf180mcu_fd_sc_mcu9t5v0__fill_1_26 VDD VSS gf180mcu_fd_sc_mcu9t5v0__fill_1
* cell instance gf180mcu_fd_sc_mcu9t5v0__fill_1_27 r0 *1 0,0
Xgf180mcu_fd_sc_mcu9t5v0__fill_1_27 VDD VSS gf180mcu_fd_sc_mcu9t5v0__fill_1
* cell instance gf180mcu_fd_sc_mcu9t5v0__fill_1_28 r0 *1 0,0
Xgf180mcu_fd_sc_mcu9t5v0__fill_1_28 VDD VSS gf180mcu_fd_sc_mcu9t5v0__fill_1
* cell instance gf180mcu_fd_sc_mcu9t5v0__fill_1_29 r0 *1 0,0
Xgf180mcu_fd_sc_mcu9t5v0__fill_1_29 VDD VSS gf180mcu_fd_sc_mcu9t5v0__fill_1
* cell instance gf180mcu_fd_sc_mcu9t5v0__fill_1_30 r0 *1 0,0
Xgf180mcu_fd_sc_mcu9t5v0__fill_1_30 VDD VSS gf180mcu_fd_sc_mcu9t5v0__fill_1
* cell instance gf180mcu_fd_sc_mcu9t5v0__fill_1_31 r0 *1 0,0
Xgf180mcu_fd_sc_mcu9t5v0__fill_1_31 VDD VSS gf180mcu_fd_sc_mcu9t5v0__fill_1
* cell instance gf180mcu_fd_sc_mcu9t5v0__fill_1_32 r0 *1 0,0
Xgf180mcu_fd_sc_mcu9t5v0__fill_1_32 VDD VSS gf180mcu_fd_sc_mcu9t5v0__fill_1
* cell instance gf180mcu_fd_sc_mcu9t5v0__fill_1_33 r0 *1 0,0
Xgf180mcu_fd_sc_mcu9t5v0__fill_1_33 VDD VSS gf180mcu_fd_sc_mcu9t5v0__fill_1
* cell instance gf180mcu_fd_sc_mcu9t5v0__fill_1_34 r0 *1 0,0
Xgf180mcu_fd_sc_mcu9t5v0__fill_1_34 VDD VSS gf180mcu_fd_sc_mcu9t5v0__fill_1
* cell instance gf180mcu_fd_sc_mcu9t5v0__fill_1_35 r0 *1 0,0
Xgf180mcu_fd_sc_mcu9t5v0__fill_1_35 VDD VSS gf180mcu_fd_sc_mcu9t5v0__fill_1
* cell instance gf180mcu_fd_sc_mcu9t5v0__fill_1_36 r0 *1 0,0
Xgf180mcu_fd_sc_mcu9t5v0__fill_1_36 VDD VSS gf180mcu_fd_sc_mcu9t5v0__fill_1
* cell instance gf180mcu_fd_sc_mcu9t5v0__fill_1_37 r0 *1 0,0
Xgf180mcu_fd_sc_mcu9t5v0__fill_1_37 VDD VSS gf180mcu_fd_sc_mcu9t5v0__fill_1
* cell instance gf180mcu_fd_sc_mcu9t5v0__fill_1_38 r0 *1 0,0
Xgf180mcu_fd_sc_mcu9t5v0__fill_1_38 VDD VSS gf180mcu_fd_sc_mcu9t5v0__fill_1
* cell instance gf180mcu_fd_sc_mcu9t5v0__fill_1_39 r0 *1 0,0
Xgf180mcu_fd_sc_mcu9t5v0__fill_1_39 VDD VSS gf180mcu_fd_sc_mcu9t5v0__fill_1
* cell instance gf180mcu_fd_sc_mcu9t5v0__fill_1_40 r0 *1 0,0
Xgf180mcu_fd_sc_mcu9t5v0__fill_1_40 VDD VSS gf180mcu_fd_sc_mcu9t5v0__fill_1
* cell instance gf180mcu_fd_sc_mcu9t5v0__fill_1_41 r0 *1 0,0
Xgf180mcu_fd_sc_mcu9t5v0__fill_1_41 VDD VSS gf180mcu_fd_sc_mcu9t5v0__fill_1
* cell instance gf180mcu_fd_sc_mcu9t5v0__fill_1_42 r0 *1 0,0
Xgf180mcu_fd_sc_mcu9t5v0__fill_1_42 VDD VSS gf180mcu_fd_sc_mcu9t5v0__fill_1
* cell instance gf180mcu_fd_sc_mcu9t5v0__fill_1_43 r0 *1 0,0
Xgf180mcu_fd_sc_mcu9t5v0__fill_1_43 VDD VSS gf180mcu_fd_sc_mcu9t5v0__fill_1
* cell instance gf180mcu_fd_sc_mcu9t5v0__fill_1_44 r0 *1 0,0
Xgf180mcu_fd_sc_mcu9t5v0__fill_1_44 VDD VSS gf180mcu_fd_sc_mcu9t5v0__fill_1
* cell instance gf180mcu_fd_sc_mcu9t5v0__fill_1_45 r0 *1 0,0
Xgf180mcu_fd_sc_mcu9t5v0__fill_1_45 VDD VSS gf180mcu_fd_sc_mcu9t5v0__fill_1
* cell instance gf180mcu_fd_sc_mcu9t5v0__fill_1_46 r0 *1 0,0
Xgf180mcu_fd_sc_mcu9t5v0__fill_1_46 VDD VSS gf180mcu_fd_sc_mcu9t5v0__fill_1
* cell instance gf180mcu_fd_sc_mcu9t5v0__fill_1_47 r0 *1 0,0
Xgf180mcu_fd_sc_mcu9t5v0__fill_1_47 VDD VSS gf180mcu_fd_sc_mcu9t5v0__fill_1
* cell instance gf180mcu_fd_sc_mcu9t5v0__fill_1_48 r0 *1 0,0
Xgf180mcu_fd_sc_mcu9t5v0__fill_1_48 VDD VSS gf180mcu_fd_sc_mcu9t5v0__fill_1
* cell instance gf180mcu_fd_sc_mcu9t5v0__fill_1_49 r0 *1 0,0
Xgf180mcu_fd_sc_mcu9t5v0__fill_1_49 VDD VSS gf180mcu_fd_sc_mcu9t5v0__fill_1
* cell instance gf180mcu_fd_sc_mcu9t5v0__fill_1_50 r0 *1 0,0
Xgf180mcu_fd_sc_mcu9t5v0__fill_1_50 VDD VSS gf180mcu_fd_sc_mcu9t5v0__fill_1
* cell instance gf180mcu_fd_sc_mcu9t5v0__fill_1_51 r0 *1 0,0
Xgf180mcu_fd_sc_mcu9t5v0__fill_1_51 VDD VSS gf180mcu_fd_sc_mcu9t5v0__fill_1
* cell instance gf180mcu_fd_sc_mcu9t5v0__fill_1_52 r0 *1 0,0
Xgf180mcu_fd_sc_mcu9t5v0__fill_1_52 VDD VSS gf180mcu_fd_sc_mcu9t5v0__fill_1
* cell instance gf180mcu_fd_sc_mcu9t5v0__fill_1_53 r0 *1 0,0
Xgf180mcu_fd_sc_mcu9t5v0__fill_1_53 VDD VSS gf180mcu_fd_sc_mcu9t5v0__fill_1
* cell instance gf180mcu_fd_sc_mcu9t5v0__fill_1_54 r0 *1 0,0
Xgf180mcu_fd_sc_mcu9t5v0__fill_1_54 VDD VSS gf180mcu_fd_sc_mcu9t5v0__fill_1
* cell instance gf180mcu_fd_sc_mcu9t5v0__fill_1_55 r0 *1 0,0
Xgf180mcu_fd_sc_mcu9t5v0__fill_1_55 VDD VSS gf180mcu_fd_sc_mcu9t5v0__fill_1
* cell instance gf180mcu_fd_sc_mcu9t5v0__fill_1_56 r0 *1 0,0
Xgf180mcu_fd_sc_mcu9t5v0__fill_1_56 VDD VSS gf180mcu_fd_sc_mcu9t5v0__fill_1
* cell instance gf180mcu_fd_sc_mcu9t5v0__fill_1_57 r0 *1 0,0
Xgf180mcu_fd_sc_mcu9t5v0__fill_1_57 VDD VSS gf180mcu_fd_sc_mcu9t5v0__fill_1
* cell instance gf180mcu_fd_sc_mcu9t5v0__fill_1_58 r0 *1 0,0
Xgf180mcu_fd_sc_mcu9t5v0__fill_1_58 VDD VSS gf180mcu_fd_sc_mcu9t5v0__fill_1
* cell instance gf180mcu_fd_sc_mcu9t5v0__fill_1_59 r0 *1 0,0
Xgf180mcu_fd_sc_mcu9t5v0__fill_1_59 VDD VSS gf180mcu_fd_sc_mcu9t5v0__fill_1
* cell instance gf180mcu_fd_sc_mcu9t5v0__fill_1_60 r0 *1 0,0
Xgf180mcu_fd_sc_mcu9t5v0__fill_1_60 VDD VSS gf180mcu_fd_sc_mcu9t5v0__fill_1
* cell instance gf180mcu_fd_sc_mcu9t5v0__fill_1_61 r0 *1 0,0
Xgf180mcu_fd_sc_mcu9t5v0__fill_1_61 VDD VSS gf180mcu_fd_sc_mcu9t5v0__fill_1
* cell instance gf180mcu_fd_sc_mcu9t5v0__fill_1_62 r0 *1 0,0
Xgf180mcu_fd_sc_mcu9t5v0__fill_1_62 VDD VSS gf180mcu_fd_sc_mcu9t5v0__fill_1
* cell instance gf180mcu_fd_sc_mcu9t5v0__fill_1_63 r0 *1 0,0
Xgf180mcu_fd_sc_mcu9t5v0__fill_1_63 VDD VSS gf180mcu_fd_sc_mcu9t5v0__fill_1
* cell instance gf180mcu_fd_sc_mcu9t5v0__fill_1_64 r0 *1 0,0
Xgf180mcu_fd_sc_mcu9t5v0__fill_1_64 VDD VSS gf180mcu_fd_sc_mcu9t5v0__fill_1
* cell instance gf180mcu_fd_sc_mcu9t5v0__fill_1_65 r0 *1 0,0
Xgf180mcu_fd_sc_mcu9t5v0__fill_1_65 VDD VSS gf180mcu_fd_sc_mcu9t5v0__fill_1
* cell instance gf180mcu_fd_sc_mcu9t5v0__fill_1_66 r0 *1 0,0
Xgf180mcu_fd_sc_mcu9t5v0__fill_1_66 VDD VSS gf180mcu_fd_sc_mcu9t5v0__fill_1
* cell instance gf180mcu_fd_sc_mcu9t5v0__fill_1_67 r0 *1 0,0
Xgf180mcu_fd_sc_mcu9t5v0__fill_1_67 VDD VSS gf180mcu_fd_sc_mcu9t5v0__fill_1
* cell instance gf180mcu_fd_sc_mcu9t5v0__fill_1_68 r0 *1 0,0
Xgf180mcu_fd_sc_mcu9t5v0__fill_1_68 VDD VSS gf180mcu_fd_sc_mcu9t5v0__fill_1
* cell instance gf180mcu_fd_sc_mcu9t5v0__fill_1_69 r0 *1 0,0
Xgf180mcu_fd_sc_mcu9t5v0__fill_1_69 VDD VSS gf180mcu_fd_sc_mcu9t5v0__fill_1
* cell instance gf180mcu_fd_sc_mcu9t5v0__fill_1_70 r0 *1 0,0
Xgf180mcu_fd_sc_mcu9t5v0__fill_1_70 VDD VSS gf180mcu_fd_sc_mcu9t5v0__fill_1
* cell instance gf180mcu_fd_sc_mcu9t5v0__fill_1_71 r0 *1 0,0
Xgf180mcu_fd_sc_mcu9t5v0__fill_1_71 VDD VSS gf180mcu_fd_sc_mcu9t5v0__fill_1
* cell instance gf180mcu_fd_sc_mcu9t5v0__fill_1_72 r0 *1 0,0
Xgf180mcu_fd_sc_mcu9t5v0__fill_1_72 VDD VSS gf180mcu_fd_sc_mcu9t5v0__fill_1
* cell instance gf180mcu_fd_sc_mcu9t5v0__fill_1_73 r0 *1 0,0
Xgf180mcu_fd_sc_mcu9t5v0__fill_1_73 VDD VSS gf180mcu_fd_sc_mcu9t5v0__fill_1
* cell instance gf180mcu_fd_sc_mcu9t5v0__fill_1_74 r0 *1 0,0
Xgf180mcu_fd_sc_mcu9t5v0__fill_1_74 VDD VSS gf180mcu_fd_sc_mcu9t5v0__fill_1
* cell instance gf180mcu_fd_sc_mcu9t5v0__fill_1_75 r0 *1 0,0
Xgf180mcu_fd_sc_mcu9t5v0__fill_1_75 VDD VSS gf180mcu_fd_sc_mcu9t5v0__fill_1
* cell instance gf180mcu_fd_sc_mcu9t5v0__fill_1_76 r0 *1 0,0
Xgf180mcu_fd_sc_mcu9t5v0__fill_1_76 VDD VSS gf180mcu_fd_sc_mcu9t5v0__fill_1
* cell instance gf180mcu_fd_sc_mcu9t5v0__fill_1_77 r0 *1 0,0
Xgf180mcu_fd_sc_mcu9t5v0__fill_1_77 VDD VSS gf180mcu_fd_sc_mcu9t5v0__fill_1
* cell instance gf180mcu_fd_sc_mcu9t5v0__fill_1_78 r0 *1 0,0
Xgf180mcu_fd_sc_mcu9t5v0__fill_1_78 VDD VSS gf180mcu_fd_sc_mcu9t5v0__fill_1
* cell instance gf180mcu_fd_sc_mcu9t5v0__fill_1_79 r0 *1 0,0
Xgf180mcu_fd_sc_mcu9t5v0__fill_1_79 VDD VSS gf180mcu_fd_sc_mcu9t5v0__fill_1
* cell instance gf180mcu_fd_sc_mcu9t5v0__fill_1_80 r0 *1 0,0
Xgf180mcu_fd_sc_mcu9t5v0__fill_1_80 VDD VSS gf180mcu_fd_sc_mcu9t5v0__fill_1
* cell instance gf180mcu_fd_sc_mcu9t5v0__fill_1_81 r0 *1 0,0
Xgf180mcu_fd_sc_mcu9t5v0__fill_1_81 VDD VSS gf180mcu_fd_sc_mcu9t5v0__fill_1
* cell instance gf180mcu_fd_sc_mcu9t5v0__fill_1_82 r0 *1 0,0
Xgf180mcu_fd_sc_mcu9t5v0__fill_1_82 VDD VSS gf180mcu_fd_sc_mcu9t5v0__fill_1
* cell instance gf180mcu_fd_sc_mcu9t5v0__fill_1_83 r0 *1 0,0
Xgf180mcu_fd_sc_mcu9t5v0__fill_1_83 VDD VSS gf180mcu_fd_sc_mcu9t5v0__fill_1
* cell instance gf180mcu_fd_sc_mcu9t5v0__fill_1_84 r0 *1 0,0
Xgf180mcu_fd_sc_mcu9t5v0__fill_1_84 VDD VSS gf180mcu_fd_sc_mcu9t5v0__fill_1
* cell instance gf180mcu_fd_sc_mcu9t5v0__fill_1_85 r0 *1 0,0
Xgf180mcu_fd_sc_mcu9t5v0__fill_1_85 VDD VSS gf180mcu_fd_sc_mcu9t5v0__fill_1
* cell instance gf180mcu_fd_sc_mcu9t5v0__fill_1_86 r0 *1 0,0
Xgf180mcu_fd_sc_mcu9t5v0__fill_1_86 VDD VSS gf180mcu_fd_sc_mcu9t5v0__fill_1
* cell instance gf180mcu_fd_sc_mcu9t5v0__fill_1_87 r0 *1 0,0
Xgf180mcu_fd_sc_mcu9t5v0__fill_1_87 VDD VSS gf180mcu_fd_sc_mcu9t5v0__fill_1
* cell instance gf180mcu_fd_sc_mcu9t5v0__fill_1_88 r0 *1 0,0
Xgf180mcu_fd_sc_mcu9t5v0__fill_1_88 VDD VSS gf180mcu_fd_sc_mcu9t5v0__fill_1
* cell instance gf180mcu_fd_sc_mcu9t5v0__fill_1_89 r0 *1 0,0
Xgf180mcu_fd_sc_mcu9t5v0__fill_1_89 VDD VSS gf180mcu_fd_sc_mcu9t5v0__fill_1
* cell instance gf180mcu_fd_sc_mcu9t5v0__fill_1_90 r0 *1 0,0
Xgf180mcu_fd_sc_mcu9t5v0__fill_1_90 VDD VSS gf180mcu_fd_sc_mcu9t5v0__fill_1
* cell instance gf180mcu_fd_sc_mcu9t5v0__fill_1_91 r0 *1 0,0
Xgf180mcu_fd_sc_mcu9t5v0__fill_1_91 VDD VSS gf180mcu_fd_sc_mcu9t5v0__fill_1
* cell instance gf180mcu_fd_sc_mcu9t5v0__fill_1_92 r0 *1 0,0
Xgf180mcu_fd_sc_mcu9t5v0__fill_1_92 VDD VSS gf180mcu_fd_sc_mcu9t5v0__fill_1
* cell instance gf180mcu_fd_sc_mcu9t5v0__fill_1_93 r0 *1 0,0
Xgf180mcu_fd_sc_mcu9t5v0__fill_1_93 VDD VSS gf180mcu_fd_sc_mcu9t5v0__fill_1
* cell instance gf180mcu_fd_sc_mcu9t5v0__fill_1_94 r0 *1 0,0
Xgf180mcu_fd_sc_mcu9t5v0__fill_1_94 VDD VSS gf180mcu_fd_sc_mcu9t5v0__fill_1
* cell instance gf180mcu_fd_sc_mcu9t5v0__fill_1_95 r0 *1 0,0
Xgf180mcu_fd_sc_mcu9t5v0__fill_1_95 VDD VSS gf180mcu_fd_sc_mcu9t5v0__fill_1
* cell instance gf180mcu_fd_sc_mcu9t5v0__fill_1_96 r0 *1 0,0
Xgf180mcu_fd_sc_mcu9t5v0__fill_1_96 VDD VSS gf180mcu_fd_sc_mcu9t5v0__fill_1
* cell instance gf180mcu_fd_sc_mcu9t5v0__fill_1_97 r0 *1 0,0
Xgf180mcu_fd_sc_mcu9t5v0__fill_1_97 VDD VSS gf180mcu_fd_sc_mcu9t5v0__fill_1
* cell instance gf180mcu_fd_sc_mcu9t5v0__fill_1_98 r0 *1 0,0
Xgf180mcu_fd_sc_mcu9t5v0__fill_1_98 VDD VSS gf180mcu_fd_sc_mcu9t5v0__fill_1
* cell instance gf180mcu_fd_sc_mcu9t5v0__fill_1_99 r0 *1 0,0
Xgf180mcu_fd_sc_mcu9t5v0__fill_1_99 VDD VSS gf180mcu_fd_sc_mcu9t5v0__fill_1
* cell instance gf180mcu_fd_sc_mcu9t5v0__fill_1_100 r0 *1 0,0
Xgf180mcu_fd_sc_mcu9t5v0__fill_1_100 VDD VSS gf180mcu_fd_sc_mcu9t5v0__fill_1
* cell instance gf180mcu_fd_sc_mcu9t5v0__fill_1_101 r0 *1 0,0
Xgf180mcu_fd_sc_mcu9t5v0__fill_1_101 VDD VSS gf180mcu_fd_sc_mcu9t5v0__fill_1
* cell instance gf180mcu_fd_sc_mcu9t5v0__fill_1_102 r0 *1 0,0
Xgf180mcu_fd_sc_mcu9t5v0__fill_1_102 VDD VSS gf180mcu_fd_sc_mcu9t5v0__fill_1
* cell instance gf180mcu_fd_sc_mcu9t5v0__fill_1_103 r0 *1 0,0
Xgf180mcu_fd_sc_mcu9t5v0__fill_1_103 VDD VSS gf180mcu_fd_sc_mcu9t5v0__fill_1
* cell instance gf180mcu_fd_sc_mcu9t5v0__fill_1_104 r0 *1 0,0
Xgf180mcu_fd_sc_mcu9t5v0__fill_1_104 VDD VSS gf180mcu_fd_sc_mcu9t5v0__fill_1
* cell instance gf180mcu_fd_sc_mcu9t5v0__fill_1_105 r0 *1 0,0
Xgf180mcu_fd_sc_mcu9t5v0__fill_1_105 VDD VSS gf180mcu_fd_sc_mcu9t5v0__fill_1
* cell instance gf180mcu_fd_sc_mcu9t5v0__fill_1_106 r0 *1 0,0
Xgf180mcu_fd_sc_mcu9t5v0__fill_1_106 VDD VSS gf180mcu_fd_sc_mcu9t5v0__fill_1
* cell instance gf180mcu_fd_sc_mcu9t5v0__fill_1_107 r0 *1 0,0
Xgf180mcu_fd_sc_mcu9t5v0__fill_1_107 VDD VSS gf180mcu_fd_sc_mcu9t5v0__fill_1
* cell instance gf180mcu_fd_sc_mcu9t5v0__fill_1_108 r0 *1 0,0
Xgf180mcu_fd_sc_mcu9t5v0__fill_1_108 VDD VSS gf180mcu_fd_sc_mcu9t5v0__fill_1
* cell instance gf180mcu_fd_sc_mcu9t5v0__fill_1_109 r0 *1 0,0
Xgf180mcu_fd_sc_mcu9t5v0__fill_1_109 VDD VSS gf180mcu_fd_sc_mcu9t5v0__fill_1
* cell instance gf180mcu_fd_sc_mcu9t5v0__fill_1_110 r0 *1 0,0
Xgf180mcu_fd_sc_mcu9t5v0__fill_1_110 VDD VSS gf180mcu_fd_sc_mcu9t5v0__fill_1
* cell instance gf180mcu_fd_sc_mcu9t5v0__fill_1_111 r0 *1 0,0
Xgf180mcu_fd_sc_mcu9t5v0__fill_1_111 VDD VSS gf180mcu_fd_sc_mcu9t5v0__fill_1
* cell instance gf180mcu_fd_sc_mcu9t5v0__fill_1_112 r0 *1 0,0
Xgf180mcu_fd_sc_mcu9t5v0__fill_1_112 VDD VSS gf180mcu_fd_sc_mcu9t5v0__fill_1
* cell instance gf180mcu_fd_sc_mcu9t5v0__fill_1_113 r0 *1 0,0
Xgf180mcu_fd_sc_mcu9t5v0__fill_1_113 VDD VSS gf180mcu_fd_sc_mcu9t5v0__fill_1
* cell instance gf180mcu_fd_sc_mcu9t5v0__fill_1_114 r0 *1 0,0
Xgf180mcu_fd_sc_mcu9t5v0__fill_1_114 VDD VSS gf180mcu_fd_sc_mcu9t5v0__fill_1
* cell instance gf180mcu_fd_sc_mcu9t5v0__fill_1_115 r0 *1 0,0
Xgf180mcu_fd_sc_mcu9t5v0__fill_1_115 VDD VSS gf180mcu_fd_sc_mcu9t5v0__fill_1
* cell instance gf180mcu_fd_sc_mcu9t5v0__fill_1_116 r0 *1 0,0
Xgf180mcu_fd_sc_mcu9t5v0__fill_1_116 VDD VSS gf180mcu_fd_sc_mcu9t5v0__fill_1
* cell instance gf180mcu_fd_sc_mcu9t5v0__fill_1_117 r0 *1 0,0
Xgf180mcu_fd_sc_mcu9t5v0__fill_1_117 VDD VSS gf180mcu_fd_sc_mcu9t5v0__fill_1
* cell instance gf180mcu_fd_sc_mcu9t5v0__fill_1_118 r0 *1 0,0
Xgf180mcu_fd_sc_mcu9t5v0__fill_1_118 VDD VSS gf180mcu_fd_sc_mcu9t5v0__fill_1
* cell instance gf180mcu_fd_sc_mcu9t5v0__fill_1_119 r0 *1 0,0
Xgf180mcu_fd_sc_mcu9t5v0__fill_1_119 VDD VSS gf180mcu_fd_sc_mcu9t5v0__fill_1
* cell instance gf180mcu_fd_sc_mcu9t5v0__fill_1_120 r0 *1 0,0
Xgf180mcu_fd_sc_mcu9t5v0__fill_1_120 VDD VSS gf180mcu_fd_sc_mcu9t5v0__fill_1
* cell instance gf180mcu_fd_sc_mcu9t5v0__fill_1_121 r0 *1 0,0
Xgf180mcu_fd_sc_mcu9t5v0__fill_1_121 VDD VSS gf180mcu_fd_sc_mcu9t5v0__fill_1
* cell instance gf180mcu_fd_sc_mcu9t5v0__fill_1_122 r0 *1 0,0
Xgf180mcu_fd_sc_mcu9t5v0__fill_1_122 VDD VSS gf180mcu_fd_sc_mcu9t5v0__fill_1
* cell instance gf180mcu_fd_sc_mcu9t5v0__fill_1_123 r0 *1 0,0
Xgf180mcu_fd_sc_mcu9t5v0__fill_1_123 VDD VSS gf180mcu_fd_sc_mcu9t5v0__fill_1
* cell instance gf180mcu_fd_sc_mcu9t5v0__fill_1_124 r0 *1 0,0
Xgf180mcu_fd_sc_mcu9t5v0__fill_1_124 VDD VSS gf180mcu_fd_sc_mcu9t5v0__fill_1
* cell instance gf180mcu_fd_sc_mcu9t5v0__fill_1_125 r0 *1 0,0
Xgf180mcu_fd_sc_mcu9t5v0__fill_1_125 VDD VSS gf180mcu_fd_sc_mcu9t5v0__fill_1
* cell instance gf180mcu_fd_sc_mcu9t5v0__fill_1_126 r0 *1 0,0
Xgf180mcu_fd_sc_mcu9t5v0__fill_1_126 VDD VSS gf180mcu_fd_sc_mcu9t5v0__fill_1
* cell instance gf180mcu_fd_sc_mcu9t5v0__fill_1_127 r0 *1 0,0
Xgf180mcu_fd_sc_mcu9t5v0__fill_1_127 VDD VSS gf180mcu_fd_sc_mcu9t5v0__fill_1
* cell instance gf180mcu_fd_sc_mcu9t5v0__fill_1_128 r0 *1 0,0
Xgf180mcu_fd_sc_mcu9t5v0__fill_1_128 VDD VSS gf180mcu_fd_sc_mcu9t5v0__fill_1
* cell instance gf180mcu_fd_sc_mcu9t5v0__fill_1_129 r0 *1 0,0
Xgf180mcu_fd_sc_mcu9t5v0__fill_1_129 VDD VSS gf180mcu_fd_sc_mcu9t5v0__fill_1
* cell instance gf180mcu_fd_sc_mcu9t5v0__fill_1_130 r0 *1 0,0
Xgf180mcu_fd_sc_mcu9t5v0__fill_1_130 VDD VSS gf180mcu_fd_sc_mcu9t5v0__fill_1
* cell instance gf180mcu_fd_sc_mcu9t5v0__fill_1_131 r0 *1 0,0
Xgf180mcu_fd_sc_mcu9t5v0__fill_1_131 VDD VSS gf180mcu_fd_sc_mcu9t5v0__fill_1
* cell instance gf180mcu_fd_sc_mcu9t5v0__fill_1_132 r0 *1 0,0
Xgf180mcu_fd_sc_mcu9t5v0__fill_1_132 VDD VSS gf180mcu_fd_sc_mcu9t5v0__fill_1
* cell instance gf180mcu_fd_sc_mcu9t5v0__fill_1_133 r0 *1 0,0
Xgf180mcu_fd_sc_mcu9t5v0__fill_1_133 VDD VSS gf180mcu_fd_sc_mcu9t5v0__fill_1
* cell instance gf180mcu_fd_sc_mcu9t5v0__fill_1_134 r0 *1 0,0
Xgf180mcu_fd_sc_mcu9t5v0__fill_1_134 VDD VSS gf180mcu_fd_sc_mcu9t5v0__fill_1
* cell instance gf180mcu_fd_sc_mcu9t5v0__fill_1_135 r0 *1 0,0
Xgf180mcu_fd_sc_mcu9t5v0__fill_1_135 VDD VSS gf180mcu_fd_sc_mcu9t5v0__fill_1
* cell instance gf180mcu_fd_sc_mcu9t5v0__fill_1_136 r0 *1 0,0
Xgf180mcu_fd_sc_mcu9t5v0__fill_1_136 VDD VSS gf180mcu_fd_sc_mcu9t5v0__fill_1
* cell instance gf180mcu_fd_sc_mcu9t5v0__fill_1_137 r0 *1 0,0
Xgf180mcu_fd_sc_mcu9t5v0__fill_1_137 VDD VSS gf180mcu_fd_sc_mcu9t5v0__fill_1
* cell instance gf180mcu_fd_sc_mcu9t5v0__fill_1_138 r0 *1 0,0
Xgf180mcu_fd_sc_mcu9t5v0__fill_1_138 VDD VSS gf180mcu_fd_sc_mcu9t5v0__fill_1
* cell instance gf180mcu_fd_sc_mcu9t5v0__fill_1_139 r0 *1 0,0
Xgf180mcu_fd_sc_mcu9t5v0__fill_1_139 VDD VSS gf180mcu_fd_sc_mcu9t5v0__fill_1
* cell instance gf180mcu_fd_sc_mcu9t5v0__fill_1_140 r0 *1 0,0
Xgf180mcu_fd_sc_mcu9t5v0__fill_1_140 VDD VSS gf180mcu_fd_sc_mcu9t5v0__fill_1
* cell instance gf180mcu_fd_sc_mcu9t5v0__fill_1_141 r0 *1 0,0
Xgf180mcu_fd_sc_mcu9t5v0__fill_1_141 VDD VSS gf180mcu_fd_sc_mcu9t5v0__fill_1
* cell instance gf180mcu_fd_sc_mcu9t5v0__fill_16_0 r0 *1 0,0
Xgf180mcu_fd_sc_mcu9t5v0__fill_16_0 VDD VSS gf180mcu_fd_sc_mcu9t5v0__fill_16
* cell instance gf180mcu_fd_sc_mcu9t5v0__fill_16_1 r0 *1 0,0
Xgf180mcu_fd_sc_mcu9t5v0__fill_16_1 VDD VSS gf180mcu_fd_sc_mcu9t5v0__fill_16
* cell instance gf180mcu_fd_sc_mcu9t5v0__fill_16_2 r0 *1 0,0
Xgf180mcu_fd_sc_mcu9t5v0__fill_16_2 VDD VSS gf180mcu_fd_sc_mcu9t5v0__fill_16
* cell instance gf180mcu_fd_sc_mcu9t5v0__fill_16_3 r0 *1 0,0
Xgf180mcu_fd_sc_mcu9t5v0__fill_16_3 VDD VSS gf180mcu_fd_sc_mcu9t5v0__fill_16
* cell instance gf180mcu_fd_sc_mcu9t5v0__fill_16_4 r0 *1 0,0
Xgf180mcu_fd_sc_mcu9t5v0__fill_16_4 VDD VSS gf180mcu_fd_sc_mcu9t5v0__fill_16
* cell instance gf180mcu_fd_sc_mcu9t5v0__fill_16_5 r0 *1 0,0
Xgf180mcu_fd_sc_mcu9t5v0__fill_16_5 VDD VSS gf180mcu_fd_sc_mcu9t5v0__fill_16
* cell instance gf180mcu_fd_sc_mcu9t5v0__fill_16_6 r0 *1 0,0
Xgf180mcu_fd_sc_mcu9t5v0__fill_16_6 VDD VSS gf180mcu_fd_sc_mcu9t5v0__fill_16
* cell instance gf180mcu_fd_sc_mcu9t5v0__fill_16_7 r0 *1 0,0
Xgf180mcu_fd_sc_mcu9t5v0__fill_16_7 VDD VSS gf180mcu_fd_sc_mcu9t5v0__fill_16
* cell instance gf180mcu_fd_sc_mcu9t5v0__fill_16_8 r0 *1 0,0
Xgf180mcu_fd_sc_mcu9t5v0__fill_16_8 VDD VSS gf180mcu_fd_sc_mcu9t5v0__fill_16
* cell instance gf180mcu_fd_sc_mcu9t5v0__fill_16_9 r0 *1 0,0
Xgf180mcu_fd_sc_mcu9t5v0__fill_16_9 VDD VSS gf180mcu_fd_sc_mcu9t5v0__fill_16
* cell instance gf180mcu_fd_sc_mcu9t5v0__fill_16_10 r0 *1 0,0
Xgf180mcu_fd_sc_mcu9t5v0__fill_16_10 VDD VSS gf180mcu_fd_sc_mcu9t5v0__fill_16
* cell instance gf180mcu_fd_sc_mcu9t5v0__fill_16_11 r0 *1 0,0
Xgf180mcu_fd_sc_mcu9t5v0__fill_16_11 VDD VSS gf180mcu_fd_sc_mcu9t5v0__fill_16
* cell instance gf180mcu_fd_sc_mcu9t5v0__fill_16_12 r0 *1 0,0
Xgf180mcu_fd_sc_mcu9t5v0__fill_16_12 VDD VSS gf180mcu_fd_sc_mcu9t5v0__fill_16
* cell instance gf180mcu_fd_sc_mcu9t5v0__fill_16_13 r0 *1 0,0
Xgf180mcu_fd_sc_mcu9t5v0__fill_16_13 VDD VSS gf180mcu_fd_sc_mcu9t5v0__fill_16
* cell instance gf180mcu_fd_sc_mcu9t5v0__fill_16_14 r0 *1 0,0
Xgf180mcu_fd_sc_mcu9t5v0__fill_16_14 VDD VSS gf180mcu_fd_sc_mcu9t5v0__fill_16
* cell instance gf180mcu_fd_sc_mcu9t5v0__fill_16_15 r0 *1 0,0
Xgf180mcu_fd_sc_mcu9t5v0__fill_16_15 VDD VSS gf180mcu_fd_sc_mcu9t5v0__fill_16
* cell instance gf180mcu_fd_sc_mcu9t5v0__fill_16_16 r0 *1 0,0
Xgf180mcu_fd_sc_mcu9t5v0__fill_16_16 VDD VSS gf180mcu_fd_sc_mcu9t5v0__fill_16
* cell instance gf180mcu_fd_sc_mcu9t5v0__fill_16_17 r0 *1 0,0
Xgf180mcu_fd_sc_mcu9t5v0__fill_16_17 VDD VSS gf180mcu_fd_sc_mcu9t5v0__fill_16
* cell instance gf180mcu_fd_sc_mcu9t5v0__fill_16_18 r0 *1 0,0
Xgf180mcu_fd_sc_mcu9t5v0__fill_16_18 VDD VSS gf180mcu_fd_sc_mcu9t5v0__fill_16
* cell instance gf180mcu_fd_sc_mcu9t5v0__fill_16_19 r0 *1 0,0
Xgf180mcu_fd_sc_mcu9t5v0__fill_16_19 VDD VSS gf180mcu_fd_sc_mcu9t5v0__fill_16
* cell instance gf180mcu_fd_sc_mcu9t5v0__fill_16_20 r0 *1 0,0
Xgf180mcu_fd_sc_mcu9t5v0__fill_16_20 VDD VSS gf180mcu_fd_sc_mcu9t5v0__fill_16
* cell instance gf180mcu_fd_sc_mcu9t5v0__fill_16_21 r0 *1 0,0
Xgf180mcu_fd_sc_mcu9t5v0__fill_16_21 VDD VSS gf180mcu_fd_sc_mcu9t5v0__fill_16
* cell instance gf180mcu_fd_sc_mcu9t5v0__fill_16_22 r0 *1 0,0
Xgf180mcu_fd_sc_mcu9t5v0__fill_16_22 VDD VSS gf180mcu_fd_sc_mcu9t5v0__fill_16
* cell instance gf180mcu_fd_sc_mcu9t5v0__fill_16_23 r0 *1 0,0
Xgf180mcu_fd_sc_mcu9t5v0__fill_16_23 VDD VSS gf180mcu_fd_sc_mcu9t5v0__fill_16
* cell instance gf180mcu_fd_sc_mcu9t5v0__fill_16_24 r0 *1 0,0
Xgf180mcu_fd_sc_mcu9t5v0__fill_16_24 VDD VSS gf180mcu_fd_sc_mcu9t5v0__fill_16
* cell instance gf180mcu_fd_sc_mcu9t5v0__fill_16_25 r0 *1 0,0
Xgf180mcu_fd_sc_mcu9t5v0__fill_16_25 VDD VSS gf180mcu_fd_sc_mcu9t5v0__fill_16
* cell instance gf180mcu_fd_sc_mcu9t5v0__fill_16_26 r0 *1 0,0
Xgf180mcu_fd_sc_mcu9t5v0__fill_16_26 VDD VSS gf180mcu_fd_sc_mcu9t5v0__fill_16
* cell instance gf180mcu_fd_sc_mcu9t5v0__fill_16_27 r0 *1 0,0
Xgf180mcu_fd_sc_mcu9t5v0__fill_16_27 VDD VSS gf180mcu_fd_sc_mcu9t5v0__fill_16
* cell instance gf180mcu_fd_sc_mcu9t5v0__fill_16_28 r0 *1 0,0
Xgf180mcu_fd_sc_mcu9t5v0__fill_16_28 VDD VSS gf180mcu_fd_sc_mcu9t5v0__fill_16
* cell instance gf180mcu_fd_sc_mcu9t5v0__fill_16_29 r0 *1 0,0
Xgf180mcu_fd_sc_mcu9t5v0__fill_16_29 VDD VSS gf180mcu_fd_sc_mcu9t5v0__fill_16
* cell instance gf180mcu_fd_sc_mcu9t5v0__fill_16_30 r0 *1 0,0
Xgf180mcu_fd_sc_mcu9t5v0__fill_16_30 VDD VSS gf180mcu_fd_sc_mcu9t5v0__fill_16
* cell instance gf180mcu_fd_sc_mcu9t5v0__fill_16_31 r0 *1 0,0
Xgf180mcu_fd_sc_mcu9t5v0__fill_16_31 VDD VSS gf180mcu_fd_sc_mcu9t5v0__fill_16
* cell instance gf180mcu_fd_sc_mcu9t5v0__fill_16_32 r0 *1 0,0
Xgf180mcu_fd_sc_mcu9t5v0__fill_16_32 VDD VSS gf180mcu_fd_sc_mcu9t5v0__fill_16
* cell instance gf180mcu_fd_sc_mcu9t5v0__fill_16_33 r0 *1 0,0
Xgf180mcu_fd_sc_mcu9t5v0__fill_16_33 VDD VSS gf180mcu_fd_sc_mcu9t5v0__fill_16
* cell instance gf180mcu_fd_sc_mcu9t5v0__fill_16_34 r0 *1 0,0
Xgf180mcu_fd_sc_mcu9t5v0__fill_16_34 VDD VSS gf180mcu_fd_sc_mcu9t5v0__fill_16
* cell instance gf180mcu_fd_sc_mcu9t5v0__fill_16_35 r0 *1 0,0
Xgf180mcu_fd_sc_mcu9t5v0__fill_16_35 VDD VSS gf180mcu_fd_sc_mcu9t5v0__fill_16
* cell instance gf180mcu_fd_sc_mcu9t5v0__fill_16_36 r0 *1 0,0
Xgf180mcu_fd_sc_mcu9t5v0__fill_16_36 VDD VSS gf180mcu_fd_sc_mcu9t5v0__fill_16
* cell instance gf180mcu_fd_sc_mcu9t5v0__fill_16_37 r0 *1 0,0
Xgf180mcu_fd_sc_mcu9t5v0__fill_16_37 VDD VSS gf180mcu_fd_sc_mcu9t5v0__fill_16
* cell instance gf180mcu_fd_sc_mcu9t5v0__fill_16_38 r0 *1 0,0
Xgf180mcu_fd_sc_mcu9t5v0__fill_16_38 VDD VSS gf180mcu_fd_sc_mcu9t5v0__fill_16
* cell instance gf180mcu_fd_sc_mcu9t5v0__fill_16_39 r0 *1 0,0
Xgf180mcu_fd_sc_mcu9t5v0__fill_16_39 VDD VSS gf180mcu_fd_sc_mcu9t5v0__fill_16
* cell instance gf180mcu_fd_sc_mcu9t5v0__fill_16_40 r0 *1 0,0
Xgf180mcu_fd_sc_mcu9t5v0__fill_16_40 VDD VSS gf180mcu_fd_sc_mcu9t5v0__fill_16
* cell instance gf180mcu_fd_sc_mcu9t5v0__fill_16_41 r0 *1 0,0
Xgf180mcu_fd_sc_mcu9t5v0__fill_16_41 VDD VSS gf180mcu_fd_sc_mcu9t5v0__fill_16
* cell instance gf180mcu_fd_sc_mcu9t5v0__fill_16_42 r0 *1 0,0
Xgf180mcu_fd_sc_mcu9t5v0__fill_16_42 VDD VSS gf180mcu_fd_sc_mcu9t5v0__fill_16
* cell instance gf180mcu_fd_sc_mcu9t5v0__fill_16_43 r0 *1 0,0
Xgf180mcu_fd_sc_mcu9t5v0__fill_16_43 VDD VSS gf180mcu_fd_sc_mcu9t5v0__fill_16
* cell instance gf180mcu_fd_sc_mcu9t5v0__fill_16_44 r0 *1 0,0
Xgf180mcu_fd_sc_mcu9t5v0__fill_16_44 VDD VSS gf180mcu_fd_sc_mcu9t5v0__fill_16
* cell instance gf180mcu_fd_sc_mcu9t5v0__fill_16_45 r0 *1 0,0
Xgf180mcu_fd_sc_mcu9t5v0__fill_16_45 VDD VSS gf180mcu_fd_sc_mcu9t5v0__fill_16
* cell instance gf180mcu_fd_sc_mcu9t5v0__fill_16_46 r0 *1 0,0
Xgf180mcu_fd_sc_mcu9t5v0__fill_16_46 VDD VSS gf180mcu_fd_sc_mcu9t5v0__fill_16
* cell instance gf180mcu_fd_sc_mcu9t5v0__fill_16_47 r0 *1 0,0
Xgf180mcu_fd_sc_mcu9t5v0__fill_16_47 VDD VSS gf180mcu_fd_sc_mcu9t5v0__fill_16
* cell instance gf180mcu_fd_sc_mcu9t5v0__fill_16_48 r0 *1 0,0
Xgf180mcu_fd_sc_mcu9t5v0__fill_16_48 VDD VSS gf180mcu_fd_sc_mcu9t5v0__fill_16
* cell instance gf180mcu_fd_sc_mcu9t5v0__fill_16_49 r0 *1 0,0
Xgf180mcu_fd_sc_mcu9t5v0__fill_16_49 VDD VSS gf180mcu_fd_sc_mcu9t5v0__fill_16
* cell instance gf180mcu_fd_sc_mcu9t5v0__fill_16_50 r0 *1 0,0
Xgf180mcu_fd_sc_mcu9t5v0__fill_16_50 VDD VSS gf180mcu_fd_sc_mcu9t5v0__fill_16
* cell instance gf180mcu_fd_sc_mcu9t5v0__fill_16_51 r0 *1 0,0
Xgf180mcu_fd_sc_mcu9t5v0__fill_16_51 VDD VSS gf180mcu_fd_sc_mcu9t5v0__fill_16
* cell instance gf180mcu_fd_sc_mcu9t5v0__fill_16_52 r0 *1 0,0
Xgf180mcu_fd_sc_mcu9t5v0__fill_16_52 VDD VSS gf180mcu_fd_sc_mcu9t5v0__fill_16
* cell instance gf180mcu_fd_sc_mcu9t5v0__fill_16_53 r0 *1 0,0
Xgf180mcu_fd_sc_mcu9t5v0__fill_16_53 VDD VSS gf180mcu_fd_sc_mcu9t5v0__fill_16
* cell instance gf180mcu_fd_sc_mcu9t5v0__fill_16_54 r0 *1 0,0
Xgf180mcu_fd_sc_mcu9t5v0__fill_16_54 VDD VSS gf180mcu_fd_sc_mcu9t5v0__fill_16
* cell instance gf180mcu_fd_sc_mcu9t5v0__fill_16_55 r0 *1 0,0
Xgf180mcu_fd_sc_mcu9t5v0__fill_16_55 VDD VSS gf180mcu_fd_sc_mcu9t5v0__fill_16
* cell instance gf180mcu_fd_sc_mcu9t5v0__fill_16_56 r0 *1 0,0
Xgf180mcu_fd_sc_mcu9t5v0__fill_16_56 VDD VSS gf180mcu_fd_sc_mcu9t5v0__fill_16
* cell instance gf180mcu_fd_sc_mcu9t5v0__fill_16_57 r0 *1 0,0
Xgf180mcu_fd_sc_mcu9t5v0__fill_16_57 VDD VSS gf180mcu_fd_sc_mcu9t5v0__fill_16
* cell instance gf180mcu_fd_sc_mcu9t5v0__fill_16_58 r0 *1 0,0
Xgf180mcu_fd_sc_mcu9t5v0__fill_16_58 VDD VSS gf180mcu_fd_sc_mcu9t5v0__fill_16
* cell instance gf180mcu_fd_sc_mcu9t5v0__fill_16_59 r0 *1 0,0
Xgf180mcu_fd_sc_mcu9t5v0__fill_16_59 VDD VSS gf180mcu_fd_sc_mcu9t5v0__fill_16
* cell instance gf180mcu_fd_sc_mcu9t5v0__fill_16_60 r0 *1 0,0
Xgf180mcu_fd_sc_mcu9t5v0__fill_16_60 VDD VSS gf180mcu_fd_sc_mcu9t5v0__fill_16
* cell instance gf180mcu_fd_sc_mcu9t5v0__fill_16_61 r0 *1 0,0
Xgf180mcu_fd_sc_mcu9t5v0__fill_16_61 VDD VSS gf180mcu_fd_sc_mcu9t5v0__fill_16
* cell instance gf180mcu_fd_sc_mcu9t5v0__fill_16_62 r0 *1 0,0
Xgf180mcu_fd_sc_mcu9t5v0__fill_16_62 VDD VSS gf180mcu_fd_sc_mcu9t5v0__fill_16
* cell instance gf180mcu_fd_sc_mcu9t5v0__fill_16_63 r0 *1 0,0
Xgf180mcu_fd_sc_mcu9t5v0__fill_16_63 VDD VSS gf180mcu_fd_sc_mcu9t5v0__fill_16
* cell instance gf180mcu_fd_sc_mcu9t5v0__fill_16_64 r0 *1 0,0
Xgf180mcu_fd_sc_mcu9t5v0__fill_16_64 VDD VSS gf180mcu_fd_sc_mcu9t5v0__fill_16
* cell instance gf180mcu_fd_sc_mcu9t5v0__fill_16_65 r0 *1 0,0
Xgf180mcu_fd_sc_mcu9t5v0__fill_16_65 VDD VSS gf180mcu_fd_sc_mcu9t5v0__fill_16
* cell instance gf180mcu_fd_sc_mcu9t5v0__fill_16_66 r0 *1 0,0
Xgf180mcu_fd_sc_mcu9t5v0__fill_16_66 VDD VSS gf180mcu_fd_sc_mcu9t5v0__fill_16
* cell instance gf180mcu_fd_sc_mcu9t5v0__fill_16_67 r0 *1 0,0
Xgf180mcu_fd_sc_mcu9t5v0__fill_16_67 VDD VSS gf180mcu_fd_sc_mcu9t5v0__fill_16
* cell instance gf180mcu_fd_sc_mcu9t5v0__fill_16_68 r0 *1 0,0
Xgf180mcu_fd_sc_mcu9t5v0__fill_16_68 VDD VSS gf180mcu_fd_sc_mcu9t5v0__fill_16
* cell instance gf180mcu_fd_sc_mcu9t5v0__fill_16_69 r0 *1 0,0
Xgf180mcu_fd_sc_mcu9t5v0__fill_16_69 VDD VSS gf180mcu_fd_sc_mcu9t5v0__fill_16
* cell instance gf180mcu_fd_sc_mcu9t5v0__fill_16_70 r0 *1 0,0
Xgf180mcu_fd_sc_mcu9t5v0__fill_16_70 VDD VSS gf180mcu_fd_sc_mcu9t5v0__fill_16
* cell instance gf180mcu_fd_sc_mcu9t5v0__fill_16_71 r0 *1 0,0
Xgf180mcu_fd_sc_mcu9t5v0__fill_16_71 VDD VSS gf180mcu_fd_sc_mcu9t5v0__fill_16
* cell instance gf180mcu_fd_sc_mcu9t5v0__fill_16_72 r0 *1 0,0
Xgf180mcu_fd_sc_mcu9t5v0__fill_16_72 VDD VSS gf180mcu_fd_sc_mcu9t5v0__fill_16
* cell instance gf180mcu_fd_sc_mcu9t5v0__fill_16_73 r0 *1 0,0
Xgf180mcu_fd_sc_mcu9t5v0__fill_16_73 VDD VSS gf180mcu_fd_sc_mcu9t5v0__fill_16
* cell instance gf180mcu_fd_sc_mcu9t5v0__fill_16_74 r0 *1 0,0
Xgf180mcu_fd_sc_mcu9t5v0__fill_16_74 VDD VSS gf180mcu_fd_sc_mcu9t5v0__fill_16
* cell instance gf180mcu_fd_sc_mcu9t5v0__fill_16_75 r0 *1 0,0
Xgf180mcu_fd_sc_mcu9t5v0__fill_16_75 VDD VSS gf180mcu_fd_sc_mcu9t5v0__fill_16
* cell instance gf180mcu_fd_sc_mcu9t5v0__fill_16_76 r0 *1 0,0
Xgf180mcu_fd_sc_mcu9t5v0__fill_16_76 VDD VSS gf180mcu_fd_sc_mcu9t5v0__fill_16
* cell instance gf180mcu_fd_sc_mcu9t5v0__fill_16_77 r0 *1 0,0
Xgf180mcu_fd_sc_mcu9t5v0__fill_16_77 VDD VSS gf180mcu_fd_sc_mcu9t5v0__fill_16
* cell instance gf180mcu_fd_sc_mcu9t5v0__fill_16_78 r0 *1 0,0
Xgf180mcu_fd_sc_mcu9t5v0__fill_16_78 VDD VSS gf180mcu_fd_sc_mcu9t5v0__fill_16
* cell instance gf180mcu_fd_sc_mcu9t5v0__fill_16_79 r0 *1 0,0
Xgf180mcu_fd_sc_mcu9t5v0__fill_16_79 VDD VSS gf180mcu_fd_sc_mcu9t5v0__fill_16
* cell instance gf180mcu_fd_sc_mcu9t5v0__fill_16_80 r0 *1 0,0
Xgf180mcu_fd_sc_mcu9t5v0__fill_16_80 VDD VSS gf180mcu_fd_sc_mcu9t5v0__fill_16
* cell instance gf180mcu_fd_sc_mcu9t5v0__fill_16_81 r0 *1 0,0
Xgf180mcu_fd_sc_mcu9t5v0__fill_16_81 VDD VSS gf180mcu_fd_sc_mcu9t5v0__fill_16
* cell instance gf180mcu_fd_sc_mcu9t5v0__fill_16_82 r0 *1 0,0
Xgf180mcu_fd_sc_mcu9t5v0__fill_16_82 VDD VSS gf180mcu_fd_sc_mcu9t5v0__fill_16
* cell instance gf180mcu_fd_sc_mcu9t5v0__fill_16_83 r0 *1 0,0
Xgf180mcu_fd_sc_mcu9t5v0__fill_16_83 VDD VSS gf180mcu_fd_sc_mcu9t5v0__fill_16
* cell instance gf180mcu_fd_sc_mcu9t5v0__fill_16_84 r0 *1 0,0
Xgf180mcu_fd_sc_mcu9t5v0__fill_16_84 VDD VSS gf180mcu_fd_sc_mcu9t5v0__fill_16
* cell instance gf180mcu_fd_sc_mcu9t5v0__fill_16_85 r0 *1 0,0
Xgf180mcu_fd_sc_mcu9t5v0__fill_16_85 VDD VSS gf180mcu_fd_sc_mcu9t5v0__fill_16
* cell instance gf180mcu_fd_sc_mcu9t5v0__fill_16_86 r0 *1 0,0
Xgf180mcu_fd_sc_mcu9t5v0__fill_16_86 VDD VSS gf180mcu_fd_sc_mcu9t5v0__fill_16
* cell instance gf180mcu_fd_sc_mcu9t5v0__fill_16_87 r0 *1 0,0
Xgf180mcu_fd_sc_mcu9t5v0__fill_16_87 VDD VSS gf180mcu_fd_sc_mcu9t5v0__fill_16
* cell instance gf180mcu_fd_sc_mcu9t5v0__fill_16_88 r0 *1 0,0
Xgf180mcu_fd_sc_mcu9t5v0__fill_16_88 VDD VSS gf180mcu_fd_sc_mcu9t5v0__fill_16
* cell instance gf180mcu_fd_sc_mcu9t5v0__fill_16_89 r0 *1 0,0
Xgf180mcu_fd_sc_mcu9t5v0__fill_16_89 VDD VSS gf180mcu_fd_sc_mcu9t5v0__fill_16
* cell instance gf180mcu_fd_sc_mcu9t5v0__fill_16_90 r0 *1 0,0
Xgf180mcu_fd_sc_mcu9t5v0__fill_16_90 VDD VSS gf180mcu_fd_sc_mcu9t5v0__fill_16
* cell instance gf180mcu_fd_sc_mcu9t5v0__fill_16_91 r0 *1 0,0
Xgf180mcu_fd_sc_mcu9t5v0__fill_16_91 VDD VSS gf180mcu_fd_sc_mcu9t5v0__fill_16
* cell instance gf180mcu_fd_sc_mcu9t5v0__fill_16_92 r0 *1 0,0
Xgf180mcu_fd_sc_mcu9t5v0__fill_16_92 VDD VSS gf180mcu_fd_sc_mcu9t5v0__fill_16
* cell instance gf180mcu_fd_sc_mcu9t5v0__fill_16_93 r0 *1 0,0
Xgf180mcu_fd_sc_mcu9t5v0__fill_16_93 VDD VSS gf180mcu_fd_sc_mcu9t5v0__fill_16
* cell instance gf180mcu_fd_sc_mcu9t5v0__fill_16_94 r0 *1 0,0
Xgf180mcu_fd_sc_mcu9t5v0__fill_16_94 VDD VSS gf180mcu_fd_sc_mcu9t5v0__fill_16
* cell instance gf180mcu_fd_sc_mcu9t5v0__fill_16_95 r0 *1 0,0
Xgf180mcu_fd_sc_mcu9t5v0__fill_16_95 VDD VSS gf180mcu_fd_sc_mcu9t5v0__fill_16
* cell instance gf180mcu_fd_sc_mcu9t5v0__fill_16_96 r0 *1 0,0
Xgf180mcu_fd_sc_mcu9t5v0__fill_16_96 VDD VSS gf180mcu_fd_sc_mcu9t5v0__fill_16
* cell instance gf180mcu_fd_sc_mcu9t5v0__fill_16_97 r0 *1 0,0
Xgf180mcu_fd_sc_mcu9t5v0__fill_16_97 VDD VSS gf180mcu_fd_sc_mcu9t5v0__fill_16
* cell instance gf180mcu_fd_sc_mcu9t5v0__fill_16_98 r0 *1 0,0
Xgf180mcu_fd_sc_mcu9t5v0__fill_16_98 VDD VSS gf180mcu_fd_sc_mcu9t5v0__fill_16
* cell instance gf180mcu_fd_sc_mcu9t5v0__fill_16_99 r0 *1 0,0
Xgf180mcu_fd_sc_mcu9t5v0__fill_16_99 VDD VSS gf180mcu_fd_sc_mcu9t5v0__fill_16
* cell instance gf180mcu_fd_sc_mcu9t5v0__fill_16_100 r0 *1 0,0
Xgf180mcu_fd_sc_mcu9t5v0__fill_16_100 VDD VSS gf180mcu_fd_sc_mcu9t5v0__fill_16
* cell instance gf180mcu_fd_sc_mcu9t5v0__fill_16_101 r0 *1 0,0
Xgf180mcu_fd_sc_mcu9t5v0__fill_16_101 VDD VSS gf180mcu_fd_sc_mcu9t5v0__fill_16
* cell instance gf180mcu_fd_sc_mcu9t5v0__fill_16_102 r0 *1 0,0
Xgf180mcu_fd_sc_mcu9t5v0__fill_16_102 VDD VSS gf180mcu_fd_sc_mcu9t5v0__fill_16
* cell instance gf180mcu_fd_sc_mcu9t5v0__fill_16_103 r0 *1 0,0
Xgf180mcu_fd_sc_mcu9t5v0__fill_16_103 VDD VSS gf180mcu_fd_sc_mcu9t5v0__fill_16
* cell instance gf180mcu_fd_sc_mcu9t5v0__fill_16_104 r0 *1 0,0
Xgf180mcu_fd_sc_mcu9t5v0__fill_16_104 VDD VSS gf180mcu_fd_sc_mcu9t5v0__fill_16
* cell instance gf180mcu_fd_sc_mcu9t5v0__fill_2_0 r0 *1 0,0
Xgf180mcu_fd_sc_mcu9t5v0__fill_2_0 VDD VSS gf180mcu_fd_sc_mcu9t5v0__fill_2
* cell instance gf180mcu_fd_sc_mcu9t5v0__fill_2_1 r0 *1 0,0
Xgf180mcu_fd_sc_mcu9t5v0__fill_2_1 VDD VSS gf180mcu_fd_sc_mcu9t5v0__fill_2
* cell instance gf180mcu_fd_sc_mcu9t5v0__fill_2_2 r0 *1 0,0
Xgf180mcu_fd_sc_mcu9t5v0__fill_2_2 VDD VSS gf180mcu_fd_sc_mcu9t5v0__fill_2
* cell instance gf180mcu_fd_sc_mcu9t5v0__fill_2_3 r0 *1 0,0
Xgf180mcu_fd_sc_mcu9t5v0__fill_2_3 VDD VSS gf180mcu_fd_sc_mcu9t5v0__fill_2
* cell instance gf180mcu_fd_sc_mcu9t5v0__fill_2_4 r0 *1 0,0
Xgf180mcu_fd_sc_mcu9t5v0__fill_2_4 VDD VSS gf180mcu_fd_sc_mcu9t5v0__fill_2
* cell instance gf180mcu_fd_sc_mcu9t5v0__fill_2_5 r0 *1 0,0
Xgf180mcu_fd_sc_mcu9t5v0__fill_2_5 VDD VSS gf180mcu_fd_sc_mcu9t5v0__fill_2
* cell instance gf180mcu_fd_sc_mcu9t5v0__fill_2_6 r0 *1 0,0
Xgf180mcu_fd_sc_mcu9t5v0__fill_2_6 VDD VSS gf180mcu_fd_sc_mcu9t5v0__fill_2
* cell instance gf180mcu_fd_sc_mcu9t5v0__fill_2_7 r0 *1 0,0
Xgf180mcu_fd_sc_mcu9t5v0__fill_2_7 VDD VSS gf180mcu_fd_sc_mcu9t5v0__fill_2
* cell instance gf180mcu_fd_sc_mcu9t5v0__fill_2_8 r0 *1 0,0
Xgf180mcu_fd_sc_mcu9t5v0__fill_2_8 VDD VSS gf180mcu_fd_sc_mcu9t5v0__fill_2
* cell instance gf180mcu_fd_sc_mcu9t5v0__fill_2_9 r0 *1 0,0
Xgf180mcu_fd_sc_mcu9t5v0__fill_2_9 VDD VSS gf180mcu_fd_sc_mcu9t5v0__fill_2
* cell instance gf180mcu_fd_sc_mcu9t5v0__fill_2_10 r0 *1 0,0
Xgf180mcu_fd_sc_mcu9t5v0__fill_2_10 VDD VSS gf180mcu_fd_sc_mcu9t5v0__fill_2
* cell instance gf180mcu_fd_sc_mcu9t5v0__fill_2_11 r0 *1 0,0
Xgf180mcu_fd_sc_mcu9t5v0__fill_2_11 VDD VSS gf180mcu_fd_sc_mcu9t5v0__fill_2
* cell instance gf180mcu_fd_sc_mcu9t5v0__fill_2_12 r0 *1 0,0
Xgf180mcu_fd_sc_mcu9t5v0__fill_2_12 VDD VSS gf180mcu_fd_sc_mcu9t5v0__fill_2
* cell instance gf180mcu_fd_sc_mcu9t5v0__fill_2_13 r0 *1 0,0
Xgf180mcu_fd_sc_mcu9t5v0__fill_2_13 VDD VSS gf180mcu_fd_sc_mcu9t5v0__fill_2
* cell instance gf180mcu_fd_sc_mcu9t5v0__fill_2_14 r0 *1 0,0
Xgf180mcu_fd_sc_mcu9t5v0__fill_2_14 VDD VSS gf180mcu_fd_sc_mcu9t5v0__fill_2
* cell instance gf180mcu_fd_sc_mcu9t5v0__fill_2_15 r0 *1 0,0
Xgf180mcu_fd_sc_mcu9t5v0__fill_2_15 VDD VSS gf180mcu_fd_sc_mcu9t5v0__fill_2
* cell instance gf180mcu_fd_sc_mcu9t5v0__fill_2_16 r0 *1 0,0
Xgf180mcu_fd_sc_mcu9t5v0__fill_2_16 VDD VSS gf180mcu_fd_sc_mcu9t5v0__fill_2
* cell instance gf180mcu_fd_sc_mcu9t5v0__fill_2_17 r0 *1 0,0
Xgf180mcu_fd_sc_mcu9t5v0__fill_2_17 VDD VSS gf180mcu_fd_sc_mcu9t5v0__fill_2
* cell instance gf180mcu_fd_sc_mcu9t5v0__fill_2_18 r0 *1 0,0
Xgf180mcu_fd_sc_mcu9t5v0__fill_2_18 VDD VSS gf180mcu_fd_sc_mcu9t5v0__fill_2
* cell instance gf180mcu_fd_sc_mcu9t5v0__fill_2_19 r0 *1 0,0
Xgf180mcu_fd_sc_mcu9t5v0__fill_2_19 VDD VSS gf180mcu_fd_sc_mcu9t5v0__fill_2
* cell instance gf180mcu_fd_sc_mcu9t5v0__fill_2_20 r0 *1 0,0
Xgf180mcu_fd_sc_mcu9t5v0__fill_2_20 VDD VSS gf180mcu_fd_sc_mcu9t5v0__fill_2
* cell instance gf180mcu_fd_sc_mcu9t5v0__fill_2_21 r0 *1 0,0
Xgf180mcu_fd_sc_mcu9t5v0__fill_2_21 VDD VSS gf180mcu_fd_sc_mcu9t5v0__fill_2
* cell instance gf180mcu_fd_sc_mcu9t5v0__fill_2_22 r0 *1 0,0
Xgf180mcu_fd_sc_mcu9t5v0__fill_2_22 VDD VSS gf180mcu_fd_sc_mcu9t5v0__fill_2
* cell instance gf180mcu_fd_sc_mcu9t5v0__fill_2_23 r0 *1 0,0
Xgf180mcu_fd_sc_mcu9t5v0__fill_2_23 VDD VSS gf180mcu_fd_sc_mcu9t5v0__fill_2
* cell instance gf180mcu_fd_sc_mcu9t5v0__fill_2_24 r0 *1 0,0
Xgf180mcu_fd_sc_mcu9t5v0__fill_2_24 VDD VSS gf180mcu_fd_sc_mcu9t5v0__fill_2
* cell instance gf180mcu_fd_sc_mcu9t5v0__fill_2_25 r0 *1 0,0
Xgf180mcu_fd_sc_mcu9t5v0__fill_2_25 VDD VSS gf180mcu_fd_sc_mcu9t5v0__fill_2
* cell instance gf180mcu_fd_sc_mcu9t5v0__fill_2_26 r0 *1 0,0
Xgf180mcu_fd_sc_mcu9t5v0__fill_2_26 VDD VSS gf180mcu_fd_sc_mcu9t5v0__fill_2
* cell instance gf180mcu_fd_sc_mcu9t5v0__fill_2_27 r0 *1 0,0
Xgf180mcu_fd_sc_mcu9t5v0__fill_2_27 VDD VSS gf180mcu_fd_sc_mcu9t5v0__fill_2
* cell instance gf180mcu_fd_sc_mcu9t5v0__fill_2_28 r0 *1 0,0
Xgf180mcu_fd_sc_mcu9t5v0__fill_2_28 VDD VSS gf180mcu_fd_sc_mcu9t5v0__fill_2
* cell instance gf180mcu_fd_sc_mcu9t5v0__fill_2_29 r0 *1 0,0
Xgf180mcu_fd_sc_mcu9t5v0__fill_2_29 VDD VSS gf180mcu_fd_sc_mcu9t5v0__fill_2
* cell instance gf180mcu_fd_sc_mcu9t5v0__fill_2_30 r0 *1 0,0
Xgf180mcu_fd_sc_mcu9t5v0__fill_2_30 VDD VSS gf180mcu_fd_sc_mcu9t5v0__fill_2
* cell instance gf180mcu_fd_sc_mcu9t5v0__fill_2_31 r0 *1 0,0
Xgf180mcu_fd_sc_mcu9t5v0__fill_2_31 VDD VSS gf180mcu_fd_sc_mcu9t5v0__fill_2
* cell instance gf180mcu_fd_sc_mcu9t5v0__fill_2_32 r0 *1 0,0
Xgf180mcu_fd_sc_mcu9t5v0__fill_2_32 VDD VSS gf180mcu_fd_sc_mcu9t5v0__fill_2
* cell instance gf180mcu_fd_sc_mcu9t5v0__fill_2_33 r0 *1 0,0
Xgf180mcu_fd_sc_mcu9t5v0__fill_2_33 VDD VSS gf180mcu_fd_sc_mcu9t5v0__fill_2
* cell instance gf180mcu_fd_sc_mcu9t5v0__fill_2_34 r0 *1 0,0
Xgf180mcu_fd_sc_mcu9t5v0__fill_2_34 VDD VSS gf180mcu_fd_sc_mcu9t5v0__fill_2
* cell instance gf180mcu_fd_sc_mcu9t5v0__fill_2_35 r0 *1 0,0
Xgf180mcu_fd_sc_mcu9t5v0__fill_2_35 VDD VSS gf180mcu_fd_sc_mcu9t5v0__fill_2
* cell instance gf180mcu_fd_sc_mcu9t5v0__fill_2_36 r0 *1 0,0
Xgf180mcu_fd_sc_mcu9t5v0__fill_2_36 VDD VSS gf180mcu_fd_sc_mcu9t5v0__fill_2
* cell instance gf180mcu_fd_sc_mcu9t5v0__fill_2_37 r0 *1 0,0
Xgf180mcu_fd_sc_mcu9t5v0__fill_2_37 VDD VSS gf180mcu_fd_sc_mcu9t5v0__fill_2
* cell instance gf180mcu_fd_sc_mcu9t5v0__fill_2_38 r0 *1 0,0
Xgf180mcu_fd_sc_mcu9t5v0__fill_2_38 VDD VSS gf180mcu_fd_sc_mcu9t5v0__fill_2
* cell instance gf180mcu_fd_sc_mcu9t5v0__fill_2_39 r0 *1 0,0
Xgf180mcu_fd_sc_mcu9t5v0__fill_2_39 VDD VSS gf180mcu_fd_sc_mcu9t5v0__fill_2
* cell instance gf180mcu_fd_sc_mcu9t5v0__fill_2_40 r0 *1 0,0
Xgf180mcu_fd_sc_mcu9t5v0__fill_2_40 VDD VSS gf180mcu_fd_sc_mcu9t5v0__fill_2
* cell instance gf180mcu_fd_sc_mcu9t5v0__fill_2_41 r0 *1 0,0
Xgf180mcu_fd_sc_mcu9t5v0__fill_2_41 VDD VSS gf180mcu_fd_sc_mcu9t5v0__fill_2
* cell instance gf180mcu_fd_sc_mcu9t5v0__fill_2_42 r0 *1 0,0
Xgf180mcu_fd_sc_mcu9t5v0__fill_2_42 VDD VSS gf180mcu_fd_sc_mcu9t5v0__fill_2
* cell instance gf180mcu_fd_sc_mcu9t5v0__fill_2_43 r0 *1 0,0
Xgf180mcu_fd_sc_mcu9t5v0__fill_2_43 VDD VSS gf180mcu_fd_sc_mcu9t5v0__fill_2
* cell instance gf180mcu_fd_sc_mcu9t5v0__fill_2_44 r0 *1 0,0
Xgf180mcu_fd_sc_mcu9t5v0__fill_2_44 VDD VSS gf180mcu_fd_sc_mcu9t5v0__fill_2
* cell instance gf180mcu_fd_sc_mcu9t5v0__fill_2_45 r0 *1 0,0
Xgf180mcu_fd_sc_mcu9t5v0__fill_2_45 VDD VSS gf180mcu_fd_sc_mcu9t5v0__fill_2
* cell instance gf180mcu_fd_sc_mcu9t5v0__fill_2_46 r0 *1 0,0
Xgf180mcu_fd_sc_mcu9t5v0__fill_2_46 VDD VSS gf180mcu_fd_sc_mcu9t5v0__fill_2
* cell instance gf180mcu_fd_sc_mcu9t5v0__fill_2_47 r0 *1 0,0
Xgf180mcu_fd_sc_mcu9t5v0__fill_2_47 VDD VSS gf180mcu_fd_sc_mcu9t5v0__fill_2
* cell instance gf180mcu_fd_sc_mcu9t5v0__fill_2_48 r0 *1 0,0
Xgf180mcu_fd_sc_mcu9t5v0__fill_2_48 VDD VSS gf180mcu_fd_sc_mcu9t5v0__fill_2
* cell instance gf180mcu_fd_sc_mcu9t5v0__fill_2_49 r0 *1 0,0
Xgf180mcu_fd_sc_mcu9t5v0__fill_2_49 VDD VSS gf180mcu_fd_sc_mcu9t5v0__fill_2
* cell instance gf180mcu_fd_sc_mcu9t5v0__fill_2_50 r0 *1 0,0
Xgf180mcu_fd_sc_mcu9t5v0__fill_2_50 VDD VSS gf180mcu_fd_sc_mcu9t5v0__fill_2
* cell instance gf180mcu_fd_sc_mcu9t5v0__fill_2_51 r0 *1 0,0
Xgf180mcu_fd_sc_mcu9t5v0__fill_2_51 VDD VSS gf180mcu_fd_sc_mcu9t5v0__fill_2
* cell instance gf180mcu_fd_sc_mcu9t5v0__fill_2_52 r0 *1 0,0
Xgf180mcu_fd_sc_mcu9t5v0__fill_2_52 VDD VSS gf180mcu_fd_sc_mcu9t5v0__fill_2
* cell instance gf180mcu_fd_sc_mcu9t5v0__fill_2_53 r0 *1 0,0
Xgf180mcu_fd_sc_mcu9t5v0__fill_2_53 VDD VSS gf180mcu_fd_sc_mcu9t5v0__fill_2
* cell instance gf180mcu_fd_sc_mcu9t5v0__fill_2_54 r0 *1 0,0
Xgf180mcu_fd_sc_mcu9t5v0__fill_2_54 VDD VSS gf180mcu_fd_sc_mcu9t5v0__fill_2
* cell instance gf180mcu_fd_sc_mcu9t5v0__fill_2_55 r0 *1 0,0
Xgf180mcu_fd_sc_mcu9t5v0__fill_2_55 VDD VSS gf180mcu_fd_sc_mcu9t5v0__fill_2
* cell instance gf180mcu_fd_sc_mcu9t5v0__fill_2_56 r0 *1 0,0
Xgf180mcu_fd_sc_mcu9t5v0__fill_2_56 VDD VSS gf180mcu_fd_sc_mcu9t5v0__fill_2
* cell instance gf180mcu_fd_sc_mcu9t5v0__fill_2_57 r0 *1 0,0
Xgf180mcu_fd_sc_mcu9t5v0__fill_2_57 VDD VSS gf180mcu_fd_sc_mcu9t5v0__fill_2
* cell instance gf180mcu_fd_sc_mcu9t5v0__fill_2_58 r0 *1 0,0
Xgf180mcu_fd_sc_mcu9t5v0__fill_2_58 VDD VSS gf180mcu_fd_sc_mcu9t5v0__fill_2
* cell instance gf180mcu_fd_sc_mcu9t5v0__fill_2_59 r0 *1 0,0
Xgf180mcu_fd_sc_mcu9t5v0__fill_2_59 VDD VSS gf180mcu_fd_sc_mcu9t5v0__fill_2
* cell instance gf180mcu_fd_sc_mcu9t5v0__fill_2_60 r0 *1 0,0
Xgf180mcu_fd_sc_mcu9t5v0__fill_2_60 VDD VSS gf180mcu_fd_sc_mcu9t5v0__fill_2
* cell instance gf180mcu_fd_sc_mcu9t5v0__fill_2_61 r0 *1 0,0
Xgf180mcu_fd_sc_mcu9t5v0__fill_2_61 VDD VSS gf180mcu_fd_sc_mcu9t5v0__fill_2
* cell instance gf180mcu_fd_sc_mcu9t5v0__fill_2_62 r0 *1 0,0
Xgf180mcu_fd_sc_mcu9t5v0__fill_2_62 VDD VSS gf180mcu_fd_sc_mcu9t5v0__fill_2
* cell instance gf180mcu_fd_sc_mcu9t5v0__fill_2_63 r0 *1 0,0
Xgf180mcu_fd_sc_mcu9t5v0__fill_2_63 VDD VSS gf180mcu_fd_sc_mcu9t5v0__fill_2
* cell instance gf180mcu_fd_sc_mcu9t5v0__fill_2_64 r0 *1 0,0
Xgf180mcu_fd_sc_mcu9t5v0__fill_2_64 VDD VSS gf180mcu_fd_sc_mcu9t5v0__fill_2
* cell instance gf180mcu_fd_sc_mcu9t5v0__fill_2_65 r0 *1 0,0
Xgf180mcu_fd_sc_mcu9t5v0__fill_2_65 VDD VSS gf180mcu_fd_sc_mcu9t5v0__fill_2
* cell instance gf180mcu_fd_sc_mcu9t5v0__fill_2_66 r0 *1 0,0
Xgf180mcu_fd_sc_mcu9t5v0__fill_2_66 VDD VSS gf180mcu_fd_sc_mcu9t5v0__fill_2
* cell instance gf180mcu_fd_sc_mcu9t5v0__fill_2_67 r0 *1 0,0
Xgf180mcu_fd_sc_mcu9t5v0__fill_2_67 VDD VSS gf180mcu_fd_sc_mcu9t5v0__fill_2
* cell instance gf180mcu_fd_sc_mcu9t5v0__fill_2_68 r0 *1 0,0
Xgf180mcu_fd_sc_mcu9t5v0__fill_2_68 VDD VSS gf180mcu_fd_sc_mcu9t5v0__fill_2
* cell instance gf180mcu_fd_sc_mcu9t5v0__fill_2_69 r0 *1 0,0
Xgf180mcu_fd_sc_mcu9t5v0__fill_2_69 VDD VSS gf180mcu_fd_sc_mcu9t5v0__fill_2
* cell instance gf180mcu_fd_sc_mcu9t5v0__fill_2_70 r0 *1 0,0
Xgf180mcu_fd_sc_mcu9t5v0__fill_2_70 VDD VSS gf180mcu_fd_sc_mcu9t5v0__fill_2
* cell instance gf180mcu_fd_sc_mcu9t5v0__fill_2_71 r0 *1 0,0
Xgf180mcu_fd_sc_mcu9t5v0__fill_2_71 VDD VSS gf180mcu_fd_sc_mcu9t5v0__fill_2
* cell instance gf180mcu_fd_sc_mcu9t5v0__fill_2_72 r0 *1 0,0
Xgf180mcu_fd_sc_mcu9t5v0__fill_2_72 VDD VSS gf180mcu_fd_sc_mcu9t5v0__fill_2
* cell instance gf180mcu_fd_sc_mcu9t5v0__fill_2_73 r0 *1 0,0
Xgf180mcu_fd_sc_mcu9t5v0__fill_2_73 VDD VSS gf180mcu_fd_sc_mcu9t5v0__fill_2
* cell instance gf180mcu_fd_sc_mcu9t5v0__fill_2_74 r0 *1 0,0
Xgf180mcu_fd_sc_mcu9t5v0__fill_2_74 VDD VSS gf180mcu_fd_sc_mcu9t5v0__fill_2
* cell instance gf180mcu_fd_sc_mcu9t5v0__fill_2_75 r0 *1 0,0
Xgf180mcu_fd_sc_mcu9t5v0__fill_2_75 VDD VSS gf180mcu_fd_sc_mcu9t5v0__fill_2
* cell instance gf180mcu_fd_sc_mcu9t5v0__fill_2_76 r0 *1 0,0
Xgf180mcu_fd_sc_mcu9t5v0__fill_2_76 VDD VSS gf180mcu_fd_sc_mcu9t5v0__fill_2
* cell instance gf180mcu_fd_sc_mcu9t5v0__fill_2_77 r0 *1 0,0
Xgf180mcu_fd_sc_mcu9t5v0__fill_2_77 VDD VSS gf180mcu_fd_sc_mcu9t5v0__fill_2
* cell instance gf180mcu_fd_sc_mcu9t5v0__fill_2_78 r0 *1 0,0
Xgf180mcu_fd_sc_mcu9t5v0__fill_2_78 VDD VSS gf180mcu_fd_sc_mcu9t5v0__fill_2
* cell instance gf180mcu_fd_sc_mcu9t5v0__fill_2_79 r0 *1 0,0
Xgf180mcu_fd_sc_mcu9t5v0__fill_2_79 VDD VSS gf180mcu_fd_sc_mcu9t5v0__fill_2
* cell instance gf180mcu_fd_sc_mcu9t5v0__fill_2_80 r0 *1 0,0
Xgf180mcu_fd_sc_mcu9t5v0__fill_2_80 VDD VSS gf180mcu_fd_sc_mcu9t5v0__fill_2
* cell instance gf180mcu_fd_sc_mcu9t5v0__fill_2_81 r0 *1 0,0
Xgf180mcu_fd_sc_mcu9t5v0__fill_2_81 VDD VSS gf180mcu_fd_sc_mcu9t5v0__fill_2
* cell instance gf180mcu_fd_sc_mcu9t5v0__fill_2_82 r0 *1 0,0
Xgf180mcu_fd_sc_mcu9t5v0__fill_2_82 VDD VSS gf180mcu_fd_sc_mcu9t5v0__fill_2
* cell instance gf180mcu_fd_sc_mcu9t5v0__fill_2_83 r0 *1 0,0
Xgf180mcu_fd_sc_mcu9t5v0__fill_2_83 VDD VSS gf180mcu_fd_sc_mcu9t5v0__fill_2
* cell instance gf180mcu_fd_sc_mcu9t5v0__fill_2_84 r0 *1 0,0
Xgf180mcu_fd_sc_mcu9t5v0__fill_2_84 VDD VSS gf180mcu_fd_sc_mcu9t5v0__fill_2
* cell instance gf180mcu_fd_sc_mcu9t5v0__fill_2_85 r0 *1 0,0
Xgf180mcu_fd_sc_mcu9t5v0__fill_2_85 VDD VSS gf180mcu_fd_sc_mcu9t5v0__fill_2
* cell instance gf180mcu_fd_sc_mcu9t5v0__fill_2_86 r0 *1 0,0
Xgf180mcu_fd_sc_mcu9t5v0__fill_2_86 VDD VSS gf180mcu_fd_sc_mcu9t5v0__fill_2
* cell instance gf180mcu_fd_sc_mcu9t5v0__fill_2_87 r0 *1 0,0
Xgf180mcu_fd_sc_mcu9t5v0__fill_2_87 VDD VSS gf180mcu_fd_sc_mcu9t5v0__fill_2
* cell instance gf180mcu_fd_sc_mcu9t5v0__fill_2_88 r0 *1 0,0
Xgf180mcu_fd_sc_mcu9t5v0__fill_2_88 VDD VSS gf180mcu_fd_sc_mcu9t5v0__fill_2
* cell instance gf180mcu_fd_sc_mcu9t5v0__fill_2_89 r0 *1 0,0
Xgf180mcu_fd_sc_mcu9t5v0__fill_2_89 VDD VSS gf180mcu_fd_sc_mcu9t5v0__fill_2
* cell instance gf180mcu_fd_sc_mcu9t5v0__fill_2_90 r0 *1 0,0
Xgf180mcu_fd_sc_mcu9t5v0__fill_2_90 VDD VSS gf180mcu_fd_sc_mcu9t5v0__fill_2
* cell instance gf180mcu_fd_sc_mcu9t5v0__fill_2_91 r0 *1 0,0
Xgf180mcu_fd_sc_mcu9t5v0__fill_2_91 VDD VSS gf180mcu_fd_sc_mcu9t5v0__fill_2
* cell instance gf180mcu_fd_sc_mcu9t5v0__fill_2_92 r0 *1 0,0
Xgf180mcu_fd_sc_mcu9t5v0__fill_2_92 VDD VSS gf180mcu_fd_sc_mcu9t5v0__fill_2
* cell instance gf180mcu_fd_sc_mcu9t5v0__fill_2_93 r0 *1 0,0
Xgf180mcu_fd_sc_mcu9t5v0__fill_2_93 VDD VSS gf180mcu_fd_sc_mcu9t5v0__fill_2
* cell instance gf180mcu_fd_sc_mcu9t5v0__fill_2_94 r0 *1 0,0
Xgf180mcu_fd_sc_mcu9t5v0__fill_2_94 VDD VSS gf180mcu_fd_sc_mcu9t5v0__fill_2
* cell instance gf180mcu_fd_sc_mcu9t5v0__fill_2_95 r0 *1 0,0
Xgf180mcu_fd_sc_mcu9t5v0__fill_2_95 VDD VSS gf180mcu_fd_sc_mcu9t5v0__fill_2
* cell instance gf180mcu_fd_sc_mcu9t5v0__fill_2_96 r0 *1 0,0
Xgf180mcu_fd_sc_mcu9t5v0__fill_2_96 VDD VSS gf180mcu_fd_sc_mcu9t5v0__fill_2
* cell instance gf180mcu_fd_sc_mcu9t5v0__fill_2_97 r0 *1 0,0
Xgf180mcu_fd_sc_mcu9t5v0__fill_2_97 VDD VSS gf180mcu_fd_sc_mcu9t5v0__fill_2
* cell instance gf180mcu_fd_sc_mcu9t5v0__fill_2_98 r0 *1 0,0
Xgf180mcu_fd_sc_mcu9t5v0__fill_2_98 VDD VSS gf180mcu_fd_sc_mcu9t5v0__fill_2
* cell instance gf180mcu_fd_sc_mcu9t5v0__fill_2_99 r0 *1 0,0
Xgf180mcu_fd_sc_mcu9t5v0__fill_2_99 VDD VSS gf180mcu_fd_sc_mcu9t5v0__fill_2
* cell instance gf180mcu_fd_sc_mcu9t5v0__fill_2_100 r0 *1 0,0
Xgf180mcu_fd_sc_mcu9t5v0__fill_2_100 VDD VSS gf180mcu_fd_sc_mcu9t5v0__fill_2
* cell instance gf180mcu_fd_sc_mcu9t5v0__fill_2_101 r0 *1 0,0
Xgf180mcu_fd_sc_mcu9t5v0__fill_2_101 VDD VSS gf180mcu_fd_sc_mcu9t5v0__fill_2
* cell instance gf180mcu_fd_sc_mcu9t5v0__fill_2_102 r0 *1 0,0
Xgf180mcu_fd_sc_mcu9t5v0__fill_2_102 VDD VSS gf180mcu_fd_sc_mcu9t5v0__fill_2
* cell instance gf180mcu_fd_sc_mcu9t5v0__fill_2_103 r0 *1 0,0
Xgf180mcu_fd_sc_mcu9t5v0__fill_2_103 VDD VSS gf180mcu_fd_sc_mcu9t5v0__fill_2
* cell instance gf180mcu_fd_sc_mcu9t5v0__fill_2_104 r0 *1 0,0
Xgf180mcu_fd_sc_mcu9t5v0__fill_2_104 VDD VSS gf180mcu_fd_sc_mcu9t5v0__fill_2
* cell instance gf180mcu_fd_sc_mcu9t5v0__fill_2_105 r0 *1 0,0
Xgf180mcu_fd_sc_mcu9t5v0__fill_2_105 VDD VSS gf180mcu_fd_sc_mcu9t5v0__fill_2
* cell instance gf180mcu_fd_sc_mcu9t5v0__fill_2_106 r0 *1 0,0
Xgf180mcu_fd_sc_mcu9t5v0__fill_2_106 VDD VSS gf180mcu_fd_sc_mcu9t5v0__fill_2
* cell instance gf180mcu_fd_sc_mcu9t5v0__fill_2_107 r0 *1 0,0
Xgf180mcu_fd_sc_mcu9t5v0__fill_2_107 VDD VSS gf180mcu_fd_sc_mcu9t5v0__fill_2
* cell instance gf180mcu_fd_sc_mcu9t5v0__fill_2_108 r0 *1 0,0
Xgf180mcu_fd_sc_mcu9t5v0__fill_2_108 VDD VSS gf180mcu_fd_sc_mcu9t5v0__fill_2
* cell instance gf180mcu_fd_sc_mcu9t5v0__fill_2_109 r0 *1 0,0
Xgf180mcu_fd_sc_mcu9t5v0__fill_2_109 VDD VSS gf180mcu_fd_sc_mcu9t5v0__fill_2
* cell instance gf180mcu_fd_sc_mcu9t5v0__fill_2_110 r0 *1 0,0
Xgf180mcu_fd_sc_mcu9t5v0__fill_2_110 VDD VSS gf180mcu_fd_sc_mcu9t5v0__fill_2
* cell instance gf180mcu_fd_sc_mcu9t5v0__fill_2_111 r0 *1 0,0
Xgf180mcu_fd_sc_mcu9t5v0__fill_2_111 VDD VSS gf180mcu_fd_sc_mcu9t5v0__fill_2
* cell instance gf180mcu_fd_sc_mcu9t5v0__fill_2_112 r0 *1 0,0
Xgf180mcu_fd_sc_mcu9t5v0__fill_2_112 VDD VSS gf180mcu_fd_sc_mcu9t5v0__fill_2
* cell instance gf180mcu_fd_sc_mcu9t5v0__fill_2_113 r0 *1 0,0
Xgf180mcu_fd_sc_mcu9t5v0__fill_2_113 VDD VSS gf180mcu_fd_sc_mcu9t5v0__fill_2
* cell instance gf180mcu_fd_sc_mcu9t5v0__fill_2_114 r0 *1 0,0
Xgf180mcu_fd_sc_mcu9t5v0__fill_2_114 VDD VSS gf180mcu_fd_sc_mcu9t5v0__fill_2
* cell instance gf180mcu_fd_sc_mcu9t5v0__fill_2_115 r0 *1 0,0
Xgf180mcu_fd_sc_mcu9t5v0__fill_2_115 VDD VSS gf180mcu_fd_sc_mcu9t5v0__fill_2
* cell instance gf180mcu_fd_sc_mcu9t5v0__fill_2_116 r0 *1 0,0
Xgf180mcu_fd_sc_mcu9t5v0__fill_2_116 VDD VSS gf180mcu_fd_sc_mcu9t5v0__fill_2
* cell instance gf180mcu_fd_sc_mcu9t5v0__fill_2_117 r0 *1 0,0
Xgf180mcu_fd_sc_mcu9t5v0__fill_2_117 VDD VSS gf180mcu_fd_sc_mcu9t5v0__fill_2
* cell instance gf180mcu_fd_sc_mcu9t5v0__fill_2_118 r0 *1 0,0
Xgf180mcu_fd_sc_mcu9t5v0__fill_2_118 VDD VSS gf180mcu_fd_sc_mcu9t5v0__fill_2
* cell instance gf180mcu_fd_sc_mcu9t5v0__fill_2_119 r0 *1 0,0
Xgf180mcu_fd_sc_mcu9t5v0__fill_2_119 VDD VSS gf180mcu_fd_sc_mcu9t5v0__fill_2
* cell instance gf180mcu_fd_sc_mcu9t5v0__fill_2_120 r0 *1 0,0
Xgf180mcu_fd_sc_mcu9t5v0__fill_2_120 VDD VSS gf180mcu_fd_sc_mcu9t5v0__fill_2
* cell instance gf180mcu_fd_sc_mcu9t5v0__fill_2_121 r0 *1 0,0
Xgf180mcu_fd_sc_mcu9t5v0__fill_2_121 VDD VSS gf180mcu_fd_sc_mcu9t5v0__fill_2
* cell instance gf180mcu_fd_sc_mcu9t5v0__fill_2_122 r0 *1 0,0
Xgf180mcu_fd_sc_mcu9t5v0__fill_2_122 VDD VSS gf180mcu_fd_sc_mcu9t5v0__fill_2
* cell instance gf180mcu_fd_sc_mcu9t5v0__fill_2_123 r0 *1 0,0
Xgf180mcu_fd_sc_mcu9t5v0__fill_2_123 VDD VSS gf180mcu_fd_sc_mcu9t5v0__fill_2
* cell instance gf180mcu_fd_sc_mcu9t5v0__fill_2_124 r0 *1 0,0
Xgf180mcu_fd_sc_mcu9t5v0__fill_2_124 VDD VSS gf180mcu_fd_sc_mcu9t5v0__fill_2
* cell instance gf180mcu_fd_sc_mcu9t5v0__fill_2_125 r0 *1 0,0
Xgf180mcu_fd_sc_mcu9t5v0__fill_2_125 VDD VSS gf180mcu_fd_sc_mcu9t5v0__fill_2
* cell instance gf180mcu_fd_sc_mcu9t5v0__fill_2_126 r0 *1 0,0
Xgf180mcu_fd_sc_mcu9t5v0__fill_2_126 VDD VSS gf180mcu_fd_sc_mcu9t5v0__fill_2
* cell instance gf180mcu_fd_sc_mcu9t5v0__fill_2_127 r0 *1 0,0
Xgf180mcu_fd_sc_mcu9t5v0__fill_2_127 VDD VSS gf180mcu_fd_sc_mcu9t5v0__fill_2
* cell instance gf180mcu_fd_sc_mcu9t5v0__fill_2_128 r0 *1 0,0
Xgf180mcu_fd_sc_mcu9t5v0__fill_2_128 VDD VSS gf180mcu_fd_sc_mcu9t5v0__fill_2
* cell instance gf180mcu_fd_sc_mcu9t5v0__fill_2_129 r0 *1 0,0
Xgf180mcu_fd_sc_mcu9t5v0__fill_2_129 VDD VSS gf180mcu_fd_sc_mcu9t5v0__fill_2
* cell instance gf180mcu_fd_sc_mcu9t5v0__fill_2_130 r0 *1 0,0
Xgf180mcu_fd_sc_mcu9t5v0__fill_2_130 VDD VSS gf180mcu_fd_sc_mcu9t5v0__fill_2
* cell instance gf180mcu_fd_sc_mcu9t5v0__fill_2_131 r0 *1 0,0
Xgf180mcu_fd_sc_mcu9t5v0__fill_2_131 VDD VSS gf180mcu_fd_sc_mcu9t5v0__fill_2
* cell instance gf180mcu_fd_sc_mcu9t5v0__fill_2_132 r0 *1 0,0
Xgf180mcu_fd_sc_mcu9t5v0__fill_2_132 VDD VSS gf180mcu_fd_sc_mcu9t5v0__fill_2
* cell instance gf180mcu_fd_sc_mcu9t5v0__fill_2_133 r0 *1 0,0
Xgf180mcu_fd_sc_mcu9t5v0__fill_2_133 VDD VSS gf180mcu_fd_sc_mcu9t5v0__fill_2
* cell instance gf180mcu_fd_sc_mcu9t5v0__fill_2_134 r0 *1 0,0
Xgf180mcu_fd_sc_mcu9t5v0__fill_2_134 VDD VSS gf180mcu_fd_sc_mcu9t5v0__fill_2
* cell instance gf180mcu_fd_sc_mcu9t5v0__fill_2_135 r0 *1 0,0
Xgf180mcu_fd_sc_mcu9t5v0__fill_2_135 VDD VSS gf180mcu_fd_sc_mcu9t5v0__fill_2
* cell instance gf180mcu_fd_sc_mcu9t5v0__fill_2_136 r0 *1 0,0
Xgf180mcu_fd_sc_mcu9t5v0__fill_2_136 VDD VSS gf180mcu_fd_sc_mcu9t5v0__fill_2
* cell instance gf180mcu_fd_sc_mcu9t5v0__fill_2_137 r0 *1 0,0
Xgf180mcu_fd_sc_mcu9t5v0__fill_2_137 VDD VSS gf180mcu_fd_sc_mcu9t5v0__fill_2
* cell instance gf180mcu_fd_sc_mcu9t5v0__fill_2_138 r0 *1 0,0
Xgf180mcu_fd_sc_mcu9t5v0__fill_2_138 VDD VSS gf180mcu_fd_sc_mcu9t5v0__fill_2
* cell instance gf180mcu_fd_sc_mcu9t5v0__fill_2_139 r0 *1 0,0
Xgf180mcu_fd_sc_mcu9t5v0__fill_2_139 VDD VSS gf180mcu_fd_sc_mcu9t5v0__fill_2
* cell instance gf180mcu_fd_sc_mcu9t5v0__fill_2_140 r0 *1 0,0
Xgf180mcu_fd_sc_mcu9t5v0__fill_2_140 VDD VSS gf180mcu_fd_sc_mcu9t5v0__fill_2
* cell instance gf180mcu_fd_sc_mcu9t5v0__fill_2_141 r0 *1 0,0
Xgf180mcu_fd_sc_mcu9t5v0__fill_2_141 VDD VSS gf180mcu_fd_sc_mcu9t5v0__fill_2
* cell instance gf180mcu_fd_sc_mcu9t5v0__fill_32_0 r0 *1 0,0
Xgf180mcu_fd_sc_mcu9t5v0__fill_32_0 VDD VSS gf180mcu_fd_sc_mcu9t5v0__fill_32
* cell instance gf180mcu_fd_sc_mcu9t5v0__fill_32_1 r0 *1 0,0
Xgf180mcu_fd_sc_mcu9t5v0__fill_32_1 VDD VSS gf180mcu_fd_sc_mcu9t5v0__fill_32
* cell instance gf180mcu_fd_sc_mcu9t5v0__fill_32_2 r0 *1 0,0
Xgf180mcu_fd_sc_mcu9t5v0__fill_32_2 VDD VSS gf180mcu_fd_sc_mcu9t5v0__fill_32
* cell instance gf180mcu_fd_sc_mcu9t5v0__fill_32_3 r0 *1 0,0
Xgf180mcu_fd_sc_mcu9t5v0__fill_32_3 VDD VSS gf180mcu_fd_sc_mcu9t5v0__fill_32
* cell instance gf180mcu_fd_sc_mcu9t5v0__fill_32_4 r0 *1 0,0
Xgf180mcu_fd_sc_mcu9t5v0__fill_32_4 VDD VSS gf180mcu_fd_sc_mcu9t5v0__fill_32
* cell instance gf180mcu_fd_sc_mcu9t5v0__fill_32_5 r0 *1 0,0
Xgf180mcu_fd_sc_mcu9t5v0__fill_32_5 VDD VSS gf180mcu_fd_sc_mcu9t5v0__fill_32
* cell instance gf180mcu_fd_sc_mcu9t5v0__fill_32_6 r0 *1 0,0
Xgf180mcu_fd_sc_mcu9t5v0__fill_32_6 VDD VSS gf180mcu_fd_sc_mcu9t5v0__fill_32
* cell instance gf180mcu_fd_sc_mcu9t5v0__fill_32_7 r0 *1 0,0
Xgf180mcu_fd_sc_mcu9t5v0__fill_32_7 VDD VSS gf180mcu_fd_sc_mcu9t5v0__fill_32
* cell instance gf180mcu_fd_sc_mcu9t5v0__fill_32_8 r0 *1 0,0
Xgf180mcu_fd_sc_mcu9t5v0__fill_32_8 VDD VSS gf180mcu_fd_sc_mcu9t5v0__fill_32
* cell instance gf180mcu_fd_sc_mcu9t5v0__fill_32_9 r0 *1 0,0
Xgf180mcu_fd_sc_mcu9t5v0__fill_32_9 VDD VSS gf180mcu_fd_sc_mcu9t5v0__fill_32
* cell instance gf180mcu_fd_sc_mcu9t5v0__fill_32_10 r0 *1 0,0
Xgf180mcu_fd_sc_mcu9t5v0__fill_32_10 VDD VSS gf180mcu_fd_sc_mcu9t5v0__fill_32
* cell instance gf180mcu_fd_sc_mcu9t5v0__fill_32_11 r0 *1 0,0
Xgf180mcu_fd_sc_mcu9t5v0__fill_32_11 VDD VSS gf180mcu_fd_sc_mcu9t5v0__fill_32
* cell instance gf180mcu_fd_sc_mcu9t5v0__fill_32_12 r0 *1 0,0
Xgf180mcu_fd_sc_mcu9t5v0__fill_32_12 VDD VSS gf180mcu_fd_sc_mcu9t5v0__fill_32
* cell instance gf180mcu_fd_sc_mcu9t5v0__fill_32_13 r0 *1 0,0
Xgf180mcu_fd_sc_mcu9t5v0__fill_32_13 VDD VSS gf180mcu_fd_sc_mcu9t5v0__fill_32
* cell instance gf180mcu_fd_sc_mcu9t5v0__fill_32_14 r0 *1 0,0
Xgf180mcu_fd_sc_mcu9t5v0__fill_32_14 VDD VSS gf180mcu_fd_sc_mcu9t5v0__fill_32
* cell instance gf180mcu_fd_sc_mcu9t5v0__fill_32_15 r0 *1 0,0
Xgf180mcu_fd_sc_mcu9t5v0__fill_32_15 VDD VSS gf180mcu_fd_sc_mcu9t5v0__fill_32
* cell instance gf180mcu_fd_sc_mcu9t5v0__fill_32_16 r0 *1 0,0
Xgf180mcu_fd_sc_mcu9t5v0__fill_32_16 VDD VSS gf180mcu_fd_sc_mcu9t5v0__fill_32
* cell instance gf180mcu_fd_sc_mcu9t5v0__fill_32_17 r0 *1 0,0
Xgf180mcu_fd_sc_mcu9t5v0__fill_32_17 VDD VSS gf180mcu_fd_sc_mcu9t5v0__fill_32
* cell instance gf180mcu_fd_sc_mcu9t5v0__fill_32_18 r0 *1 0,0
Xgf180mcu_fd_sc_mcu9t5v0__fill_32_18 VDD VSS gf180mcu_fd_sc_mcu9t5v0__fill_32
* cell instance gf180mcu_fd_sc_mcu9t5v0__fill_32_19 r0 *1 0,0
Xgf180mcu_fd_sc_mcu9t5v0__fill_32_19 VDD VSS gf180mcu_fd_sc_mcu9t5v0__fill_32
* cell instance gf180mcu_fd_sc_mcu9t5v0__fill_32_20 r0 *1 0,0
Xgf180mcu_fd_sc_mcu9t5v0__fill_32_20 VDD VSS gf180mcu_fd_sc_mcu9t5v0__fill_32
* cell instance gf180mcu_fd_sc_mcu9t5v0__fill_32_21 r0 *1 0,0
Xgf180mcu_fd_sc_mcu9t5v0__fill_32_21 VDD VSS gf180mcu_fd_sc_mcu9t5v0__fill_32
* cell instance gf180mcu_fd_sc_mcu9t5v0__fill_32_22 r0 *1 0,0
Xgf180mcu_fd_sc_mcu9t5v0__fill_32_22 VDD VSS gf180mcu_fd_sc_mcu9t5v0__fill_32
* cell instance gf180mcu_fd_sc_mcu9t5v0__fill_32_23 r0 *1 0,0
Xgf180mcu_fd_sc_mcu9t5v0__fill_32_23 VDD VSS gf180mcu_fd_sc_mcu9t5v0__fill_32
* cell instance gf180mcu_fd_sc_mcu9t5v0__fill_32_24 r0 *1 0,0
Xgf180mcu_fd_sc_mcu9t5v0__fill_32_24 VDD VSS gf180mcu_fd_sc_mcu9t5v0__fill_32
* cell instance gf180mcu_fd_sc_mcu9t5v0__fill_32_25 r0 *1 0,0
Xgf180mcu_fd_sc_mcu9t5v0__fill_32_25 VDD VSS gf180mcu_fd_sc_mcu9t5v0__fill_32
* cell instance gf180mcu_fd_sc_mcu9t5v0__fill_32_26 r0 *1 0,0
Xgf180mcu_fd_sc_mcu9t5v0__fill_32_26 VDD VSS gf180mcu_fd_sc_mcu9t5v0__fill_32
* cell instance gf180mcu_fd_sc_mcu9t5v0__fill_4_0 r0 *1 0,0
Xgf180mcu_fd_sc_mcu9t5v0__fill_4_0 VDD VSS gf180mcu_fd_sc_mcu9t5v0__fill_4
* cell instance gf180mcu_fd_sc_mcu9t5v0__fill_4_1 r0 *1 0,0
Xgf180mcu_fd_sc_mcu9t5v0__fill_4_1 VDD VSS gf180mcu_fd_sc_mcu9t5v0__fill_4
* cell instance gf180mcu_fd_sc_mcu9t5v0__fill_4_2 r0 *1 0,0
Xgf180mcu_fd_sc_mcu9t5v0__fill_4_2 VDD VSS gf180mcu_fd_sc_mcu9t5v0__fill_4
* cell instance gf180mcu_fd_sc_mcu9t5v0__fill_4_3 r0 *1 0,0
Xgf180mcu_fd_sc_mcu9t5v0__fill_4_3 VDD VSS gf180mcu_fd_sc_mcu9t5v0__fill_4
* cell instance gf180mcu_fd_sc_mcu9t5v0__fill_4_4 r0 *1 0,0
Xgf180mcu_fd_sc_mcu9t5v0__fill_4_4 VDD VSS gf180mcu_fd_sc_mcu9t5v0__fill_4
* cell instance gf180mcu_fd_sc_mcu9t5v0__fill_4_5 r0 *1 0,0
Xgf180mcu_fd_sc_mcu9t5v0__fill_4_5 VDD VSS gf180mcu_fd_sc_mcu9t5v0__fill_4
* cell instance gf180mcu_fd_sc_mcu9t5v0__fill_4_6 r0 *1 0,0
Xgf180mcu_fd_sc_mcu9t5v0__fill_4_6 VDD VSS gf180mcu_fd_sc_mcu9t5v0__fill_4
* cell instance gf180mcu_fd_sc_mcu9t5v0__fill_4_7 r0 *1 0,0
Xgf180mcu_fd_sc_mcu9t5v0__fill_4_7 VDD VSS gf180mcu_fd_sc_mcu9t5v0__fill_4
* cell instance gf180mcu_fd_sc_mcu9t5v0__fill_4_8 r0 *1 0,0
Xgf180mcu_fd_sc_mcu9t5v0__fill_4_8 VDD VSS gf180mcu_fd_sc_mcu9t5v0__fill_4
* cell instance gf180mcu_fd_sc_mcu9t5v0__fill_4_9 r0 *1 0,0
Xgf180mcu_fd_sc_mcu9t5v0__fill_4_9 VDD VSS gf180mcu_fd_sc_mcu9t5v0__fill_4
* cell instance gf180mcu_fd_sc_mcu9t5v0__fill_4_10 r0 *1 0,0
Xgf180mcu_fd_sc_mcu9t5v0__fill_4_10 VDD VSS gf180mcu_fd_sc_mcu9t5v0__fill_4
* cell instance gf180mcu_fd_sc_mcu9t5v0__fill_4_11 r0 *1 0,0
Xgf180mcu_fd_sc_mcu9t5v0__fill_4_11 VDD VSS gf180mcu_fd_sc_mcu9t5v0__fill_4
* cell instance gf180mcu_fd_sc_mcu9t5v0__fill_4_12 r0 *1 0,0
Xgf180mcu_fd_sc_mcu9t5v0__fill_4_12 VDD VSS gf180mcu_fd_sc_mcu9t5v0__fill_4
* cell instance gf180mcu_fd_sc_mcu9t5v0__fill_4_13 r0 *1 0,0
Xgf180mcu_fd_sc_mcu9t5v0__fill_4_13 VDD VSS gf180mcu_fd_sc_mcu9t5v0__fill_4
* cell instance gf180mcu_fd_sc_mcu9t5v0__fill_4_14 r0 *1 0,0
Xgf180mcu_fd_sc_mcu9t5v0__fill_4_14 VDD VSS gf180mcu_fd_sc_mcu9t5v0__fill_4
* cell instance gf180mcu_fd_sc_mcu9t5v0__fill_4_15 r0 *1 0,0
Xgf180mcu_fd_sc_mcu9t5v0__fill_4_15 VDD VSS gf180mcu_fd_sc_mcu9t5v0__fill_4
* cell instance gf180mcu_fd_sc_mcu9t5v0__fill_4_16 r0 *1 0,0
Xgf180mcu_fd_sc_mcu9t5v0__fill_4_16 VDD VSS gf180mcu_fd_sc_mcu9t5v0__fill_4
* cell instance gf180mcu_fd_sc_mcu9t5v0__fill_4_17 r0 *1 0,0
Xgf180mcu_fd_sc_mcu9t5v0__fill_4_17 VDD VSS gf180mcu_fd_sc_mcu9t5v0__fill_4
* cell instance gf180mcu_fd_sc_mcu9t5v0__fill_4_18 r0 *1 0,0
Xgf180mcu_fd_sc_mcu9t5v0__fill_4_18 VDD VSS gf180mcu_fd_sc_mcu9t5v0__fill_4
* cell instance gf180mcu_fd_sc_mcu9t5v0__fill_4_19 r0 *1 0,0
Xgf180mcu_fd_sc_mcu9t5v0__fill_4_19 VDD VSS gf180mcu_fd_sc_mcu9t5v0__fill_4
* cell instance gf180mcu_fd_sc_mcu9t5v0__fill_4_20 r0 *1 0,0
Xgf180mcu_fd_sc_mcu9t5v0__fill_4_20 VDD VSS gf180mcu_fd_sc_mcu9t5v0__fill_4
* cell instance gf180mcu_fd_sc_mcu9t5v0__fill_4_21 r0 *1 0,0
Xgf180mcu_fd_sc_mcu9t5v0__fill_4_21 VDD VSS gf180mcu_fd_sc_mcu9t5v0__fill_4
* cell instance gf180mcu_fd_sc_mcu9t5v0__fill_4_22 r0 *1 0,0
Xgf180mcu_fd_sc_mcu9t5v0__fill_4_22 VDD VSS gf180mcu_fd_sc_mcu9t5v0__fill_4
* cell instance gf180mcu_fd_sc_mcu9t5v0__fill_4_23 r0 *1 0,0
Xgf180mcu_fd_sc_mcu9t5v0__fill_4_23 VDD VSS gf180mcu_fd_sc_mcu9t5v0__fill_4
* cell instance gf180mcu_fd_sc_mcu9t5v0__fill_4_24 r0 *1 0,0
Xgf180mcu_fd_sc_mcu9t5v0__fill_4_24 VDD VSS gf180mcu_fd_sc_mcu9t5v0__fill_4
* cell instance gf180mcu_fd_sc_mcu9t5v0__fill_4_25 r0 *1 0,0
Xgf180mcu_fd_sc_mcu9t5v0__fill_4_25 VDD VSS gf180mcu_fd_sc_mcu9t5v0__fill_4
* cell instance gf180mcu_fd_sc_mcu9t5v0__fill_4_26 r0 *1 0,0
Xgf180mcu_fd_sc_mcu9t5v0__fill_4_26 VDD VSS gf180mcu_fd_sc_mcu9t5v0__fill_4
* cell instance gf180mcu_fd_sc_mcu9t5v0__fill_4_27 r0 *1 0,0
Xgf180mcu_fd_sc_mcu9t5v0__fill_4_27 VDD VSS gf180mcu_fd_sc_mcu9t5v0__fill_4
* cell instance gf180mcu_fd_sc_mcu9t5v0__fill_4_28 r0 *1 0,0
Xgf180mcu_fd_sc_mcu9t5v0__fill_4_28 VDD VSS gf180mcu_fd_sc_mcu9t5v0__fill_4
* cell instance gf180mcu_fd_sc_mcu9t5v0__fill_4_29 r0 *1 0,0
Xgf180mcu_fd_sc_mcu9t5v0__fill_4_29 VDD VSS gf180mcu_fd_sc_mcu9t5v0__fill_4
* cell instance gf180mcu_fd_sc_mcu9t5v0__fill_4_30 r0 *1 0,0
Xgf180mcu_fd_sc_mcu9t5v0__fill_4_30 VDD VSS gf180mcu_fd_sc_mcu9t5v0__fill_4
* cell instance gf180mcu_fd_sc_mcu9t5v0__fill_4_31 r0 *1 0,0
Xgf180mcu_fd_sc_mcu9t5v0__fill_4_31 VDD VSS gf180mcu_fd_sc_mcu9t5v0__fill_4
* cell instance gf180mcu_fd_sc_mcu9t5v0__fill_4_32 r0 *1 0,0
Xgf180mcu_fd_sc_mcu9t5v0__fill_4_32 VDD VSS gf180mcu_fd_sc_mcu9t5v0__fill_4
* cell instance gf180mcu_fd_sc_mcu9t5v0__fill_4_33 r0 *1 0,0
Xgf180mcu_fd_sc_mcu9t5v0__fill_4_33 VDD VSS gf180mcu_fd_sc_mcu9t5v0__fill_4
* cell instance gf180mcu_fd_sc_mcu9t5v0__fill_4_34 r0 *1 0,0
Xgf180mcu_fd_sc_mcu9t5v0__fill_4_34 VDD VSS gf180mcu_fd_sc_mcu9t5v0__fill_4
* cell instance gf180mcu_fd_sc_mcu9t5v0__fill_4_35 r0 *1 0,0
Xgf180mcu_fd_sc_mcu9t5v0__fill_4_35 VDD VSS gf180mcu_fd_sc_mcu9t5v0__fill_4
* cell instance gf180mcu_fd_sc_mcu9t5v0__fill_4_36 r0 *1 0,0
Xgf180mcu_fd_sc_mcu9t5v0__fill_4_36 VDD VSS gf180mcu_fd_sc_mcu9t5v0__fill_4
* cell instance gf180mcu_fd_sc_mcu9t5v0__fill_4_37 r0 *1 0,0
Xgf180mcu_fd_sc_mcu9t5v0__fill_4_37 VDD VSS gf180mcu_fd_sc_mcu9t5v0__fill_4
* cell instance gf180mcu_fd_sc_mcu9t5v0__fill_4_38 r0 *1 0,0
Xgf180mcu_fd_sc_mcu9t5v0__fill_4_38 VDD VSS gf180mcu_fd_sc_mcu9t5v0__fill_4
* cell instance gf180mcu_fd_sc_mcu9t5v0__fill_4_39 r0 *1 0,0
Xgf180mcu_fd_sc_mcu9t5v0__fill_4_39 VDD VSS gf180mcu_fd_sc_mcu9t5v0__fill_4
* cell instance gf180mcu_fd_sc_mcu9t5v0__fill_4_40 r0 *1 0,0
Xgf180mcu_fd_sc_mcu9t5v0__fill_4_40 VDD VSS gf180mcu_fd_sc_mcu9t5v0__fill_4
* cell instance gf180mcu_fd_sc_mcu9t5v0__fill_4_41 r0 *1 0,0
Xgf180mcu_fd_sc_mcu9t5v0__fill_4_41 VDD VSS gf180mcu_fd_sc_mcu9t5v0__fill_4
* cell instance gf180mcu_fd_sc_mcu9t5v0__fill_4_42 r0 *1 0,0
Xgf180mcu_fd_sc_mcu9t5v0__fill_4_42 VDD VSS gf180mcu_fd_sc_mcu9t5v0__fill_4
* cell instance gf180mcu_fd_sc_mcu9t5v0__fill_4_43 r0 *1 0,0
Xgf180mcu_fd_sc_mcu9t5v0__fill_4_43 VDD VSS gf180mcu_fd_sc_mcu9t5v0__fill_4
* cell instance gf180mcu_fd_sc_mcu9t5v0__fill_4_44 r0 *1 0,0
Xgf180mcu_fd_sc_mcu9t5v0__fill_4_44 VDD VSS gf180mcu_fd_sc_mcu9t5v0__fill_4
* cell instance gf180mcu_fd_sc_mcu9t5v0__fill_4_45 r0 *1 0,0
Xgf180mcu_fd_sc_mcu9t5v0__fill_4_45 VDD VSS gf180mcu_fd_sc_mcu9t5v0__fill_4
* cell instance gf180mcu_fd_sc_mcu9t5v0__fill_4_46 r0 *1 0,0
Xgf180mcu_fd_sc_mcu9t5v0__fill_4_46 VDD VSS gf180mcu_fd_sc_mcu9t5v0__fill_4
* cell instance gf180mcu_fd_sc_mcu9t5v0__fill_4_47 r0 *1 0,0
Xgf180mcu_fd_sc_mcu9t5v0__fill_4_47 VDD VSS gf180mcu_fd_sc_mcu9t5v0__fill_4
* cell instance gf180mcu_fd_sc_mcu9t5v0__fill_4_48 r0 *1 0,0
Xgf180mcu_fd_sc_mcu9t5v0__fill_4_48 VDD VSS gf180mcu_fd_sc_mcu9t5v0__fill_4
* cell instance gf180mcu_fd_sc_mcu9t5v0__fill_4_49 r0 *1 0,0
Xgf180mcu_fd_sc_mcu9t5v0__fill_4_49 VDD VSS gf180mcu_fd_sc_mcu9t5v0__fill_4
* cell instance gf180mcu_fd_sc_mcu9t5v0__fill_4_50 r0 *1 0,0
Xgf180mcu_fd_sc_mcu9t5v0__fill_4_50 VDD VSS gf180mcu_fd_sc_mcu9t5v0__fill_4
* cell instance gf180mcu_fd_sc_mcu9t5v0__fill_4_51 r0 *1 0,0
Xgf180mcu_fd_sc_mcu9t5v0__fill_4_51 VDD VSS gf180mcu_fd_sc_mcu9t5v0__fill_4
* cell instance gf180mcu_fd_sc_mcu9t5v0__fill_4_52 r0 *1 0,0
Xgf180mcu_fd_sc_mcu9t5v0__fill_4_52 VDD VSS gf180mcu_fd_sc_mcu9t5v0__fill_4
* cell instance gf180mcu_fd_sc_mcu9t5v0__fill_4_53 r0 *1 0,0
Xgf180mcu_fd_sc_mcu9t5v0__fill_4_53 VDD VSS gf180mcu_fd_sc_mcu9t5v0__fill_4
* cell instance gf180mcu_fd_sc_mcu9t5v0__fill_4_54 r0 *1 0,0
Xgf180mcu_fd_sc_mcu9t5v0__fill_4_54 VDD VSS gf180mcu_fd_sc_mcu9t5v0__fill_4
* cell instance gf180mcu_fd_sc_mcu9t5v0__fill_4_55 r0 *1 0,0
Xgf180mcu_fd_sc_mcu9t5v0__fill_4_55 VDD VSS gf180mcu_fd_sc_mcu9t5v0__fill_4
* cell instance gf180mcu_fd_sc_mcu9t5v0__fill_4_56 r0 *1 0,0
Xgf180mcu_fd_sc_mcu9t5v0__fill_4_56 VDD VSS gf180mcu_fd_sc_mcu9t5v0__fill_4
* cell instance gf180mcu_fd_sc_mcu9t5v0__fill_4_57 r0 *1 0,0
Xgf180mcu_fd_sc_mcu9t5v0__fill_4_57 VDD VSS gf180mcu_fd_sc_mcu9t5v0__fill_4
* cell instance gf180mcu_fd_sc_mcu9t5v0__fill_4_58 r0 *1 0,0
Xgf180mcu_fd_sc_mcu9t5v0__fill_4_58 VDD VSS gf180mcu_fd_sc_mcu9t5v0__fill_4
* cell instance gf180mcu_fd_sc_mcu9t5v0__fill_4_59 r0 *1 0,0
Xgf180mcu_fd_sc_mcu9t5v0__fill_4_59 VDD VSS gf180mcu_fd_sc_mcu9t5v0__fill_4
* cell instance gf180mcu_fd_sc_mcu9t5v0__fill_4_60 r0 *1 0,0
Xgf180mcu_fd_sc_mcu9t5v0__fill_4_60 VDD VSS gf180mcu_fd_sc_mcu9t5v0__fill_4
* cell instance gf180mcu_fd_sc_mcu9t5v0__fill_4_61 r0 *1 0,0
Xgf180mcu_fd_sc_mcu9t5v0__fill_4_61 VDD VSS gf180mcu_fd_sc_mcu9t5v0__fill_4
* cell instance gf180mcu_fd_sc_mcu9t5v0__fill_4_62 r0 *1 0,0
Xgf180mcu_fd_sc_mcu9t5v0__fill_4_62 VDD VSS gf180mcu_fd_sc_mcu9t5v0__fill_4
* cell instance gf180mcu_fd_sc_mcu9t5v0__fill_4_63 r0 *1 0,0
Xgf180mcu_fd_sc_mcu9t5v0__fill_4_63 VDD VSS gf180mcu_fd_sc_mcu9t5v0__fill_4
* cell instance gf180mcu_fd_sc_mcu9t5v0__fill_4_64 r0 *1 0,0
Xgf180mcu_fd_sc_mcu9t5v0__fill_4_64 VDD VSS gf180mcu_fd_sc_mcu9t5v0__fill_4
* cell instance gf180mcu_fd_sc_mcu9t5v0__fill_4_65 r0 *1 0,0
Xgf180mcu_fd_sc_mcu9t5v0__fill_4_65 VDD VSS gf180mcu_fd_sc_mcu9t5v0__fill_4
* cell instance gf180mcu_fd_sc_mcu9t5v0__fill_4_66 r0 *1 0,0
Xgf180mcu_fd_sc_mcu9t5v0__fill_4_66 VDD VSS gf180mcu_fd_sc_mcu9t5v0__fill_4
* cell instance gf180mcu_fd_sc_mcu9t5v0__fill_4_67 r0 *1 0,0
Xgf180mcu_fd_sc_mcu9t5v0__fill_4_67 VDD VSS gf180mcu_fd_sc_mcu9t5v0__fill_4
* cell instance gf180mcu_fd_sc_mcu9t5v0__fill_4_68 r0 *1 0,0
Xgf180mcu_fd_sc_mcu9t5v0__fill_4_68 VDD VSS gf180mcu_fd_sc_mcu9t5v0__fill_4
* cell instance gf180mcu_fd_sc_mcu9t5v0__fill_4_69 r0 *1 0,0
Xgf180mcu_fd_sc_mcu9t5v0__fill_4_69 VDD VSS gf180mcu_fd_sc_mcu9t5v0__fill_4
* cell instance gf180mcu_fd_sc_mcu9t5v0__fill_4_70 r0 *1 0,0
Xgf180mcu_fd_sc_mcu9t5v0__fill_4_70 VDD VSS gf180mcu_fd_sc_mcu9t5v0__fill_4
* cell instance gf180mcu_fd_sc_mcu9t5v0__fill_4_71 r0 *1 0,0
Xgf180mcu_fd_sc_mcu9t5v0__fill_4_71 VDD VSS gf180mcu_fd_sc_mcu9t5v0__fill_4
* cell instance gf180mcu_fd_sc_mcu9t5v0__fill_4_72 r0 *1 0,0
Xgf180mcu_fd_sc_mcu9t5v0__fill_4_72 VDD VSS gf180mcu_fd_sc_mcu9t5v0__fill_4
* cell instance gf180mcu_fd_sc_mcu9t5v0__fill_4_73 r0 *1 0,0
Xgf180mcu_fd_sc_mcu9t5v0__fill_4_73 VDD VSS gf180mcu_fd_sc_mcu9t5v0__fill_4
* cell instance gf180mcu_fd_sc_mcu9t5v0__fill_4_74 r0 *1 0,0
Xgf180mcu_fd_sc_mcu9t5v0__fill_4_74 VDD VSS gf180mcu_fd_sc_mcu9t5v0__fill_4
* cell instance gf180mcu_fd_sc_mcu9t5v0__fill_4_75 r0 *1 0,0
Xgf180mcu_fd_sc_mcu9t5v0__fill_4_75 VDD VSS gf180mcu_fd_sc_mcu9t5v0__fill_4
* cell instance gf180mcu_fd_sc_mcu9t5v0__fill_4_76 r0 *1 0,0
Xgf180mcu_fd_sc_mcu9t5v0__fill_4_76 VDD VSS gf180mcu_fd_sc_mcu9t5v0__fill_4
* cell instance gf180mcu_fd_sc_mcu9t5v0__fill_4_77 r0 *1 0,0
Xgf180mcu_fd_sc_mcu9t5v0__fill_4_77 VDD VSS gf180mcu_fd_sc_mcu9t5v0__fill_4
* cell instance gf180mcu_fd_sc_mcu9t5v0__fill_4_78 r0 *1 0,0
Xgf180mcu_fd_sc_mcu9t5v0__fill_4_78 VDD VSS gf180mcu_fd_sc_mcu9t5v0__fill_4
* cell instance gf180mcu_fd_sc_mcu9t5v0__fill_4_79 r0 *1 0,0
Xgf180mcu_fd_sc_mcu9t5v0__fill_4_79 VDD VSS gf180mcu_fd_sc_mcu9t5v0__fill_4
* cell instance gf180mcu_fd_sc_mcu9t5v0__fill_4_80 r0 *1 0,0
Xgf180mcu_fd_sc_mcu9t5v0__fill_4_80 VDD VSS gf180mcu_fd_sc_mcu9t5v0__fill_4
* cell instance gf180mcu_fd_sc_mcu9t5v0__fill_4_81 r0 *1 0,0
Xgf180mcu_fd_sc_mcu9t5v0__fill_4_81 VDD VSS gf180mcu_fd_sc_mcu9t5v0__fill_4
* cell instance gf180mcu_fd_sc_mcu9t5v0__fill_4_82 r0 *1 0,0
Xgf180mcu_fd_sc_mcu9t5v0__fill_4_82 VDD VSS gf180mcu_fd_sc_mcu9t5v0__fill_4
* cell instance gf180mcu_fd_sc_mcu9t5v0__fill_4_83 r0 *1 0,0
Xgf180mcu_fd_sc_mcu9t5v0__fill_4_83 VDD VSS gf180mcu_fd_sc_mcu9t5v0__fill_4
* cell instance gf180mcu_fd_sc_mcu9t5v0__fill_4_84 r0 *1 0,0
Xgf180mcu_fd_sc_mcu9t5v0__fill_4_84 VDD VSS gf180mcu_fd_sc_mcu9t5v0__fill_4
* cell instance gf180mcu_fd_sc_mcu9t5v0__fill_4_85 r0 *1 0,0
Xgf180mcu_fd_sc_mcu9t5v0__fill_4_85 VDD VSS gf180mcu_fd_sc_mcu9t5v0__fill_4
* cell instance gf180mcu_fd_sc_mcu9t5v0__fill_4_86 r0 *1 0,0
Xgf180mcu_fd_sc_mcu9t5v0__fill_4_86 VDD VSS gf180mcu_fd_sc_mcu9t5v0__fill_4
* cell instance gf180mcu_fd_sc_mcu9t5v0__fill_4_87 r0 *1 0,0
Xgf180mcu_fd_sc_mcu9t5v0__fill_4_87 VDD VSS gf180mcu_fd_sc_mcu9t5v0__fill_4
* cell instance gf180mcu_fd_sc_mcu9t5v0__fill_4_88 r0 *1 0,0
Xgf180mcu_fd_sc_mcu9t5v0__fill_4_88 VDD VSS gf180mcu_fd_sc_mcu9t5v0__fill_4
* cell instance gf180mcu_fd_sc_mcu9t5v0__fill_4_89 r0 *1 0,0
Xgf180mcu_fd_sc_mcu9t5v0__fill_4_89 VDD VSS gf180mcu_fd_sc_mcu9t5v0__fill_4
* cell instance gf180mcu_fd_sc_mcu9t5v0__fill_4_90 r0 *1 0,0
Xgf180mcu_fd_sc_mcu9t5v0__fill_4_90 VDD VSS gf180mcu_fd_sc_mcu9t5v0__fill_4
* cell instance gf180mcu_fd_sc_mcu9t5v0__fill_4_91 r0 *1 0,0
Xgf180mcu_fd_sc_mcu9t5v0__fill_4_91 VDD VSS gf180mcu_fd_sc_mcu9t5v0__fill_4
* cell instance gf180mcu_fd_sc_mcu9t5v0__fill_4_92 r0 *1 0,0
Xgf180mcu_fd_sc_mcu9t5v0__fill_4_92 VDD VSS gf180mcu_fd_sc_mcu9t5v0__fill_4
* cell instance gf180mcu_fd_sc_mcu9t5v0__fill_4_93 r0 *1 0,0
Xgf180mcu_fd_sc_mcu9t5v0__fill_4_93 VDD VSS gf180mcu_fd_sc_mcu9t5v0__fill_4
* cell instance gf180mcu_fd_sc_mcu9t5v0__fill_4_94 r0 *1 0,0
Xgf180mcu_fd_sc_mcu9t5v0__fill_4_94 VDD VSS gf180mcu_fd_sc_mcu9t5v0__fill_4
* cell instance gf180mcu_fd_sc_mcu9t5v0__fill_4_95 r0 *1 0,0
Xgf180mcu_fd_sc_mcu9t5v0__fill_4_95 VDD VSS gf180mcu_fd_sc_mcu9t5v0__fill_4
* cell instance gf180mcu_fd_sc_mcu9t5v0__fill_4_96 r0 *1 0,0
Xgf180mcu_fd_sc_mcu9t5v0__fill_4_96 VDD VSS gf180mcu_fd_sc_mcu9t5v0__fill_4
* cell instance gf180mcu_fd_sc_mcu9t5v0__fill_4_97 r0 *1 0,0
Xgf180mcu_fd_sc_mcu9t5v0__fill_4_97 VDD VSS gf180mcu_fd_sc_mcu9t5v0__fill_4
* cell instance gf180mcu_fd_sc_mcu9t5v0__fill_4_98 r0 *1 0,0
Xgf180mcu_fd_sc_mcu9t5v0__fill_4_98 VDD VSS gf180mcu_fd_sc_mcu9t5v0__fill_4
* cell instance gf180mcu_fd_sc_mcu9t5v0__fill_4_99 r0 *1 0,0
Xgf180mcu_fd_sc_mcu9t5v0__fill_4_99 VDD VSS gf180mcu_fd_sc_mcu9t5v0__fill_4
* cell instance gf180mcu_fd_sc_mcu9t5v0__fill_4_100 r0 *1 0,0
Xgf180mcu_fd_sc_mcu9t5v0__fill_4_100 VDD VSS gf180mcu_fd_sc_mcu9t5v0__fill_4
* cell instance gf180mcu_fd_sc_mcu9t5v0__fill_4_101 r0 *1 0,0
Xgf180mcu_fd_sc_mcu9t5v0__fill_4_101 VDD VSS gf180mcu_fd_sc_mcu9t5v0__fill_4
* cell instance gf180mcu_fd_sc_mcu9t5v0__fill_4_102 r0 *1 0,0
Xgf180mcu_fd_sc_mcu9t5v0__fill_4_102 VDD VSS gf180mcu_fd_sc_mcu9t5v0__fill_4
* cell instance gf180mcu_fd_sc_mcu9t5v0__fill_4_103 r0 *1 0,0
Xgf180mcu_fd_sc_mcu9t5v0__fill_4_103 VDD VSS gf180mcu_fd_sc_mcu9t5v0__fill_4
* cell instance gf180mcu_fd_sc_mcu9t5v0__fill_4_104 r0 *1 0,0
Xgf180mcu_fd_sc_mcu9t5v0__fill_4_104 VDD VSS gf180mcu_fd_sc_mcu9t5v0__fill_4
* cell instance gf180mcu_fd_sc_mcu9t5v0__fill_4_105 r0 *1 0,0
Xgf180mcu_fd_sc_mcu9t5v0__fill_4_105 VDD VSS gf180mcu_fd_sc_mcu9t5v0__fill_4
* cell instance gf180mcu_fd_sc_mcu9t5v0__fill_4_106 r0 *1 0,0
Xgf180mcu_fd_sc_mcu9t5v0__fill_4_106 VDD VSS gf180mcu_fd_sc_mcu9t5v0__fill_4
* cell instance gf180mcu_fd_sc_mcu9t5v0__fill_4_107 r0 *1 0,0
Xgf180mcu_fd_sc_mcu9t5v0__fill_4_107 VDD VSS gf180mcu_fd_sc_mcu9t5v0__fill_4
* cell instance gf180mcu_fd_sc_mcu9t5v0__fill_4_108 r0 *1 0,0
Xgf180mcu_fd_sc_mcu9t5v0__fill_4_108 VDD VSS gf180mcu_fd_sc_mcu9t5v0__fill_4
* cell instance gf180mcu_fd_sc_mcu9t5v0__fill_4_109 r0 *1 0,0
Xgf180mcu_fd_sc_mcu9t5v0__fill_4_109 VDD VSS gf180mcu_fd_sc_mcu9t5v0__fill_4
* cell instance gf180mcu_fd_sc_mcu9t5v0__fill_4_110 r0 *1 0,0
Xgf180mcu_fd_sc_mcu9t5v0__fill_4_110 VDD VSS gf180mcu_fd_sc_mcu9t5v0__fill_4
* cell instance gf180mcu_fd_sc_mcu9t5v0__fill_4_111 r0 *1 0,0
Xgf180mcu_fd_sc_mcu9t5v0__fill_4_111 VDD VSS gf180mcu_fd_sc_mcu9t5v0__fill_4
* cell instance gf180mcu_fd_sc_mcu9t5v0__fill_4_112 r0 *1 0,0
Xgf180mcu_fd_sc_mcu9t5v0__fill_4_112 VDD VSS gf180mcu_fd_sc_mcu9t5v0__fill_4
* cell instance gf180mcu_fd_sc_mcu9t5v0__fill_4_113 r0 *1 0,0
Xgf180mcu_fd_sc_mcu9t5v0__fill_4_113 VDD VSS gf180mcu_fd_sc_mcu9t5v0__fill_4
* cell instance gf180mcu_fd_sc_mcu9t5v0__fill_4_114 r0 *1 0,0
Xgf180mcu_fd_sc_mcu9t5v0__fill_4_114 VDD VSS gf180mcu_fd_sc_mcu9t5v0__fill_4
* cell instance gf180mcu_fd_sc_mcu9t5v0__fill_4_115 r0 *1 0,0
Xgf180mcu_fd_sc_mcu9t5v0__fill_4_115 VDD VSS gf180mcu_fd_sc_mcu9t5v0__fill_4
* cell instance gf180mcu_fd_sc_mcu9t5v0__fill_4_116 r0 *1 0,0
Xgf180mcu_fd_sc_mcu9t5v0__fill_4_116 VDD VSS gf180mcu_fd_sc_mcu9t5v0__fill_4
* cell instance gf180mcu_fd_sc_mcu9t5v0__fill_4_117 r0 *1 0,0
Xgf180mcu_fd_sc_mcu9t5v0__fill_4_117 VDD VSS gf180mcu_fd_sc_mcu9t5v0__fill_4
* cell instance gf180mcu_fd_sc_mcu9t5v0__fill_4_118 r0 *1 0,0
Xgf180mcu_fd_sc_mcu9t5v0__fill_4_118 VDD VSS gf180mcu_fd_sc_mcu9t5v0__fill_4
* cell instance gf180mcu_fd_sc_mcu9t5v0__fill_4_119 r0 *1 0,0
Xgf180mcu_fd_sc_mcu9t5v0__fill_4_119 VDD VSS gf180mcu_fd_sc_mcu9t5v0__fill_4
* cell instance gf180mcu_fd_sc_mcu9t5v0__fill_4_120 r0 *1 0,0
Xgf180mcu_fd_sc_mcu9t5v0__fill_4_120 VDD VSS gf180mcu_fd_sc_mcu9t5v0__fill_4
* cell instance gf180mcu_fd_sc_mcu9t5v0__fill_4_121 r0 *1 0,0
Xgf180mcu_fd_sc_mcu9t5v0__fill_4_121 VDD VSS gf180mcu_fd_sc_mcu9t5v0__fill_4
* cell instance gf180mcu_fd_sc_mcu9t5v0__fill_4_122 r0 *1 0,0
Xgf180mcu_fd_sc_mcu9t5v0__fill_4_122 VDD VSS gf180mcu_fd_sc_mcu9t5v0__fill_4
* cell instance gf180mcu_fd_sc_mcu9t5v0__fill_4_123 r0 *1 0,0
Xgf180mcu_fd_sc_mcu9t5v0__fill_4_123 VDD VSS gf180mcu_fd_sc_mcu9t5v0__fill_4
* cell instance gf180mcu_fd_sc_mcu9t5v0__fill_4_124 r0 *1 0,0
Xgf180mcu_fd_sc_mcu9t5v0__fill_4_124 VDD VSS gf180mcu_fd_sc_mcu9t5v0__fill_4
* cell instance gf180mcu_fd_sc_mcu9t5v0__fill_4_125 r0 *1 0,0
Xgf180mcu_fd_sc_mcu9t5v0__fill_4_125 VDD VSS gf180mcu_fd_sc_mcu9t5v0__fill_4
* cell instance gf180mcu_fd_sc_mcu9t5v0__fill_4_126 r0 *1 0,0
Xgf180mcu_fd_sc_mcu9t5v0__fill_4_126 VDD VSS gf180mcu_fd_sc_mcu9t5v0__fill_4
* cell instance gf180mcu_fd_sc_mcu9t5v0__fill_4_127 r0 *1 0,0
Xgf180mcu_fd_sc_mcu9t5v0__fill_4_127 VDD VSS gf180mcu_fd_sc_mcu9t5v0__fill_4
* cell instance gf180mcu_fd_sc_mcu9t5v0__fill_4_128 r0 *1 0,0
Xgf180mcu_fd_sc_mcu9t5v0__fill_4_128 VDD VSS gf180mcu_fd_sc_mcu9t5v0__fill_4
* cell instance gf180mcu_fd_sc_mcu9t5v0__fill_4_129 r0 *1 0,0
Xgf180mcu_fd_sc_mcu9t5v0__fill_4_129 VDD VSS gf180mcu_fd_sc_mcu9t5v0__fill_4
* cell instance gf180mcu_fd_sc_mcu9t5v0__fill_4_130 r0 *1 0,0
Xgf180mcu_fd_sc_mcu9t5v0__fill_4_130 VDD VSS gf180mcu_fd_sc_mcu9t5v0__fill_4
* cell instance gf180mcu_fd_sc_mcu9t5v0__fill_4_131 r0 *1 0,0
Xgf180mcu_fd_sc_mcu9t5v0__fill_4_131 VDD VSS gf180mcu_fd_sc_mcu9t5v0__fill_4
* cell instance gf180mcu_fd_sc_mcu9t5v0__fill_4_132 r0 *1 0,0
Xgf180mcu_fd_sc_mcu9t5v0__fill_4_132 VDD VSS gf180mcu_fd_sc_mcu9t5v0__fill_4
* cell instance gf180mcu_fd_sc_mcu9t5v0__fill_4_133 r0 *1 0,0
Xgf180mcu_fd_sc_mcu9t5v0__fill_4_133 VDD VSS gf180mcu_fd_sc_mcu9t5v0__fill_4
* cell instance gf180mcu_fd_sc_mcu9t5v0__fill_4_134 r0 *1 0,0
Xgf180mcu_fd_sc_mcu9t5v0__fill_4_134 VDD VSS gf180mcu_fd_sc_mcu9t5v0__fill_4
* cell instance gf180mcu_fd_sc_mcu9t5v0__fill_4_135 r0 *1 0,0
Xgf180mcu_fd_sc_mcu9t5v0__fill_4_135 VDD VSS gf180mcu_fd_sc_mcu9t5v0__fill_4
* cell instance gf180mcu_fd_sc_mcu9t5v0__fill_4_136 r0 *1 0,0
Xgf180mcu_fd_sc_mcu9t5v0__fill_4_136 VDD VSS gf180mcu_fd_sc_mcu9t5v0__fill_4
* cell instance gf180mcu_fd_sc_mcu9t5v0__fill_4_137 r0 *1 0,0
Xgf180mcu_fd_sc_mcu9t5v0__fill_4_137 VDD VSS gf180mcu_fd_sc_mcu9t5v0__fill_4
* cell instance gf180mcu_fd_sc_mcu9t5v0__fill_4_138 r0 *1 0,0
Xgf180mcu_fd_sc_mcu9t5v0__fill_4_138 VDD VSS gf180mcu_fd_sc_mcu9t5v0__fill_4
* cell instance gf180mcu_fd_sc_mcu9t5v0__fill_64_0 r0 *1 0,0
Xgf180mcu_fd_sc_mcu9t5v0__fill_64_0 VDD VSS gf180mcu_fd_sc_mcu9t5v0__fill_64
* cell instance gf180mcu_fd_sc_mcu9t5v0__fill_64_1 r0 *1 0,0
Xgf180mcu_fd_sc_mcu9t5v0__fill_64_1 VDD VSS gf180mcu_fd_sc_mcu9t5v0__fill_64
* cell instance gf180mcu_fd_sc_mcu9t5v0__fill_64_2 r0 *1 0,0
Xgf180mcu_fd_sc_mcu9t5v0__fill_64_2 VDD VSS gf180mcu_fd_sc_mcu9t5v0__fill_64
* cell instance gf180mcu_fd_sc_mcu9t5v0__fill_64_3 r0 *1 0,0
Xgf180mcu_fd_sc_mcu9t5v0__fill_64_3 VDD VSS gf180mcu_fd_sc_mcu9t5v0__fill_64
* cell instance gf180mcu_fd_sc_mcu9t5v0__fill_64_4 r0 *1 0,0
Xgf180mcu_fd_sc_mcu9t5v0__fill_64_4 VDD VSS gf180mcu_fd_sc_mcu9t5v0__fill_64
* cell instance gf180mcu_fd_sc_mcu9t5v0__fill_64_5 r0 *1 0,0
Xgf180mcu_fd_sc_mcu9t5v0__fill_64_5 VDD VSS gf180mcu_fd_sc_mcu9t5v0__fill_64
* cell instance gf180mcu_fd_sc_mcu9t5v0__fill_64_6 r0 *1 0,0
Xgf180mcu_fd_sc_mcu9t5v0__fill_64_6 VDD VSS gf180mcu_fd_sc_mcu9t5v0__fill_64
* cell instance gf180mcu_fd_sc_mcu9t5v0__fill_64_7 r0 *1 0,0
Xgf180mcu_fd_sc_mcu9t5v0__fill_64_7 VDD VSS gf180mcu_fd_sc_mcu9t5v0__fill_64
* cell instance gf180mcu_fd_sc_mcu9t5v0__fill_64_8 r0 *1 0,0
Xgf180mcu_fd_sc_mcu9t5v0__fill_64_8 VDD VSS gf180mcu_fd_sc_mcu9t5v0__fill_64
* cell instance gf180mcu_fd_sc_mcu9t5v0__fill_64_9 r0 *1 0,0
Xgf180mcu_fd_sc_mcu9t5v0__fill_64_9 VDD VSS gf180mcu_fd_sc_mcu9t5v0__fill_64
* cell instance gf180mcu_fd_sc_mcu9t5v0__fill_64_10 r0 *1 0,0
Xgf180mcu_fd_sc_mcu9t5v0__fill_64_10 VDD VSS gf180mcu_fd_sc_mcu9t5v0__fill_64
* cell instance gf180mcu_fd_sc_mcu9t5v0__fill_64_11 r0 *1 0,0
Xgf180mcu_fd_sc_mcu9t5v0__fill_64_11 VDD VSS gf180mcu_fd_sc_mcu9t5v0__fill_64
* cell instance gf180mcu_fd_sc_mcu9t5v0__fill_64_12 r0 *1 0,0
Xgf180mcu_fd_sc_mcu9t5v0__fill_64_12 VDD VSS gf180mcu_fd_sc_mcu9t5v0__fill_64
* cell instance gf180mcu_fd_sc_mcu9t5v0__fill_8_0 r0 *1 0,0
Xgf180mcu_fd_sc_mcu9t5v0__fill_8_0 VDD VSS gf180mcu_fd_sc_mcu9t5v0__fill_8
* cell instance gf180mcu_fd_sc_mcu9t5v0__fill_8_1 r0 *1 0,0
Xgf180mcu_fd_sc_mcu9t5v0__fill_8_1 VDD VSS gf180mcu_fd_sc_mcu9t5v0__fill_8
* cell instance gf180mcu_fd_sc_mcu9t5v0__fill_8_2 r0 *1 0,0
Xgf180mcu_fd_sc_mcu9t5v0__fill_8_2 VDD VSS gf180mcu_fd_sc_mcu9t5v0__fill_8
* cell instance gf180mcu_fd_sc_mcu9t5v0__fill_8_3 r0 *1 0,0
Xgf180mcu_fd_sc_mcu9t5v0__fill_8_3 VDD VSS gf180mcu_fd_sc_mcu9t5v0__fill_8
* cell instance gf180mcu_fd_sc_mcu9t5v0__fill_8_4 r0 *1 0,0
Xgf180mcu_fd_sc_mcu9t5v0__fill_8_4 VDD VSS gf180mcu_fd_sc_mcu9t5v0__fill_8
* cell instance gf180mcu_fd_sc_mcu9t5v0__fill_8_5 r0 *1 0,0
Xgf180mcu_fd_sc_mcu9t5v0__fill_8_5 VDD VSS gf180mcu_fd_sc_mcu9t5v0__fill_8
* cell instance gf180mcu_fd_sc_mcu9t5v0__fill_8_6 r0 *1 0,0
Xgf180mcu_fd_sc_mcu9t5v0__fill_8_6 VDD VSS gf180mcu_fd_sc_mcu9t5v0__fill_8
* cell instance gf180mcu_fd_sc_mcu9t5v0__fill_8_7 r0 *1 0,0
Xgf180mcu_fd_sc_mcu9t5v0__fill_8_7 VDD VSS gf180mcu_fd_sc_mcu9t5v0__fill_8
* cell instance gf180mcu_fd_sc_mcu9t5v0__fill_8_8 r0 *1 0,0
Xgf180mcu_fd_sc_mcu9t5v0__fill_8_8 VDD VSS gf180mcu_fd_sc_mcu9t5v0__fill_8
* cell instance gf180mcu_fd_sc_mcu9t5v0__fill_8_9 r0 *1 0,0
Xgf180mcu_fd_sc_mcu9t5v0__fill_8_9 VDD VSS gf180mcu_fd_sc_mcu9t5v0__fill_8
* cell instance gf180mcu_fd_sc_mcu9t5v0__fill_8_10 r0 *1 0,0
Xgf180mcu_fd_sc_mcu9t5v0__fill_8_10 VDD VSS gf180mcu_fd_sc_mcu9t5v0__fill_8
* cell instance gf180mcu_fd_sc_mcu9t5v0__fill_8_11 r0 *1 0,0
Xgf180mcu_fd_sc_mcu9t5v0__fill_8_11 VDD VSS gf180mcu_fd_sc_mcu9t5v0__fill_8
* cell instance gf180mcu_fd_sc_mcu9t5v0__fill_8_12 r0 *1 0,0
Xgf180mcu_fd_sc_mcu9t5v0__fill_8_12 VDD VSS gf180mcu_fd_sc_mcu9t5v0__fill_8
* cell instance gf180mcu_fd_sc_mcu9t5v0__fill_8_13 r0 *1 0,0
Xgf180mcu_fd_sc_mcu9t5v0__fill_8_13 VDD VSS gf180mcu_fd_sc_mcu9t5v0__fill_8
* cell instance gf180mcu_fd_sc_mcu9t5v0__fill_8_14 r0 *1 0,0
Xgf180mcu_fd_sc_mcu9t5v0__fill_8_14 VDD VSS gf180mcu_fd_sc_mcu9t5v0__fill_8
* cell instance gf180mcu_fd_sc_mcu9t5v0__fill_8_15 r0 *1 0,0
Xgf180mcu_fd_sc_mcu9t5v0__fill_8_15 VDD VSS gf180mcu_fd_sc_mcu9t5v0__fill_8
* cell instance gf180mcu_fd_sc_mcu9t5v0__fill_8_16 r0 *1 0,0
Xgf180mcu_fd_sc_mcu9t5v0__fill_8_16 VDD VSS gf180mcu_fd_sc_mcu9t5v0__fill_8
* cell instance gf180mcu_fd_sc_mcu9t5v0__fill_8_17 r0 *1 0,0
Xgf180mcu_fd_sc_mcu9t5v0__fill_8_17 VDD VSS gf180mcu_fd_sc_mcu9t5v0__fill_8
* cell instance gf180mcu_fd_sc_mcu9t5v0__fill_8_18 r0 *1 0,0
Xgf180mcu_fd_sc_mcu9t5v0__fill_8_18 VDD VSS gf180mcu_fd_sc_mcu9t5v0__fill_8
* cell instance gf180mcu_fd_sc_mcu9t5v0__fill_8_19 r0 *1 0,0
Xgf180mcu_fd_sc_mcu9t5v0__fill_8_19 VDD VSS gf180mcu_fd_sc_mcu9t5v0__fill_8
* cell instance gf180mcu_fd_sc_mcu9t5v0__fill_8_20 r0 *1 0,0
Xgf180mcu_fd_sc_mcu9t5v0__fill_8_20 VDD VSS gf180mcu_fd_sc_mcu9t5v0__fill_8
* cell instance gf180mcu_fd_sc_mcu9t5v0__fill_8_21 r0 *1 0,0
Xgf180mcu_fd_sc_mcu9t5v0__fill_8_21 VDD VSS gf180mcu_fd_sc_mcu9t5v0__fill_8
* cell instance gf180mcu_fd_sc_mcu9t5v0__fill_8_22 r0 *1 0,0
Xgf180mcu_fd_sc_mcu9t5v0__fill_8_22 VDD VSS gf180mcu_fd_sc_mcu9t5v0__fill_8
* cell instance gf180mcu_fd_sc_mcu9t5v0__fill_8_23 r0 *1 0,0
Xgf180mcu_fd_sc_mcu9t5v0__fill_8_23 VDD VSS gf180mcu_fd_sc_mcu9t5v0__fill_8
* cell instance gf180mcu_fd_sc_mcu9t5v0__fill_8_24 r0 *1 0,0
Xgf180mcu_fd_sc_mcu9t5v0__fill_8_24 VDD VSS gf180mcu_fd_sc_mcu9t5v0__fill_8
* cell instance gf180mcu_fd_sc_mcu9t5v0__fill_8_25 r0 *1 0,0
Xgf180mcu_fd_sc_mcu9t5v0__fill_8_25 VDD VSS gf180mcu_fd_sc_mcu9t5v0__fill_8
* cell instance gf180mcu_fd_sc_mcu9t5v0__fill_8_26 r0 *1 0,0
Xgf180mcu_fd_sc_mcu9t5v0__fill_8_26 VDD VSS gf180mcu_fd_sc_mcu9t5v0__fill_8
* cell instance gf180mcu_fd_sc_mcu9t5v0__fill_8_27 r0 *1 0,0
Xgf180mcu_fd_sc_mcu9t5v0__fill_8_27 VDD VSS gf180mcu_fd_sc_mcu9t5v0__fill_8
* cell instance gf180mcu_fd_sc_mcu9t5v0__fill_8_28 r0 *1 0,0
Xgf180mcu_fd_sc_mcu9t5v0__fill_8_28 VDD VSS gf180mcu_fd_sc_mcu9t5v0__fill_8
* cell instance gf180mcu_fd_sc_mcu9t5v0__fill_8_29 r0 *1 0,0
Xgf180mcu_fd_sc_mcu9t5v0__fill_8_29 VDD VSS gf180mcu_fd_sc_mcu9t5v0__fill_8
* cell instance gf180mcu_fd_sc_mcu9t5v0__fill_8_30 r0 *1 0,0
Xgf180mcu_fd_sc_mcu9t5v0__fill_8_30 VDD VSS gf180mcu_fd_sc_mcu9t5v0__fill_8
* cell instance gf180mcu_fd_sc_mcu9t5v0__fill_8_31 r0 *1 0,0
Xgf180mcu_fd_sc_mcu9t5v0__fill_8_31 VDD VSS gf180mcu_fd_sc_mcu9t5v0__fill_8
* cell instance gf180mcu_fd_sc_mcu9t5v0__fill_8_32 r0 *1 0,0
Xgf180mcu_fd_sc_mcu9t5v0__fill_8_32 VDD VSS gf180mcu_fd_sc_mcu9t5v0__fill_8
* cell instance gf180mcu_fd_sc_mcu9t5v0__fill_8_33 r0 *1 0,0
Xgf180mcu_fd_sc_mcu9t5v0__fill_8_33 VDD VSS gf180mcu_fd_sc_mcu9t5v0__fill_8
* cell instance gf180mcu_fd_sc_mcu9t5v0__fill_8_34 r0 *1 0,0
Xgf180mcu_fd_sc_mcu9t5v0__fill_8_34 VDD VSS gf180mcu_fd_sc_mcu9t5v0__fill_8
* cell instance gf180mcu_fd_sc_mcu9t5v0__fill_8_35 r0 *1 0,0
Xgf180mcu_fd_sc_mcu9t5v0__fill_8_35 VDD VSS gf180mcu_fd_sc_mcu9t5v0__fill_8
* cell instance gf180mcu_fd_sc_mcu9t5v0__fill_8_36 r0 *1 0,0
Xgf180mcu_fd_sc_mcu9t5v0__fill_8_36 VDD VSS gf180mcu_fd_sc_mcu9t5v0__fill_8
* cell instance gf180mcu_fd_sc_mcu9t5v0__fill_8_37 r0 *1 0,0
Xgf180mcu_fd_sc_mcu9t5v0__fill_8_37 VDD VSS gf180mcu_fd_sc_mcu9t5v0__fill_8
* cell instance gf180mcu_fd_sc_mcu9t5v0__fill_8_38 r0 *1 0,0
Xgf180mcu_fd_sc_mcu9t5v0__fill_8_38 VDD VSS gf180mcu_fd_sc_mcu9t5v0__fill_8
* cell instance gf180mcu_fd_sc_mcu9t5v0__fill_8_39 r0 *1 0,0
Xgf180mcu_fd_sc_mcu9t5v0__fill_8_39 VDD VSS gf180mcu_fd_sc_mcu9t5v0__fill_8
* cell instance gf180mcu_fd_sc_mcu9t5v0__fill_8_40 r0 *1 0,0
Xgf180mcu_fd_sc_mcu9t5v0__fill_8_40 VDD VSS gf180mcu_fd_sc_mcu9t5v0__fill_8
* cell instance gf180mcu_fd_sc_mcu9t5v0__fill_8_41 r0 *1 0,0
Xgf180mcu_fd_sc_mcu9t5v0__fill_8_41 VDD VSS gf180mcu_fd_sc_mcu9t5v0__fill_8
* cell instance gf180mcu_fd_sc_mcu9t5v0__fill_8_42 r0 *1 0,0
Xgf180mcu_fd_sc_mcu9t5v0__fill_8_42 VDD VSS gf180mcu_fd_sc_mcu9t5v0__fill_8
* cell instance gf180mcu_fd_sc_mcu9t5v0__fill_8_43 r0 *1 0,0
Xgf180mcu_fd_sc_mcu9t5v0__fill_8_43 VDD VSS gf180mcu_fd_sc_mcu9t5v0__fill_8
* cell instance gf180mcu_fd_sc_mcu9t5v0__fill_8_44 r0 *1 0,0
Xgf180mcu_fd_sc_mcu9t5v0__fill_8_44 VDD VSS gf180mcu_fd_sc_mcu9t5v0__fill_8
* cell instance gf180mcu_fd_sc_mcu9t5v0__fill_8_45 r0 *1 0,0
Xgf180mcu_fd_sc_mcu9t5v0__fill_8_45 VDD VSS gf180mcu_fd_sc_mcu9t5v0__fill_8
* cell instance gf180mcu_fd_sc_mcu9t5v0__fill_8_46 r0 *1 0,0
Xgf180mcu_fd_sc_mcu9t5v0__fill_8_46 VDD VSS gf180mcu_fd_sc_mcu9t5v0__fill_8
* cell instance gf180mcu_fd_sc_mcu9t5v0__fill_8_47 r0 *1 0,0
Xgf180mcu_fd_sc_mcu9t5v0__fill_8_47 VDD VSS gf180mcu_fd_sc_mcu9t5v0__fill_8
* cell instance gf180mcu_fd_sc_mcu9t5v0__fill_8_48 r0 *1 0,0
Xgf180mcu_fd_sc_mcu9t5v0__fill_8_48 VDD VSS gf180mcu_fd_sc_mcu9t5v0__fill_8
* cell instance gf180mcu_fd_sc_mcu9t5v0__fill_8_49 r0 *1 0,0
Xgf180mcu_fd_sc_mcu9t5v0__fill_8_49 VDD VSS gf180mcu_fd_sc_mcu9t5v0__fill_8
* cell instance gf180mcu_fd_sc_mcu9t5v0__fill_8_50 r0 *1 0,0
Xgf180mcu_fd_sc_mcu9t5v0__fill_8_50 VDD VSS gf180mcu_fd_sc_mcu9t5v0__fill_8
* cell instance gf180mcu_fd_sc_mcu9t5v0__fill_8_51 r0 *1 0,0
Xgf180mcu_fd_sc_mcu9t5v0__fill_8_51 VDD VSS gf180mcu_fd_sc_mcu9t5v0__fill_8
* cell instance gf180mcu_fd_sc_mcu9t5v0__fill_8_52 r0 *1 0,0
Xgf180mcu_fd_sc_mcu9t5v0__fill_8_52 VDD VSS gf180mcu_fd_sc_mcu9t5v0__fill_8
* cell instance gf180mcu_fd_sc_mcu9t5v0__fill_8_53 r0 *1 0,0
Xgf180mcu_fd_sc_mcu9t5v0__fill_8_53 VDD VSS gf180mcu_fd_sc_mcu9t5v0__fill_8
* cell instance gf180mcu_fd_sc_mcu9t5v0__fill_8_54 r0 *1 0,0
Xgf180mcu_fd_sc_mcu9t5v0__fill_8_54 VDD VSS gf180mcu_fd_sc_mcu9t5v0__fill_8
* cell instance gf180mcu_fd_sc_mcu9t5v0__fill_8_55 r0 *1 0,0
Xgf180mcu_fd_sc_mcu9t5v0__fill_8_55 VDD VSS gf180mcu_fd_sc_mcu9t5v0__fill_8
* cell instance gf180mcu_fd_sc_mcu9t5v0__fill_8_56 r0 *1 0,0
Xgf180mcu_fd_sc_mcu9t5v0__fill_8_56 VDD VSS gf180mcu_fd_sc_mcu9t5v0__fill_8
* cell instance gf180mcu_fd_sc_mcu9t5v0__fill_8_57 r0 *1 0,0
Xgf180mcu_fd_sc_mcu9t5v0__fill_8_57 VDD VSS gf180mcu_fd_sc_mcu9t5v0__fill_8
* cell instance gf180mcu_fd_sc_mcu9t5v0__fill_8_58 r0 *1 0,0
Xgf180mcu_fd_sc_mcu9t5v0__fill_8_58 VDD VSS gf180mcu_fd_sc_mcu9t5v0__fill_8
* cell instance gf180mcu_fd_sc_mcu9t5v0__fill_8_59 r0 *1 0,0
Xgf180mcu_fd_sc_mcu9t5v0__fill_8_59 VDD VSS gf180mcu_fd_sc_mcu9t5v0__fill_8
* cell instance gf180mcu_fd_sc_mcu9t5v0__fill_8_60 r0 *1 0,0
Xgf180mcu_fd_sc_mcu9t5v0__fill_8_60 VDD VSS gf180mcu_fd_sc_mcu9t5v0__fill_8
* cell instance gf180mcu_fd_sc_mcu9t5v0__fill_8_61 r0 *1 0,0
Xgf180mcu_fd_sc_mcu9t5v0__fill_8_61 VDD VSS gf180mcu_fd_sc_mcu9t5v0__fill_8
* cell instance gf180mcu_fd_sc_mcu9t5v0__fill_8_62 r0 *1 0,0
Xgf180mcu_fd_sc_mcu9t5v0__fill_8_62 VDD VSS gf180mcu_fd_sc_mcu9t5v0__fill_8
* cell instance gf180mcu_fd_sc_mcu9t5v0__fill_8_63 r0 *1 0,0
Xgf180mcu_fd_sc_mcu9t5v0__fill_8_63 VDD VSS gf180mcu_fd_sc_mcu9t5v0__fill_8
* cell instance gf180mcu_fd_sc_mcu9t5v0__fill_8_64 r0 *1 0,0
Xgf180mcu_fd_sc_mcu9t5v0__fill_8_64 VDD VSS gf180mcu_fd_sc_mcu9t5v0__fill_8
* cell instance gf180mcu_fd_sc_mcu9t5v0__fill_8_65 r0 *1 0,0
Xgf180mcu_fd_sc_mcu9t5v0__fill_8_65 VDD VSS gf180mcu_fd_sc_mcu9t5v0__fill_8
* cell instance gf180mcu_fd_sc_mcu9t5v0__fill_8_66 r0 *1 0,0
Xgf180mcu_fd_sc_mcu9t5v0__fill_8_66 VDD VSS gf180mcu_fd_sc_mcu9t5v0__fill_8
* cell instance gf180mcu_fd_sc_mcu9t5v0__fill_8_67 r0 *1 0,0
Xgf180mcu_fd_sc_mcu9t5v0__fill_8_67 VDD VSS gf180mcu_fd_sc_mcu9t5v0__fill_8
* cell instance gf180mcu_fd_sc_mcu9t5v0__fill_8_68 r0 *1 0,0
Xgf180mcu_fd_sc_mcu9t5v0__fill_8_68 VDD VSS gf180mcu_fd_sc_mcu9t5v0__fill_8
* cell instance gf180mcu_fd_sc_mcu9t5v0__fill_8_69 r0 *1 0,0
Xgf180mcu_fd_sc_mcu9t5v0__fill_8_69 VDD VSS gf180mcu_fd_sc_mcu9t5v0__fill_8
* cell instance gf180mcu_fd_sc_mcu9t5v0__fill_8_70 r0 *1 0,0
Xgf180mcu_fd_sc_mcu9t5v0__fill_8_70 VDD VSS gf180mcu_fd_sc_mcu9t5v0__fill_8
* cell instance gf180mcu_fd_sc_mcu9t5v0__fill_8_71 r0 *1 0,0
Xgf180mcu_fd_sc_mcu9t5v0__fill_8_71 VDD VSS gf180mcu_fd_sc_mcu9t5v0__fill_8
* cell instance gf180mcu_fd_sc_mcu9t5v0__fill_8_72 r0 *1 0,0
Xgf180mcu_fd_sc_mcu9t5v0__fill_8_72 VDD VSS gf180mcu_fd_sc_mcu9t5v0__fill_8
* cell instance gf180mcu_fd_sc_mcu9t5v0__fill_8_73 r0 *1 0,0
Xgf180mcu_fd_sc_mcu9t5v0__fill_8_73 VDD VSS gf180mcu_fd_sc_mcu9t5v0__fill_8
* cell instance gf180mcu_fd_sc_mcu9t5v0__fill_8_74 r0 *1 0,0
Xgf180mcu_fd_sc_mcu9t5v0__fill_8_74 VDD VSS gf180mcu_fd_sc_mcu9t5v0__fill_8
* cell instance gf180mcu_fd_sc_mcu9t5v0__fill_8_75 r0 *1 0,0
Xgf180mcu_fd_sc_mcu9t5v0__fill_8_75 VDD VSS gf180mcu_fd_sc_mcu9t5v0__fill_8
* cell instance gf180mcu_fd_sc_mcu9t5v0__fill_8_76 r0 *1 0,0
Xgf180mcu_fd_sc_mcu9t5v0__fill_8_76 VDD VSS gf180mcu_fd_sc_mcu9t5v0__fill_8
* cell instance gf180mcu_fd_sc_mcu9t5v0__fill_8_77 r0 *1 0,0
Xgf180mcu_fd_sc_mcu9t5v0__fill_8_77 VDD VSS gf180mcu_fd_sc_mcu9t5v0__fill_8
* cell instance gf180mcu_fd_sc_mcu9t5v0__fill_8_78 r0 *1 0,0
Xgf180mcu_fd_sc_mcu9t5v0__fill_8_78 VDD VSS gf180mcu_fd_sc_mcu9t5v0__fill_8
* cell instance gf180mcu_fd_sc_mcu9t5v0__fill_8_79 r0 *1 0,0
Xgf180mcu_fd_sc_mcu9t5v0__fill_8_79 VDD VSS gf180mcu_fd_sc_mcu9t5v0__fill_8
* cell instance gf180mcu_fd_sc_mcu9t5v0__fill_8_80 r0 *1 0,0
Xgf180mcu_fd_sc_mcu9t5v0__fill_8_80 VDD VSS gf180mcu_fd_sc_mcu9t5v0__fill_8
* cell instance gf180mcu_fd_sc_mcu9t5v0__fill_8_81 r0 *1 0,0
Xgf180mcu_fd_sc_mcu9t5v0__fill_8_81 VDD VSS gf180mcu_fd_sc_mcu9t5v0__fill_8
* cell instance gf180mcu_fd_sc_mcu9t5v0__fill_8_82 r0 *1 0,0
Xgf180mcu_fd_sc_mcu9t5v0__fill_8_82 VDD VSS gf180mcu_fd_sc_mcu9t5v0__fill_8
* cell instance gf180mcu_fd_sc_mcu9t5v0__fill_8_83 r0 *1 0,0
Xgf180mcu_fd_sc_mcu9t5v0__fill_8_83 VDD VSS gf180mcu_fd_sc_mcu9t5v0__fill_8
* cell instance gf180mcu_fd_sc_mcu9t5v0__fill_8_84 r0 *1 0,0
Xgf180mcu_fd_sc_mcu9t5v0__fill_8_84 VDD VSS gf180mcu_fd_sc_mcu9t5v0__fill_8
* cell instance gf180mcu_fd_sc_mcu9t5v0__fill_8_85 r0 *1 0,0
Xgf180mcu_fd_sc_mcu9t5v0__fill_8_85 VDD VSS gf180mcu_fd_sc_mcu9t5v0__fill_8
* cell instance gf180mcu_fd_sc_mcu9t5v0__fill_8_86 r0 *1 0,0
Xgf180mcu_fd_sc_mcu9t5v0__fill_8_86 VDD VSS gf180mcu_fd_sc_mcu9t5v0__fill_8
* cell instance gf180mcu_fd_sc_mcu9t5v0__fill_8_87 r0 *1 0,0
Xgf180mcu_fd_sc_mcu9t5v0__fill_8_87 VDD VSS gf180mcu_fd_sc_mcu9t5v0__fill_8
* cell instance gf180mcu_fd_sc_mcu9t5v0__fill_8_88 r0 *1 0,0
Xgf180mcu_fd_sc_mcu9t5v0__fill_8_88 VDD VSS gf180mcu_fd_sc_mcu9t5v0__fill_8
* cell instance gf180mcu_fd_sc_mcu9t5v0__fill_8_89 r0 *1 0,0
Xgf180mcu_fd_sc_mcu9t5v0__fill_8_89 VDD VSS gf180mcu_fd_sc_mcu9t5v0__fill_8
* cell instance gf180mcu_fd_sc_mcu9t5v0__fill_8_90 r0 *1 0,0
Xgf180mcu_fd_sc_mcu9t5v0__fill_8_90 VDD VSS gf180mcu_fd_sc_mcu9t5v0__fill_8
* cell instance gf180mcu_fd_sc_mcu9t5v0__fill_8_91 r0 *1 0,0
Xgf180mcu_fd_sc_mcu9t5v0__fill_8_91 VDD VSS gf180mcu_fd_sc_mcu9t5v0__fill_8
* cell instance gf180mcu_fd_sc_mcu9t5v0__fill_8_92 r0 *1 0,0
Xgf180mcu_fd_sc_mcu9t5v0__fill_8_92 VDD VSS gf180mcu_fd_sc_mcu9t5v0__fill_8
* cell instance gf180mcu_fd_sc_mcu9t5v0__fill_8_93 r0 *1 0,0
Xgf180mcu_fd_sc_mcu9t5v0__fill_8_93 VDD VSS gf180mcu_fd_sc_mcu9t5v0__fill_8
* cell instance gf180mcu_fd_sc_mcu9t5v0__fill_8_94 r0 *1 0,0
Xgf180mcu_fd_sc_mcu9t5v0__fill_8_94 VDD VSS gf180mcu_fd_sc_mcu9t5v0__fill_8
* cell instance gf180mcu_fd_sc_mcu9t5v0__fill_8_95 r0 *1 0,0
Xgf180mcu_fd_sc_mcu9t5v0__fill_8_95 VDD VSS gf180mcu_fd_sc_mcu9t5v0__fill_8
* cell instance gf180mcu_fd_sc_mcu9t5v0__fill_8_96 r0 *1 0,0
Xgf180mcu_fd_sc_mcu9t5v0__fill_8_96 VDD VSS gf180mcu_fd_sc_mcu9t5v0__fill_8
* cell instance gf180mcu_fd_sc_mcu9t5v0__fill_8_97 r0 *1 0,0
Xgf180mcu_fd_sc_mcu9t5v0__fill_8_97 VDD VSS gf180mcu_fd_sc_mcu9t5v0__fill_8
* cell instance gf180mcu_fd_sc_mcu9t5v0__fill_8_98 r0 *1 0,0
Xgf180mcu_fd_sc_mcu9t5v0__fill_8_98 VDD VSS gf180mcu_fd_sc_mcu9t5v0__fill_8
* cell instance gf180mcu_fd_sc_mcu9t5v0__fill_8_99 r0 *1 0,0
Xgf180mcu_fd_sc_mcu9t5v0__fill_8_99 VDD VSS gf180mcu_fd_sc_mcu9t5v0__fill_8
* cell instance gf180mcu_fd_sc_mcu9t5v0__fill_8_100 r0 *1 0,0
Xgf180mcu_fd_sc_mcu9t5v0__fill_8_100 VDD VSS gf180mcu_fd_sc_mcu9t5v0__fill_8
* cell instance gf180mcu_fd_sc_mcu9t5v0__fill_8_101 r0 *1 0,0
Xgf180mcu_fd_sc_mcu9t5v0__fill_8_101 VDD VSS gf180mcu_fd_sc_mcu9t5v0__fill_8
* cell instance gf180mcu_fd_sc_mcu9t5v0__fill_8_102 r0 *1 0,0
Xgf180mcu_fd_sc_mcu9t5v0__fill_8_102 VDD VSS gf180mcu_fd_sc_mcu9t5v0__fill_8
* cell instance gf180mcu_fd_sc_mcu9t5v0__fill_8_103 r0 *1 0,0
Xgf180mcu_fd_sc_mcu9t5v0__fill_8_103 VDD VSS gf180mcu_fd_sc_mcu9t5v0__fill_8
* cell instance gf180mcu_fd_sc_mcu9t5v0__fill_8_104 r0 *1 0,0
Xgf180mcu_fd_sc_mcu9t5v0__fill_8_104 VDD VSS gf180mcu_fd_sc_mcu9t5v0__fill_8
* cell instance gf180mcu_fd_sc_mcu9t5v0__fill_8_105 r0 *1 0,0
Xgf180mcu_fd_sc_mcu9t5v0__fill_8_105 VDD VSS gf180mcu_fd_sc_mcu9t5v0__fill_8
* cell instance gf180mcu_fd_sc_mcu9t5v0__fill_8_106 r0 *1 0,0
Xgf180mcu_fd_sc_mcu9t5v0__fill_8_106 VDD VSS gf180mcu_fd_sc_mcu9t5v0__fill_8
* cell instance gf180mcu_fd_sc_mcu9t5v0__fill_8_107 r0 *1 0,0
Xgf180mcu_fd_sc_mcu9t5v0__fill_8_107 VDD VSS gf180mcu_fd_sc_mcu9t5v0__fill_8
* cell instance gf180mcu_fd_sc_mcu9t5v0__fill_8_108 r0 *1 0,0
Xgf180mcu_fd_sc_mcu9t5v0__fill_8_108 VDD VSS gf180mcu_fd_sc_mcu9t5v0__fill_8
* cell instance gf180mcu_fd_sc_mcu9t5v0__fill_8_109 r0 *1 0,0
Xgf180mcu_fd_sc_mcu9t5v0__fill_8_109 VDD VSS gf180mcu_fd_sc_mcu9t5v0__fill_8
* cell instance gf180mcu_fd_sc_mcu9t5v0__fill_8_110 r0 *1 0,0
Xgf180mcu_fd_sc_mcu9t5v0__fill_8_110 VDD VSS gf180mcu_fd_sc_mcu9t5v0__fill_8
* cell instance gf180mcu_fd_sc_mcu9t5v0__fill_8_111 r0 *1 0,0
Xgf180mcu_fd_sc_mcu9t5v0__fill_8_111 VDD VSS gf180mcu_fd_sc_mcu9t5v0__fill_8
* cell instance gf180mcu_fd_sc_mcu9t5v0__fill_8_112 r0 *1 0,0
Xgf180mcu_fd_sc_mcu9t5v0__fill_8_112 VDD VSS gf180mcu_fd_sc_mcu9t5v0__fill_8
* cell instance gf180mcu_fd_sc_mcu9t5v0__fill_8_113 r0 *1 0,0
Xgf180mcu_fd_sc_mcu9t5v0__fill_8_113 VDD VSS gf180mcu_fd_sc_mcu9t5v0__fill_8
* cell instance gf180mcu_fd_sc_mcu9t5v0__fill_8_114 r0 *1 0,0
Xgf180mcu_fd_sc_mcu9t5v0__fill_8_114 VDD VSS gf180mcu_fd_sc_mcu9t5v0__fill_8
* cell instance gf180mcu_fd_sc_mcu9t5v0__fill_8_115 r0 *1 0,0
Xgf180mcu_fd_sc_mcu9t5v0__fill_8_115 VDD VSS gf180mcu_fd_sc_mcu9t5v0__fill_8
* cell instance gf180mcu_fd_sc_mcu9t5v0__fill_8_116 r0 *1 0,0
Xgf180mcu_fd_sc_mcu9t5v0__fill_8_116 VDD VSS gf180mcu_fd_sc_mcu9t5v0__fill_8
* cell instance gf180mcu_fd_sc_mcu9t5v0__fill_8_117 r0 *1 0,0
Xgf180mcu_fd_sc_mcu9t5v0__fill_8_117 VDD VSS gf180mcu_fd_sc_mcu9t5v0__fill_8
* cell instance gf180mcu_fd_sc_mcu9t5v0__fill_8_118 r0 *1 0,0
Xgf180mcu_fd_sc_mcu9t5v0__fill_8_118 VDD VSS gf180mcu_fd_sc_mcu9t5v0__fill_8
* cell instance gf180mcu_fd_sc_mcu9t5v0__fill_8_119 r0 *1 0,0
Xgf180mcu_fd_sc_mcu9t5v0__fill_8_119 VDD VSS gf180mcu_fd_sc_mcu9t5v0__fill_8
* cell instance gf180mcu_fd_sc_mcu9t5v0__fill_8_120 r0 *1 0,0
Xgf180mcu_fd_sc_mcu9t5v0__fill_8_120 VDD VSS gf180mcu_fd_sc_mcu9t5v0__fill_8
* cell instance gf180mcu_fd_sc_mcu9t5v0__fill_8_121 r0 *1 0,0
Xgf180mcu_fd_sc_mcu9t5v0__fill_8_121 VDD VSS gf180mcu_fd_sc_mcu9t5v0__fill_8
* cell instance gf180mcu_fd_sc_mcu9t5v0__fill_8_122 r0 *1 0,0
Xgf180mcu_fd_sc_mcu9t5v0__fill_8_122 VDD VSS gf180mcu_fd_sc_mcu9t5v0__fill_8
* cell instance gf180mcu_fd_sc_mcu9t5v0__fill_8_123 r0 *1 0,0
Xgf180mcu_fd_sc_mcu9t5v0__fill_8_123 VDD VSS gf180mcu_fd_sc_mcu9t5v0__fill_8
* cell instance gf180mcu_fd_sc_mcu9t5v0__fill_8_124 r0 *1 0,0
Xgf180mcu_fd_sc_mcu9t5v0__fill_8_124 VDD VSS gf180mcu_fd_sc_mcu9t5v0__fill_8
* cell instance gf180mcu_fd_sc_mcu9t5v0__fill_8_125 r0 *1 0,0
Xgf180mcu_fd_sc_mcu9t5v0__fill_8_125 VDD VSS gf180mcu_fd_sc_mcu9t5v0__fill_8
* cell instance gf180mcu_fd_sc_mcu9t5v0__fill_8_126 r0 *1 0,0
Xgf180mcu_fd_sc_mcu9t5v0__fill_8_126 VDD VSS gf180mcu_fd_sc_mcu9t5v0__fill_8
* cell instance gf180mcu_fd_sc_mcu9t5v0__fill_8_127 r0 *1 0,0
Xgf180mcu_fd_sc_mcu9t5v0__fill_8_127 VDD VSS gf180mcu_fd_sc_mcu9t5v0__fill_8
* cell instance gf180mcu_fd_sc_mcu9t5v0__fill_8_128 r0 *1 0,0
Xgf180mcu_fd_sc_mcu9t5v0__fill_8_128 VDD VSS gf180mcu_fd_sc_mcu9t5v0__fill_8
* cell instance gf180mcu_fd_sc_mcu9t5v0__fill_8_129 r0 *1 0,0
Xgf180mcu_fd_sc_mcu9t5v0__fill_8_129 VDD VSS gf180mcu_fd_sc_mcu9t5v0__fill_8
* cell instance gf180mcu_fd_sc_mcu9t5v0__fill_8_130 r0 *1 0,0
Xgf180mcu_fd_sc_mcu9t5v0__fill_8_130 VDD VSS gf180mcu_fd_sc_mcu9t5v0__fill_8
* cell instance gf180mcu_fd_sc_mcu9t5v0__fill_8_131 r0 *1 0,0
Xgf180mcu_fd_sc_mcu9t5v0__fill_8_131 VDD VSS gf180mcu_fd_sc_mcu9t5v0__fill_8
* cell instance gf180mcu_fd_sc_mcu9t5v0__fill_8_132 r0 *1 0,0
Xgf180mcu_fd_sc_mcu9t5v0__fill_8_132 VDD VSS gf180mcu_fd_sc_mcu9t5v0__fill_8
* cell instance gf180mcu_fd_sc_mcu9t5v0__fill_8_133 r0 *1 0,0
Xgf180mcu_fd_sc_mcu9t5v0__fill_8_133 VDD VSS gf180mcu_fd_sc_mcu9t5v0__fill_8
* cell instance gf180mcu_fd_sc_mcu9t5v0__fill_8_134 r0 *1 0,0
Xgf180mcu_fd_sc_mcu9t5v0__fill_8_134 VDD VSS gf180mcu_fd_sc_mcu9t5v0__fill_8
* cell instance gf180mcu_fd_sc_mcu9t5v0__fill_8_135 r0 *1 0,0
Xgf180mcu_fd_sc_mcu9t5v0__fill_8_135 VDD VSS gf180mcu_fd_sc_mcu9t5v0__fill_8
* cell instance gf180mcu_fd_sc_mcu9t5v0__fill_8_136 r0 *1 0,0
Xgf180mcu_fd_sc_mcu9t5v0__fill_8_136 VDD VSS gf180mcu_fd_sc_mcu9t5v0__fill_8
* cell instance gf180mcu_fd_sc_mcu9t5v0__fill_8_137 r0 *1 0,0
Xgf180mcu_fd_sc_mcu9t5v0__fill_8_137 VDD VSS gf180mcu_fd_sc_mcu9t5v0__fill_8
* cell instance gf180mcu_fd_sc_mcu9t5v0__filltie_0 r0 *1 0,0
Xgf180mcu_fd_sc_mcu9t5v0__filltie_0 VDD VSS gf180mcu_fd_sc_mcu9t5v0__filltie
* cell instance gf180mcu_fd_sc_mcu9t5v0__filltie_1 r0 *1 0,0
Xgf180mcu_fd_sc_mcu9t5v0__filltie_1 VDD VSS gf180mcu_fd_sc_mcu9t5v0__filltie
* cell instance gf180mcu_fd_sc_mcu9t5v0__filltie_2 r0 *1 0,0
Xgf180mcu_fd_sc_mcu9t5v0__filltie_2 VDD VSS gf180mcu_fd_sc_mcu9t5v0__filltie
* cell instance gf180mcu_fd_sc_mcu9t5v0__filltie_3 r0 *1 0,0
Xgf180mcu_fd_sc_mcu9t5v0__filltie_3 VDD VSS gf180mcu_fd_sc_mcu9t5v0__filltie
* cell instance gf180mcu_fd_sc_mcu9t5v0__filltie_4 r0 *1 0,0
Xgf180mcu_fd_sc_mcu9t5v0__filltie_4 VDD VSS gf180mcu_fd_sc_mcu9t5v0__filltie
* cell instance gf180mcu_fd_sc_mcu9t5v0__filltie_5 r0 *1 0,0
Xgf180mcu_fd_sc_mcu9t5v0__filltie_5 VDD VSS gf180mcu_fd_sc_mcu9t5v0__filltie
* cell instance gf180mcu_fd_sc_mcu9t5v0__filltie_6 r0 *1 0,0
Xgf180mcu_fd_sc_mcu9t5v0__filltie_6 VDD VSS gf180mcu_fd_sc_mcu9t5v0__filltie
* cell instance gf180mcu_fd_sc_mcu9t5v0__filltie_7 r0 *1 0,0
Xgf180mcu_fd_sc_mcu9t5v0__filltie_7 VDD VSS gf180mcu_fd_sc_mcu9t5v0__filltie
* cell instance gf180mcu_fd_sc_mcu9t5v0__filltie_8 r0 *1 0,0
Xgf180mcu_fd_sc_mcu9t5v0__filltie_8 VDD VSS gf180mcu_fd_sc_mcu9t5v0__filltie
* cell instance gf180mcu_fd_sc_mcu9t5v0__filltie_9 r0 *1 0,0
Xgf180mcu_fd_sc_mcu9t5v0__filltie_9 VDD VSS gf180mcu_fd_sc_mcu9t5v0__filltie
* cell instance gf180mcu_fd_sc_mcu9t5v0__filltie_10 r0 *1 0,0
Xgf180mcu_fd_sc_mcu9t5v0__filltie_10 VDD VSS gf180mcu_fd_sc_mcu9t5v0__filltie
* cell instance gf180mcu_fd_sc_mcu9t5v0__filltie_11 r0 *1 0,0
Xgf180mcu_fd_sc_mcu9t5v0__filltie_11 VDD VSS gf180mcu_fd_sc_mcu9t5v0__filltie
* cell instance gf180mcu_fd_sc_mcu9t5v0__filltie_12 r0 *1 0,0
Xgf180mcu_fd_sc_mcu9t5v0__filltie_12 VDD VSS gf180mcu_fd_sc_mcu9t5v0__filltie
* cell instance gf180mcu_fd_sc_mcu9t5v0__filltie_13 r0 *1 0,0
Xgf180mcu_fd_sc_mcu9t5v0__filltie_13 VDD VSS gf180mcu_fd_sc_mcu9t5v0__filltie
* cell instance gf180mcu_fd_sc_mcu9t5v0__filltie_14 r0 *1 0,0
Xgf180mcu_fd_sc_mcu9t5v0__filltie_14 VDD VSS gf180mcu_fd_sc_mcu9t5v0__filltie
* cell instance gf180mcu_fd_sc_mcu9t5v0__filltie_15 r0 *1 0,0
Xgf180mcu_fd_sc_mcu9t5v0__filltie_15 VDD VSS gf180mcu_fd_sc_mcu9t5v0__filltie
* cell instance gf180mcu_fd_sc_mcu9t5v0__filltie_16 r0 *1 0,0
Xgf180mcu_fd_sc_mcu9t5v0__filltie_16 VDD VSS gf180mcu_fd_sc_mcu9t5v0__filltie
* cell instance gf180mcu_fd_sc_mcu9t5v0__inv_2_0 r0 *1 0,0
Xgf180mcu_fd_sc_mcu9t5v0__inv_2_0 \$165 VDD VSS \$323
+ gf180mcu_fd_sc_mcu9t5v0__inv_2
* cell instance gf180mcu_fd_sc_mcu9t5v0__inv_2_1 r0 *1 0,0
Xgf180mcu_fd_sc_mcu9t5v0__inv_2_1 \$385 VDD VSS \$469
+ gf180mcu_fd_sc_mcu9t5v0__inv_2
* cell instance gf180mcu_fd_sc_mcu9t5v0__mux2_1_0 r0 *1 0,0
Xgf180mcu_fd_sc_mcu9t5v0__mux2_1_0 \$566 \$653 \$612 VDD VSS \$638
+ gf180mcu_fd_sc_mcu9t5v0__mux2_1
* cell instance gf180mcu_fd_sc_mcu9t5v0__nand2_1_0 r0 *1 0,0
Xgf180mcu_fd_sc_mcu9t5v0__nand2_1_0 \$57 \$109 VDD VSS \$110
+ gf180mcu_fd_sc_mcu9t5v0__nand2_1
* cell instance gf180mcu_fd_sc_mcu9t5v0__nand2_1_1 r0 *1 0,0
Xgf180mcu_fd_sc_mcu9t5v0__nand2_1_1 \$51 \$44 VDD VSS \$50
+ gf180mcu_fd_sc_mcu9t5v0__nand2_1
* cell instance gf180mcu_fd_sc_mcu9t5v0__nand2_1_2 r0 *1 0,0
Xgf180mcu_fd_sc_mcu9t5v0__nand2_1_2 \$103 \$44 VDD VSS \$142
+ gf180mcu_fd_sc_mcu9t5v0__nand2_1
* cell instance gf180mcu_fd_sc_mcu9t5v0__nand2_1_3 r0 *1 0,0
Xgf180mcu_fd_sc_mcu9t5v0__nand2_1_3 \$149 \$222 VDD VSS \$267
+ gf180mcu_fd_sc_mcu9t5v0__nand2_1
* cell instance gf180mcu_fd_sc_mcu9t5v0__nand2_1_4 r0 *1 0,0
Xgf180mcu_fd_sc_mcu9t5v0__nand2_1_4 \$77 \$50 VDD VSS \$57
+ gf180mcu_fd_sc_mcu9t5v0__nand2_1
* cell instance gf180mcu_fd_sc_mcu9t5v0__nand2_1_5 r0 *1 0,0
Xgf180mcu_fd_sc_mcu9t5v0__nand2_1_5 \$149 \$142 VDD VSS \$109
+ gf180mcu_fd_sc_mcu9t5v0__nand2_1
* cell instance gf180mcu_fd_sc_mcu9t5v0__nand2_1_6 r0 *1 0,0
Xgf180mcu_fd_sc_mcu9t5v0__nand2_1_6 data[6] \$155 VDD VSS \$149
+ gf180mcu_fd_sc_mcu9t5v0__nand2_1
* cell instance gf180mcu_fd_sc_mcu9t5v0__nand2_1_7 r0 *1 0,0
Xgf180mcu_fd_sc_mcu9t5v0__nand2_1_7 data[7] \$255 VDD VSS \$222
+ gf180mcu_fd_sc_mcu9t5v0__nand2_1
* cell instance gf180mcu_fd_sc_mcu9t5v0__nand2_1_8 r0 *1 0,0
Xgf180mcu_fd_sc_mcu9t5v0__nand2_1_8 data[0] \$182 VDD VSS \$183
+ gf180mcu_fd_sc_mcu9t5v0__nand2_1
* cell instance gf180mcu_fd_sc_mcu9t5v0__nand2_1_9 r0 *1 0,0
Xgf180mcu_fd_sc_mcu9t5v0__nand2_1_9 data[4] \$98 VDD VSS \$79
+ gf180mcu_fd_sc_mcu9t5v0__nand2_1
* cell instance gf180mcu_fd_sc_mcu9t5v0__nand2_1_10 r0 *1 0,0
Xgf180mcu_fd_sc_mcu9t5v0__nand2_1_10 \$487 \$605 VDD VSS \$637
+ gf180mcu_fd_sc_mcu9t5v0__nand2_1
* cell instance gf180mcu_fd_sc_mcu9t5v0__nand2_1_11 r0 *1 0,0
Xgf180mcu_fd_sc_mcu9t5v0__nand2_1_11 \$564 \$617 VDD VSS \$612
+ gf180mcu_fd_sc_mcu9t5v0__nand2_1
* cell instance gf180mcu_fd_sc_mcu9t5v0__nand2_1_12 r0 *1 0,0
Xgf180mcu_fd_sc_mcu9t5v0__nand2_1_12 \$100 \$99 VDD VSS \$44
+ gf180mcu_fd_sc_mcu9t5v0__nand2_1
* cell instance gf180mcu_fd_sc_mcu9t5v0__nand2_1_13 r0 *1 0,0
Xgf180mcu_fd_sc_mcu9t5v0__nand2_1_13 data[2] \$145 VDD VSS \$100
+ gf180mcu_fd_sc_mcu9t5v0__nand2_1
* cell instance gf180mcu_fd_sc_mcu9t5v0__nand2_1_14 r0 *1 0,0
Xgf180mcu_fd_sc_mcu9t5v0__nand2_1_14 \$425 \$743 VDD VSS \$765
+ gf180mcu_fd_sc_mcu9t5v0__nand2_1
* cell instance gf180mcu_fd_sc_mcu9t5v0__nand2_1_15 r0 *1 0,0
Xgf180mcu_fd_sc_mcu9t5v0__nand2_1_15 \$737 \$726 VDD VSS \$654
+ gf180mcu_fd_sc_mcu9t5v0__nand2_1
* cell instance gf180mcu_fd_sc_mcu9t5v0__nand2_1_16 r0 *1 0,0
Xgf180mcu_fd_sc_mcu9t5v0__nand2_1_16 \$765 \$702 VDD VSS \$801
+ gf180mcu_fd_sc_mcu9t5v0__nand2_1
* cell instance gf180mcu_fd_sc_mcu9t5v0__nand2_1_17 r0 *1 0,0
Xgf180mcu_fd_sc_mcu9t5v0__nand2_1_17 \$257 \$286 VDD VSS \$265
+ gf180mcu_fd_sc_mcu9t5v0__nand2_1
* cell instance gf180mcu_fd_sc_mcu9t5v0__nand2_1_18 r0 *1 0,0
Xgf180mcu_fd_sc_mcu9t5v0__nand2_1_18 \$257 \$423 VDD VSS \$403
+ gf180mcu_fd_sc_mcu9t5v0__nand2_1
* cell instance gf180mcu_fd_sc_mcu9t5v0__nand2_1_19 r0 *1 0,0
Xgf180mcu_fd_sc_mcu9t5v0__nand2_1_19 \$257 \$358 VDD VSS \$359
+ gf180mcu_fd_sc_mcu9t5v0__nand2_1
* cell instance gf180mcu_fd_sc_mcu9t5v0__nand2_1_20 r0 *1 0,0
Xgf180mcu_fd_sc_mcu9t5v0__nand2_1_20 \$234 \$265 VDD VSS \$203
+ gf180mcu_fd_sc_mcu9t5v0__nand2_1
* cell instance gf180mcu_fd_sc_mcu9t5v0__nand2_1_21 r0 *1 0,0
Xgf180mcu_fd_sc_mcu9t5v0__nand2_1_21 \$234 \$359 VDD VSS \$289
+ gf180mcu_fd_sc_mcu9t5v0__nand2_1
* cell instance gf180mcu_fd_sc_mcu9t5v0__nand2_1_22 r0 *1 0,0
Xgf180mcu_fd_sc_mcu9t5v0__nand2_1_22 \$234 \$403 VDD VSS \$106
+ gf180mcu_fd_sc_mcu9t5v0__nand2_1
* cell instance gf180mcu_fd_sc_mcu9t5v0__nand2_1_23 r0 *1 0,0
Xgf180mcu_fd_sc_mcu9t5v0__nand2_1_23 \$552 \$718 VDD VSS \$623
+ gf180mcu_fd_sc_mcu9t5v0__nand2_1
* cell instance gf180mcu_fd_sc_mcu9t5v0__nand2_1_24 r0 *1 0,0
Xgf180mcu_fd_sc_mcu9t5v0__nand2_1_24 \$510 \$552 VDD VSS \$729
+ gf180mcu_fd_sc_mcu9t5v0__nand2_1
* cell instance gf180mcu_fd_sc_mcu9t5v0__nand2_1_25 r0 *1 0,0
Xgf180mcu_fd_sc_mcu9t5v0__nand2_1_25 \$369 \$234 VDD VSS \$368
+ gf180mcu_fd_sc_mcu9t5v0__nand2_1
* cell instance gf180mcu_fd_sc_mcu9t5v0__nand2_1_26 r0 *1 0,0
Xgf180mcu_fd_sc_mcu9t5v0__nand2_1_26 \$510 \$257 VDD VSS \$369
+ gf180mcu_fd_sc_mcu9t5v0__nand2_1
* cell instance gf180mcu_fd_sc_mcu9t5v0__nand2_1_27 r0 *1 0,0
Xgf180mcu_fd_sc_mcu9t5v0__nand2_1_27 \$208 \$249 VDD VSS \$234
+ gf180mcu_fd_sc_mcu9t5v0__nand2_1
* cell instance gf180mcu_fd_sc_mcu9t5v0__nand2_1_28 r0 *1 0,0
Xgf180mcu_fd_sc_mcu9t5v0__nand2_1_28 \$740 \$752 VDD VSS \$835
+ gf180mcu_fd_sc_mcu9t5v0__nand2_1
* cell instance gf180mcu_fd_sc_mcu9t5v0__nand2_1_29 r0 *1 0,0
Xgf180mcu_fd_sc_mcu9t5v0__nand2_1_29 \$150 \$266 VDD VSS \$208
+ gf180mcu_fd_sc_mcu9t5v0__nand2_1
* cell instance gf180mcu_fd_sc_mcu9t5v0__nand2_1_30 r0 *1 0,0
Xgf180mcu_fd_sc_mcu9t5v0__nand2_1_30 \$101 \$47 VDD VSS \$249
+ gf180mcu_fd_sc_mcu9t5v0__nand2_1
* cell instance gf180mcu_fd_sc_mcu9t5v0__nand2_1_31 r0 *1 0,0
Xgf180mcu_fd_sc_mcu9t5v0__nand2_1_31 \$607 \$662 VDD VSS \$647
+ gf180mcu_fd_sc_mcu9t5v0__nand2_1
* cell instance gf180mcu_fd_sc_mcu9t5v0__nand2_1_32 r0 *1 0,0
Xgf180mcu_fd_sc_mcu9t5v0__nand2_1_32 \$712 \$764 VDD VSS \$710
+ gf180mcu_fd_sc_mcu9t5v0__nand2_1
* cell instance gf180mcu_fd_sc_mcu9t5v0__nand2_1_33 r0 *1 0,0
Xgf180mcu_fd_sc_mcu9t5v0__nand2_1_33 \$150 \$247 VDD VSS \$180
+ gf180mcu_fd_sc_mcu9t5v0__nand2_1
* cell instance gf180mcu_fd_sc_mcu9t5v0__nand2_1_34 r0 *1 0,0
Xgf180mcu_fd_sc_mcu9t5v0__nand2_1_34 \$510 \$553 VDD VSS \$741
+ gf180mcu_fd_sc_mcu9t5v0__nand2_1
* cell instance gf180mcu_fd_sc_mcu9t5v0__nand2_1_35 r0 *1 0,0
Xgf180mcu_fd_sc_mcu9t5v0__nand2_1_35 \$647 \$656 VDD VSS \$626
+ gf180mcu_fd_sc_mcu9t5v0__nand2_1
* cell instance gf180mcu_fd_sc_mcu9t5v0__nand2_1_36 r0 *1 0,0
Xgf180mcu_fd_sc_mcu9t5v0__nand2_1_36 \$342 \$777 VDD VSS \$212
+ gf180mcu_fd_sc_mcu9t5v0__nand2_1
* cell instance gf180mcu_fd_sc_mcu9t5v0__nand2_1_37 r0 *1 0,0
Xgf180mcu_fd_sc_mcu9t5v0__nand2_1_37 \$259 \$713 VDD VSS \$793
+ gf180mcu_fd_sc_mcu9t5v0__nand2_1
* cell instance gf180mcu_fd_sc_mcu9t5v0__nand2_1_38 r0 *1 0,0
Xgf180mcu_fd_sc_mcu9t5v0__nand2_1_38 \$764 \$734 VDD VSS \$735
+ gf180mcu_fd_sc_mcu9t5v0__nand2_1
* cell instance gf180mcu_fd_sc_mcu9t5v0__nand2_1_39 r0 *1 0,0
Xgf180mcu_fd_sc_mcu9t5v0__nand2_1_39 \$506 \$504 VDD VSS \$630
+ gf180mcu_fd_sc_mcu9t5v0__nand2_1
* cell instance gf180mcu_fd_sc_mcu9t5v0__nand2_1_40 r0 *1 0,0
Xgf180mcu_fd_sc_mcu9t5v0__nand2_1_40 \$602 \$620 VDD VSS \$556
+ gf180mcu_fd_sc_mcu9t5v0__nand2_1
* cell instance gf180mcu_fd_sc_mcu9t5v0__nand2_1_41 r0 *1 0,0
Xgf180mcu_fd_sc_mcu9t5v0__nand2_1_41 \$602 \$574 VDD VSS \$454
+ gf180mcu_fd_sc_mcu9t5v0__nand2_1
* cell instance gf180mcu_fd_sc_mcu9t5v0__nand2_1_42 r0 *1 0,0
Xgf180mcu_fd_sc_mcu9t5v0__nand2_1_42 \$259 \$553 VDD VSS \$844
+ gf180mcu_fd_sc_mcu9t5v0__nand2_1
* cell instance gf180mcu_fd_sc_mcu9t5v0__nand2_1_43 r0 *1 0,0
Xgf180mcu_fd_sc_mcu9t5v0__nand2_1_43 \$628 \$621 VDD VSS \$695
+ gf180mcu_fd_sc_mcu9t5v0__nand2_1
* cell instance gf180mcu_fd_sc_mcu9t5v0__nand2_1_44 r0 *1 0,0
Xgf180mcu_fd_sc_mcu9t5v0__nand2_1_44 \$250 \$553 VDD VSS \$820
+ gf180mcu_fd_sc_mcu9t5v0__nand2_1
* cell instance gf180mcu_fd_sc_mcu9t5v0__nand2_1_45 r0 *1 0,0
Xgf180mcu_fd_sc_mcu9t5v0__nand2_1_45 \$820 \$742 VDD VSS \$816
+ gf180mcu_fd_sc_mcu9t5v0__nand2_1
* cell instance gf180mcu_fd_sc_mcu9t5v0__nand2_1_46 r0 *1 0,0
Xgf180mcu_fd_sc_mcu9t5v0__nand2_1_46 \$264 \$263 VDD VSS \$241
+ gf180mcu_fd_sc_mcu9t5v0__nand2_1
* cell instance gf180mcu_fd_sc_mcu9t5v0__nand2_1_47 r0 *1 0,0
Xgf180mcu_fd_sc_mcu9t5v0__nand2_1_47 \$250 \$260 VDD VSS \$264
+ gf180mcu_fd_sc_mcu9t5v0__nand2_1
* cell instance gf180mcu_fd_sc_mcu9t5v0__nand2_1_48 r0 *1 0,0
Xgf180mcu_fd_sc_mcu9t5v0__nand2_1_48 \$742 \$778 VDD VSS \$717
+ gf180mcu_fd_sc_mcu9t5v0__nand2_1
* cell instance gf180mcu_fd_sc_mcu9t5v0__nand3_1_0 r0 *1 0,0
Xgf180mcu_fd_sc_mcu9t5v0__nand3_1_0 \$637 \$698 \$665 VDD VSS \$725
+ gf180mcu_fd_sc_mcu9t5v0__nand3_1
* cell instance gf180mcu_fd_sc_mcu9t5v0__nand3_1_1 r0 *1 0,0
Xgf180mcu_fd_sc_mcu9t5v0__nand3_1_1 \$551 \$737 \$726 VDD VSS \$738
+ gf180mcu_fd_sc_mcu9t5v0__nand3_1
* cell instance gf180mcu_fd_sc_mcu9t5v0__nand3_1_2 r0 *1 0,0
Xgf180mcu_fd_sc_mcu9t5v0__nand3_1_2 \$510 \$552 \$551 VDD VSS \$730
+ gf180mcu_fd_sc_mcu9t5v0__nand3_1
* cell instance gf180mcu_fd_sc_mcu9t5v0__nand3_1_3 r0 *1 0,0
Xgf180mcu_fd_sc_mcu9t5v0__nand3_1_3 \$630 \$631 \$626 VDD VSS \$456
+ gf180mcu_fd_sc_mcu9t5v0__nand3_1
* cell instance gf180mcu_fd_sc_mcu9t5v0__nand3_1_4 r0 *1 0,0
Xgf180mcu_fd_sc_mcu9t5v0__nand3_1_4 \$250 \$259 \$713 VDD VSS \$732
+ gf180mcu_fd_sc_mcu9t5v0__nand3_1
* cell instance gf180mcu_fd_sc_mcu9t5v0__nand3_1_5 r0 *1 0,0
Xgf180mcu_fd_sc_mcu9t5v0__nand3_1_5 \$506 \$627 \$672 VDD VSS \$262
+ gf180mcu_fd_sc_mcu9t5v0__nand3_1
* cell instance gf180mcu_fd_sc_mcu9t5v0__nand4_1_0 r0 *1 0,0
Xgf180mcu_fd_sc_mcu9t5v0__nand4_1_0 data[2] data[1] data[0] data[3] VDD VSS
+ \$51 gf180mcu_fd_sc_mcu9t5v0__nand4_1
* cell instance gf180mcu_fd_sc_mcu9t5v0__nand4_1_1 r0 *1 0,0
Xgf180mcu_fd_sc_mcu9t5v0__nand4_1_1 \$765 \$702 \$780 \$725 VDD VSS \$737
+ gf180mcu_fd_sc_mcu9t5v0__nand4_1
* cell instance gf180mcu_fd_sc_mcu9t5v0__nand4_1_2 r0 *1 0,0
Xgf180mcu_fd_sc_mcu9t5v0__nand4_1_2 \$250 \$512 \$259 \$713 VDD VSS \$705
+ gf180mcu_fd_sc_mcu9t5v0__nand4_1
* cell instance gf180mcu_fd_sc_mcu9t5v0__nor2_1_0 r0 *1 0,0
Xgf180mcu_fd_sc_mcu9t5v0__nor2_1_0 \$455 \$447 VDD VSS \$430
+ gf180mcu_fd_sc_mcu9t5v0__nor2_1
* cell instance gf180mcu_fd_sc_mcu9t5v0__nor2_1_1 r0 *1 0,0
Xgf180mcu_fd_sc_mcu9t5v0__nor2_1_1 \$309 \$268 VDD VSS \$363
+ gf180mcu_fd_sc_mcu9t5v0__nor2_1
* cell instance gf180mcu_fd_sc_mcu9t5v0__nor2_1_2 r0 *1 0,0
Xgf180mcu_fd_sc_mcu9t5v0__nor2_1_2 \$455 \$316 VDD VSS \$372
+ gf180mcu_fd_sc_mcu9t5v0__nor2_1
* cell instance gf180mcu_fd_sc_mcu9t5v0__nor2_1_3 r0 *1 0,0
Xgf180mcu_fd_sc_mcu9t5v0__nor2_1_3 \$455 \$448 VDD VSS \$431
+ gf180mcu_fd_sc_mcu9t5v0__nor2_1
* cell instance gf180mcu_fd_sc_mcu9t5v0__nor2_1_4 r0 *1 0,0
Xgf180mcu_fd_sc_mcu9t5v0__nor2_1_4 \$681 \$659 VDD VSS \$722
+ gf180mcu_fd_sc_mcu9t5v0__nor2_1
* cell instance gf180mcu_fd_sc_mcu9t5v0__nor2_1_5 r0 *1 0,0
Xgf180mcu_fd_sc_mcu9t5v0__nor2_1_5 \$455 \$401 VDD VSS \$437
+ gf180mcu_fd_sc_mcu9t5v0__nor2_1
* cell instance gf180mcu_fd_sc_mcu9t5v0__nor2_1_6 r0 *1 0,0
Xgf180mcu_fd_sc_mcu9t5v0__nor2_1_6 \$455 \$363 VDD VSS \$432
+ gf180mcu_fd_sc_mcu9t5v0__nor2_1
* cell instance gf180mcu_fd_sc_mcu9t5v0__nor2_1_7 r0 *1 0,0
Xgf180mcu_fd_sc_mcu9t5v0__nor2_1_7 \$526 \$687 VDD VSS \$700
+ gf180mcu_fd_sc_mcu9t5v0__nor2_1
* cell instance gf180mcu_fd_sc_mcu9t5v0__nor2_1_8 r0 *1 0,0
Xgf180mcu_fd_sc_mcu9t5v0__nor2_1_8 \$510 \$622 VDD VSS \$618
+ gf180mcu_fd_sc_mcu9t5v0__nor2_1
* cell instance gf180mcu_fd_sc_mcu9t5v0__nor2_1_9 r0 *1 0,0
Xgf180mcu_fd_sc_mcu9t5v0__nor2_1_9 \$622 \$598 VDD VSS \$693
+ gf180mcu_fd_sc_mcu9t5v0__nor2_1
* cell instance gf180mcu_fd_sc_mcu9t5v0__nor2_1_10 r0 *1 0,0
Xgf180mcu_fd_sc_mcu9t5v0__nor2_1_10 \$794 \$790 VDD VSS \$703
+ gf180mcu_fd_sc_mcu9t5v0__nor2_1
* cell instance gf180mcu_fd_sc_mcu9t5v0__nor2_1_11 r0 *1 0,0
Xgf180mcu_fd_sc_mcu9t5v0__nor2_1_11 \$467 \$502 VDD VSS \$468
+ gf180mcu_fd_sc_mcu9t5v0__nor2_1
* cell instance gf180mcu_fd_sc_mcu9t5v0__nor2_1_12 r0 *1 0,0
Xgf180mcu_fd_sc_mcu9t5v0__nor2_1_12 \$740 \$752 VDD VSS \$825
+ gf180mcu_fd_sc_mcu9t5v0__nor2_1
* cell instance gf180mcu_fd_sc_mcu9t5v0__nor2_1_13 r0 *1 0,0
Xgf180mcu_fd_sc_mcu9t5v0__nor2_1_13 \$510 \$624 VDD VSS \$607
+ gf180mcu_fd_sc_mcu9t5v0__nor2_1
* cell instance gf180mcu_fd_sc_mcu9t5v0__nor2_1_14 r0 *1 0,0
Xgf180mcu_fd_sc_mcu9t5v0__nor2_1_14 \$506 \$624 VDD VSS \$573
+ gf180mcu_fd_sc_mcu9t5v0__nor2_1
* cell instance gf180mcu_fd_sc_mcu9t5v0__nor2_1_15 r0 *1 0,0
Xgf180mcu_fd_sc_mcu9t5v0__nor2_1_15 \$208 \$424 VDD VSS \$345
+ gf180mcu_fd_sc_mcu9t5v0__nor2_1
* cell instance gf180mcu_fd_sc_mcu9t5v0__nor2_1_16 r0 *1 0,0
Xgf180mcu_fd_sc_mcu9t5v0__nor2_1_16 \$797 \$730 VDD VSS \$713
+ gf180mcu_fd_sc_mcu9t5v0__nor2_1
* cell instance gf180mcu_fd_sc_mcu9t5v0__nor2_1_17 r0 *1 0,0
Xgf180mcu_fd_sc_mcu9t5v0__nor2_1_17 \$342 \$777 VDD VSS \$297
+ gf180mcu_fd_sc_mcu9t5v0__nor2_1
* cell instance gf180mcu_fd_sc_mcu9t5v0__nor2_1_18 r0 *1 0,0
Xgf180mcu_fd_sc_mcu9t5v0__nor2_1_18 \$467 \$224 VDD VSS \$214
+ gf180mcu_fd_sc_mcu9t5v0__nor2_1
* cell instance gf180mcu_fd_sc_mcu9t5v0__nor2_1_19 r0 *1 0,0
Xgf180mcu_fd_sc_mcu9t5v0__nor2_1_19 \$553 \$841 VDD VSS \$842
+ gf180mcu_fd_sc_mcu9t5v0__nor2_1
* cell instance gf180mcu_fd_sc_mcu9t5v0__nor2_1_20 r0 *1 0,0
Xgf180mcu_fd_sc_mcu9t5v0__nor2_1_20 \$834 \$829 VDD VSS \$831
+ gf180mcu_fd_sc_mcu9t5v0__nor2_1
* cell instance gf180mcu_fd_sc_mcu9t5v0__nor2_1_21 r0 *1 0,0
Xgf180mcu_fd_sc_mcu9t5v0__nor2_1_21 \$259 \$553 VDD VSS \$833
+ gf180mcu_fd_sc_mcu9t5v0__nor2_1
* cell instance gf180mcu_fd_sc_mcu9t5v0__nor2_2_0 r0 *1 0,0
Xgf180mcu_fd_sc_mcu9t5v0__nor2_2_0 \$699 \$769 VDD VSS \$781
+ gf180mcu_fd_sc_mcu9t5v0__nor2_2
* cell instance gf180mcu_fd_sc_mcu9t5v0__nor2_2_1 r0 *1 0,0
Xgf180mcu_fd_sc_mcu9t5v0__nor2_2_1 \$790 \$819 VDD VSS \$553
+ gf180mcu_fd_sc_mcu9t5v0__nor2_2
* cell instance gf180mcu_fd_sc_mcu9t5v0__nor2_4_0 r0 *1 0,0
Xgf180mcu_fd_sc_mcu9t5v0__nor2_4_0 \$631 \$657 VDD VSS \$628
+ gf180mcu_fd_sc_mcu9t5v0__nor2_4
* cell instance gf180mcu_fd_sc_mcu9t5v0__nor2_4_1 r0 *1 0,0
Xgf180mcu_fd_sc_mcu9t5v0__nor2_4_1 \$304 \$300 VDD VSS \$506
+ gf180mcu_fd_sc_mcu9t5v0__nor2_4
* cell instance gf180mcu_fd_sc_mcu9t5v0__nor3_1_0 r0 *1 0,0
Xgf180mcu_fd_sc_mcu9t5v0__nor3_1_0 \$310 \$183 \$254 VDD VSS \$268
+ gf180mcu_fd_sc_mcu9t5v0__nor3_1
* cell instance gf180mcu_fd_sc_mcu9t5v0__nor3_1_1 r0 *1 0,0
Xgf180mcu_fd_sc_mcu9t5v0__nor3_1_1 \$834 \$829 \$814 VDD VSS \$799
+ gf180mcu_fd_sc_mcu9t5v0__nor3_1
* cell instance gf180mcu_fd_sc_mcu9t5v0__nor3_2_0 r0 *1 0,0
Xgf180mcu_fd_sc_mcu9t5v0__nor3_2_0 \$749 \$614 \$689 VDD VSS \$821
+ gf180mcu_fd_sc_mcu9t5v0__nor3_2
* cell instance gf180mcu_fd_sc_mcu9t5v0__nor3_2_1 r0 *1 0,0
Xgf180mcu_fd_sc_mcu9t5v0__nor3_2_1 \$703 \$718 \$740 VDD VSS \$304
+ gf180mcu_fd_sc_mcu9t5v0__nor3_2
* cell instance gf180mcu_fd_sc_mcu9t5v0__nor3_4_0 r0 *1 0,0
Xgf180mcu_fd_sc_mcu9t5v0__nor3_4_0 \$675 \$722 \$638 VDD VSS \$769
+ gf180mcu_fd_sc_mcu9t5v0__nor3_4
* cell instance gf180mcu_fd_sc_mcu9t5v0__nor4_1_0 r0 *1 0,0
Xgf180mcu_fd_sc_mcu9t5v0__nor4_1_0 \$749 \$700 \$699 \$769 VDD VSS \$794
+ gf180mcu_fd_sc_mcu9t5v0__nor4_1
* cell instance gf180mcu_fd_sc_mcu9t5v0__nor4_1_1 r0 *1 0,0
Xgf180mcu_fd_sc_mcu9t5v0__nor4_1_1 \$259 \$552 \$551 \$471 VDD VSS \$300
+ gf180mcu_fd_sc_mcu9t5v0__nor4_1
* cell instance gf180mcu_fd_sc_mcu9t5v0__oai211_1_0 r0 *1 0,0
Xgf180mcu_fd_sc_mcu9t5v0__oai211_1_0 \$222 \$181 \$110 \$51 VDD VSS \$188
+ gf180mcu_fd_sc_mcu9t5v0__oai211_1
* cell instance gf180mcu_fd_sc_mcu9t5v0__oai211_1_1 r0 *1 0,0
Xgf180mcu_fd_sc_mcu9t5v0__oai211_1_1 \$257 \$151 \$180 \$47 VDD VSS \$133
+ gf180mcu_fd_sc_mcu9t5v0__oai211_1
* cell instance gf180mcu_fd_sc_mcu9t5v0__oai211_1_2 r0 *1 0,0
Xgf180mcu_fd_sc_mcu9t5v0__oai211_1_2 \$715 \$714 \$735 \$705 VDD VSS \$620
+ gf180mcu_fd_sc_mcu9t5v0__oai211_1
* cell instance gf180mcu_fd_sc_mcu9t5v0__oai211_1_3 r0 *1 0,0
Xgf180mcu_fd_sc_mcu9t5v0__oai211_1_3 \$602 \$554 \$556 \$506 VDD VSS \$429
+ gf180mcu_fd_sc_mcu9t5v0__oai211_1
* cell instance gf180mcu_fd_sc_mcu9t5v0__oai211_1_4 r0 *1 0,0
Xgf180mcu_fd_sc_mcu9t5v0__oai211_1_4 \$837 \$833 \$820 \$844 VDD VSS \$778
+ gf180mcu_fd_sc_mcu9t5v0__oai211_1
* cell instance gf180mcu_fd_sc_mcu9t5v0__oai211_1_5 r0 *1 0,0
Xgf180mcu_fd_sc_mcu9t5v0__oai211_1_5 \$674 \$673 \$628 \$621 VDD VSS \$599
+ gf180mcu_fd_sc_mcu9t5v0__oai211_1
* cell instance gf180mcu_fd_sc_mcu9t5v0__oai21_1_0 r0 *1 0,0
Xgf180mcu_fd_sc_mcu9t5v0__oai21_1_0 \$105 \$78 \$79 VDD VSS \$103
+ gf180mcu_fd_sc_mcu9t5v0__oai21_1
* cell instance gf180mcu_fd_sc_mcu9t5v0__oai21_1_1 r0 *1 0,0
Xgf180mcu_fd_sc_mcu9t5v0__oai21_1_1 \$98 \$363 \$47 VDD VSS \$347
+ gf180mcu_fd_sc_mcu9t5v0__oai21_1
* cell instance gf180mcu_fd_sc_mcu9t5v0__oai21_1_2 r0 *1 0,0
Xgf180mcu_fd_sc_mcu9t5v0__oai21_1_2 \$675 \$722 \$638 VDD VSS \$780
+ gf180mcu_fd_sc_mcu9t5v0__oai21_1
* cell instance gf180mcu_fd_sc_mcu9t5v0__oai21_1_3 r0 *1 0,0
Xgf180mcu_fd_sc_mcu9t5v0__oai21_1_3 \$145 \$363 \$47 VDD VSS \$349
+ gf180mcu_fd_sc_mcu9t5v0__oai21_1
* cell instance gf180mcu_fd_sc_mcu9t5v0__oai21_1_4 r0 *1 0,0
Xgf180mcu_fd_sc_mcu9t5v0__oai21_1_4 \$623 \$739 \$738 VDD VSS \$728
+ gf180mcu_fd_sc_mcu9t5v0__oai21_1
* cell instance gf180mcu_fd_sc_mcu9t5v0__oai21_1_5 r0 *1 0,0
Xgf180mcu_fd_sc_mcu9t5v0__oai21_1_5 \$794 \$790 \$751 VDD VSS \$783
+ gf180mcu_fd_sc_mcu9t5v0__oai21_1
* cell instance gf180mcu_fd_sc_mcu9t5v0__oai21_1_6 r0 *1 0,0
Xgf180mcu_fd_sc_mcu9t5v0__oai21_1_6 \$693 \$813 \$783 VDD VSS \$763
+ gf180mcu_fd_sc_mcu9t5v0__oai21_1
* cell instance gf180mcu_fd_sc_mcu9t5v0__oai21_1_7 r0 *1 0,0
Xgf180mcu_fd_sc_mcu9t5v0__oai21_1_7 \$703 \$718 \$712 VDD VSS \$704
+ gf180mcu_fd_sc_mcu9t5v0__oai21_1
* cell instance gf180mcu_fd_sc_mcu9t5v0__oai21_1_8 r0 *1 0,0
Xgf180mcu_fd_sc_mcu9t5v0__oai21_1_8 \$101 \$150 \$47 VDD VSS \$258
+ gf180mcu_fd_sc_mcu9t5v0__oai21_1
* cell instance gf180mcu_fd_sc_mcu9t5v0__oai21_1_9 r0 *1 0,0
Xgf180mcu_fd_sc_mcu9t5v0__oai21_1_9 \$365 \$297 \$223 VDD VSS \$443
+ gf180mcu_fd_sc_mcu9t5v0__oai21_1
* cell instance gf180mcu_fd_sc_mcu9t5v0__oai21_1_10 r0 *1 0,0
Xgf180mcu_fd_sc_mcu9t5v0__oai21_1_10 \$814 \$670 \$671 VDD VSS \$672
+ gf180mcu_fd_sc_mcu9t5v0__oai21_1
* cell instance gf180mcu_fd_sc_mcu9t5v0__oai21_1_11 r0 *1 0,0
Xgf180mcu_fd_sc_mcu9t5v0__oai21_1_11 \$628 \$621 \$615 VDD VSS \$627
+ gf180mcu_fd_sc_mcu9t5v0__oai21_1
* cell instance gf180mcu_fd_sc_mcu9t5v0__oai21_1_12 r0 *1 0,0
Xgf180mcu_fd_sc_mcu9t5v0__oai21_1_12 \$837 \$833 \$844 VDD VSS \$856
+ gf180mcu_fd_sc_mcu9t5v0__oai21_1
* cell instance gf180mcu_fd_sc_mcu9t5v0__oai21_2_0 r0 *1 0,0
Xgf180mcu_fd_sc_mcu9t5v0__oai21_2_0 \$510 \$506 \$630 VDD VSS \$247
+ gf180mcu_fd_sc_mcu9t5v0__oai21_2
* cell instance gf180mcu_fd_sc_mcu9t5v0__oai21_4_0 r0 *1 0,0
Xgf180mcu_fd_sc_mcu9t5v0__oai21_4_0 \$304 \$710 \$741 VDD VSS \$260
+ gf180mcu_fd_sc_mcu9t5v0__oai21_4
* cell instance gf180mcu_fd_sc_mcu9t5v0__oai22_1_0 r0 *1 0,0
Xgf180mcu_fd_sc_mcu9t5v0__oai22_1_0 \$749 \$700 \$699 \$769 VDD VSS \$726
+ gf180mcu_fd_sc_mcu9t5v0__oai22_1
* cell instance gf180mcu_fd_sc_mcu9t5v0__oai22_1_1 r0 *1 0,0
Xgf180mcu_fd_sc_mcu9t5v0__oai22_1_1 \$250 \$260 \$272 \$211 VDD VSS \$263
+ gf180mcu_fd_sc_mcu9t5v0__oai22_1
* cell instance gf180mcu_fd_sc_mcu9t5v0__oai32_1_0 r0 *1 0,0
Xgf180mcu_fd_sc_mcu9t5v0__oai32_1_0 \$370 \$361 \$395 \$300 \$304 VDD VSS \$392
+ gf180mcu_fd_sc_mcu9t5v0__oai32_1
* cell instance gf180mcu_fd_sc_mcu9t5v0__oai32_1_1 r0 *1 0,0
Xgf180mcu_fd_sc_mcu9t5v0__oai32_1_1 \$272 \$211 \$238 \$300 \$304 VDD VSS \$261
+ gf180mcu_fd_sc_mcu9t5v0__oai32_1
* cell instance gf180mcu_fd_sc_mcu9t5v0__oai32_4_0 r0 *1 0,0
Xgf180mcu_fd_sc_mcu9t5v0__oai32_4_0 \$702 \$781 \$821 \$819 \$790 VDD VSS \$740
+ gf180mcu_fd_sc_mcu9t5v0__oai32_4
* cell instance gf180mcu_fd_sc_mcu9t5v0__or2_1_0 r0 *1 0,0
Xgf180mcu_fd_sc_mcu9t5v0__or2_1_0 \$364 \$343 VDD VSS \$581
+ gf180mcu_fd_sc_mcu9t5v0__or2_1
* cell instance gf180mcu_fd_sc_mcu9t5v0__or2_1_1 r0 *1 0,0
Xgf180mcu_fd_sc_mcu9t5v0__or2_1_1 \$614 \$689 VDD VSS \$819
+ gf180mcu_fd_sc_mcu9t5v0__or2_1
* cell instance gf180mcu_fd_sc_mcu9t5v0__or2_1_2 r0 *1 0,0
Xgf180mcu_fd_sc_mcu9t5v0__or2_1_2 \$551 \$550 VDD VSS \$498
+ gf180mcu_fd_sc_mcu9t5v0__or2_1
* cell instance gf180mcu_fd_sc_mcu9t5v0__or2_1_3 r0 *1 0,0
Xgf180mcu_fd_sc_mcu9t5v0__or2_1_3 \$790 \$819 VDD VSS \$764
+ gf180mcu_fd_sc_mcu9t5v0__or2_1
* cell instance gf180mcu_fd_sc_mcu9t5v0__or2_1_4 r0 *1 0,0
Xgf180mcu_fd_sc_mcu9t5v0__or2_1_4 \$342 \$740 VDD VSS \$838
+ gf180mcu_fd_sc_mcu9t5v0__or2_1
* cell instance gf180mcu_fd_sc_mcu9t5v0__or2_1_5 r0 *1 0,0
Xgf180mcu_fd_sc_mcu9t5v0__or2_1_5 \$842 \$831 VDD VSS \$670
+ gf180mcu_fd_sc_mcu9t5v0__or2_1
* cell instance gf180mcu_fd_sc_mcu9t5v0__or2_1_6 r0 *1 0,0
Xgf180mcu_fd_sc_mcu9t5v0__or2_1_6 \$250 \$553 VDD VSS \$742
+ gf180mcu_fd_sc_mcu9t5v0__or2_1
* cell instance gf180mcu_fd_sc_mcu9t5v0__or2_2_0 r0 *1 0,0
Xgf180mcu_fd_sc_mcu9t5v0__or2_2_0 \$681 \$659 VDD VSS \$698
+ gf180mcu_fd_sc_mcu9t5v0__or2_2
* cell instance gf180mcu_fd_sc_mcu9t5v0__or2_2_1 r0 *1 0,0
Xgf180mcu_fd_sc_mcu9t5v0__or2_2_1 \$304 \$300 VDD VSS \$467
+ gf180mcu_fd_sc_mcu9t5v0__or2_2
* cell instance gf180mcu_fd_sc_mcu9t5v0__or2_4_0 r0 *1 0,0
Xgf180mcu_fd_sc_mcu9t5v0__or2_4_0 \$526 \$687 VDD VSS \$702
+ gf180mcu_fd_sc_mcu9t5v0__or2_4
* cell instance gf180mcu_fd_sc_mcu9t5v0__or2_4_1 r0 *1 0,0
Xgf180mcu_fd_sc_mcu9t5v0__or2_4_1 \$647 \$656 VDD VSS \$631
+ gf180mcu_fd_sc_mcu9t5v0__or2_4
* cell instance gf180mcu_fd_sc_mcu9t5v0__or4_1_0 r0 *1 0,0
Xgf180mcu_fd_sc_mcu9t5v0__or4_1_0 \$453 \$342 \$250 \$512 VDD VSS \$471
+ gf180mcu_fd_sc_mcu9t5v0__or4_1
* cell instance gf180mcu_fd_sc_mcu9t5v0__xnor2_1_0 r0 *1 0,0
Xgf180mcu_fd_sc_mcu9t5v0__xnor2_1_0 \$181 \$267 VDD VSS \$254
+ gf180mcu_fd_sc_mcu9t5v0__xnor2_1
* cell instance gf180mcu_fd_sc_mcu9t5v0__xnor2_1_1 r0 *1 0,0
Xgf180mcu_fd_sc_mcu9t5v0__xnor2_1_1 \$155 \$363 VDD VSS \$447
+ gf180mcu_fd_sc_mcu9t5v0__xnor2_1
* cell instance gf180mcu_fd_sc_mcu9t5v0__xnor2_1_2 r0 *1 0,0
Xgf180mcu_fd_sc_mcu9t5v0__xnor2_1_2 \$105 \$78 VDD VSS \$156
+ gf180mcu_fd_sc_mcu9t5v0__xnor2_1
* cell instance gf180mcu_fd_sc_mcu9t5v0__xnor2_1_3 r0 *1 0,0
Xgf180mcu_fd_sc_mcu9t5v0__xnor2_1_3 \$486 \$659 VDD VSS \$743
+ gf180mcu_fd_sc_mcu9t5v0__xnor2_1
* cell instance gf180mcu_fd_sc_mcu9t5v0__xnor2_1_4 r0 *1 0,0
Xgf180mcu_fd_sc_mcu9t5v0__xnor2_1_4 \$144 \$143 VDD VSS \$45
+ gf180mcu_fd_sc_mcu9t5v0__xnor2_1
* cell instance gf180mcu_fd_sc_mcu9t5v0__xnor2_1_5 r0 *1 0,0
Xgf180mcu_fd_sc_mcu9t5v0__xnor2_1_5 \$486 \$247 VDD VSS \$569
+ gf180mcu_fd_sc_mcu9t5v0__xnor2_1
* cell instance gf180mcu_fd_sc_mcu9t5v0__xnor2_1_6 r0 *1 0,0
Xgf180mcu_fd_sc_mcu9t5v0__xnor2_1_6 \$364 \$247 VDD VSS \$344
+ gf180mcu_fd_sc_mcu9t5v0__xnor2_1
* cell instance gf180mcu_fd_sc_mcu9t5v0__xnor2_1_7 r0 *1 0,0
Xgf180mcu_fd_sc_mcu9t5v0__xnor2_1_7 \$343 \$247 VDD VSS \$232
+ gf180mcu_fd_sc_mcu9t5v0__xnor2_1
* cell instance gf180mcu_fd_sc_mcu9t5v0__xnor2_1_8 r0 *1 0,0
Xgf180mcu_fd_sc_mcu9t5v0__xnor2_1_8 \$525 \$247 VDD VSS \$450
+ gf180mcu_fd_sc_mcu9t5v0__xnor2_1
* cell instance gf180mcu_fd_sc_mcu9t5v0__xnor2_1_9 r0 *1 0,0
Xgf180mcu_fd_sc_mcu9t5v0__xnor2_1_9 \$564 \$247 VDD VSS \$529
+ gf180mcu_fd_sc_mcu9t5v0__xnor2_1
* cell instance gf180mcu_fd_sc_mcu9t5v0__xnor2_1_10 r0 *1 0,0
Xgf180mcu_fd_sc_mcu9t5v0__xnor2_1_10 \$654 \$618 VDD VSS \$550
+ gf180mcu_fd_sc_mcu9t5v0__xnor2_1
* cell instance gf180mcu_fd_sc_mcu9t5v0__xnor2_1_11 r0 *1 0,0
Xgf180mcu_fd_sc_mcu9t5v0__xnor2_1_11 \$510 \$552 VDD VSS \$655
+ gf180mcu_fd_sc_mcu9t5v0__xnor2_1
* cell instance gf180mcu_fd_sc_mcu9t5v0__xnor2_1_12 r0 *1 0,0
Xgf180mcu_fd_sc_mcu9t5v0__xnor2_1_12 \$551 \$729 VDD VSS \$751
+ gf180mcu_fd_sc_mcu9t5v0__xnor2_1
* cell instance gf180mcu_fd_sc_mcu9t5v0__xnor2_1_13 r0 *1 0,0
Xgf180mcu_fd_sc_mcu9t5v0__xnor2_1_13 \$693 \$813 VDD VSS \$773
+ gf180mcu_fd_sc_mcu9t5v0__xnor2_1
* cell instance gf180mcu_fd_sc_mcu9t5v0__xnor2_1_14 r0 *1 0,0
Xgf180mcu_fd_sc_mcu9t5v0__xnor2_1_14 \$552 \$622 VDD VSS \$624
+ gf180mcu_fd_sc_mcu9t5v0__xnor2_1
* cell instance gf180mcu_fd_sc_mcu9t5v0__xnor2_1_15 r0 *1 0,0
Xgf180mcu_fd_sc_mcu9t5v0__xnor2_1_15 \$797 \$730 VDD VSS \$752
+ gf180mcu_fd_sc_mcu9t5v0__xnor2_1
* cell instance gf180mcu_fd_sc_mcu9t5v0__xnor2_1_16 r0 *1 0,0
Xgf180mcu_fd_sc_mcu9t5v0__xnor2_1_16 \$259 \$260 VDD VSS \$213
+ gf180mcu_fd_sc_mcu9t5v0__xnor2_1
* cell instance gf180mcu_fd_sc_mcu9t5v0__xnor2_1_17 r0 *1 0,0
Xgf180mcu_fd_sc_mcu9t5v0__xnor2_1_17 \$512 \$732 VDD VSS \$734
+ gf180mcu_fd_sc_mcu9t5v0__xnor2_1
* cell instance gf180mcu_fd_sc_mcu9t5v0__xnor2_1_18 r0 *1 0,0
Xgf180mcu_fd_sc_mcu9t5v0__xnor2_1_18 \$250 \$793 VDD VSS \$787
+ gf180mcu_fd_sc_mcu9t5v0__xnor2_1
* cell instance gf180mcu_fd_sc_mcu9t5v0__xnor2_1_19 r0 *1 0,0
Xgf180mcu_fd_sc_mcu9t5v0__xnor2_1_19 \$259 \$713 VDD VSS \$841
+ gf180mcu_fd_sc_mcu9t5v0__xnor2_1
* cell instance gf180mcu_fd_sc_mcu9t5v0__xnor2_1_20 r0 *1 0,0
Xgf180mcu_fd_sc_mcu9t5v0__xnor2_1_20 \$453 \$553 VDD VSS \$504
+ gf180mcu_fd_sc_mcu9t5v0__xnor2_1
* cell instance gf180mcu_fd_sc_mcu9t5v0__xnor2_1_21 r0 *1 0,0
Xgf180mcu_fd_sc_mcu9t5v0__xnor2_1_21 \$834 \$829 VDD VSS \$632
+ gf180mcu_fd_sc_mcu9t5v0__xnor2_1
* cell instance gf180mcu_fd_sc_mcu9t5v0__xnor2_1_22 r0 *1 0,0
Xgf180mcu_fd_sc_mcu9t5v0__xnor2_1_22 \$764 \$734 VDD VSS \$714
+ gf180mcu_fd_sc_mcu9t5v0__xnor2_1
* cell instance gf180mcu_fd_sc_mcu9t5v0__xnor2_1_23 r0 *1 0,0
Xgf180mcu_fd_sc_mcu9t5v0__xnor2_1_23 \$553 \$841 VDD VSS \$829
+ gf180mcu_fd_sc_mcu9t5v0__xnor2_1
* cell instance gf180mcu_fd_sc_mcu9t5v0__xnor2_1_24 r0 *1 0,0
Xgf180mcu_fd_sc_mcu9t5v0__xnor2_1_24 \$764 \$787 VDD VSS \$814
+ gf180mcu_fd_sc_mcu9t5v0__xnor2_1
* cell instance gf180mcu_fd_sc_mcu9t5v0__xnor2_1_25 r0 *1 0,0
Xgf180mcu_fd_sc_mcu9t5v0__xnor2_1_25 \$512 \$260 VDD VSS \$362
+ gf180mcu_fd_sc_mcu9t5v0__xnor2_1
* cell instance gf180mcu_fd_sc_mcu9t5v0__xnor2_2_0 r0 *1 0,0
Xgf180mcu_fd_sc_mcu9t5v0__xnor2_2_0 \$526 \$687 VDD VSS \$622
+ gf180mcu_fd_sc_mcu9t5v0__xnor2_2
* cell instance gf180mcu_fd_sc_mcu9t5v0__xnor2_2_1 r0 *1 0,0
Xgf180mcu_fd_sc_mcu9t5v0__xnor2_2_1 \$512 \$764 VDD VSS \$711
+ gf180mcu_fd_sc_mcu9t5v0__xnor2_2
* cell instance gf180mcu_fd_sc_mcu9t5v0__xnor2_4_0 r0 *1 0,0
Xgf180mcu_fd_sc_mcu9t5v0__xnor2_4_0 \$740 \$704 VDD VSS \$777
+ gf180mcu_fd_sc_mcu9t5v0__xnor2_4
* cell instance gf180mcu_fd_sc_mcu9t5v0__xnor3_1_0 r0 *1 0,0
Xgf180mcu_fd_sc_mcu9t5v0__xnor3_1_0 \$487 \$564 \$617 VDD VSS \$659
+ gf180mcu_fd_sc_mcu9t5v0__xnor3_1
* cell instance gf180mcu_fd_sc_mcu9t5v0__xnor3_1_1 r0 *1 0,0
Xgf180mcu_fd_sc_mcu9t5v0__xnor3_1_1 \$551 \$654 \$623 VDD VSS \$662
+ gf180mcu_fd_sc_mcu9t5v0__xnor3_1
* cell instance gf180mcu_fd_sc_mcu9t5v0__xnor3_1_2 r0 *1 0,0
Xgf180mcu_fd_sc_mcu9t5v0__xnor3_1_2 \$551 \$550 \$501 VDD VSS \$534
+ gf180mcu_fd_sc_mcu9t5v0__xnor3_1
* cell instance gf180mcu_fd_sc_mcu9t5v0__xnor3_1_3 r0 *1 0,0
Xgf180mcu_fd_sc_mcu9t5v0__xnor3_1_3 \$801 \$781 \$751 VDD VSS \$813
+ gf180mcu_fd_sc_mcu9t5v0__xnor3_1
* cell instance gf180mcu_fd_sc_mcu9t5v0__xnor3_1_4 r0 *1 0,0
Xgf180mcu_fd_sc_mcu9t5v0__xnor3_1_4 \$622 \$504 \$598 VDD VSS \$592
+ gf180mcu_fd_sc_mcu9t5v0__xnor3_1
* cell instance gf180mcu_fd_sc_mcu9t5v0__xnor3_1_5 r0 *1 0,0
Xgf180mcu_fd_sc_mcu9t5v0__xnor3_1_5 \$797 \$740 \$728 VDD VSS \$656
+ gf180mcu_fd_sc_mcu9t5v0__xnor3_1
* cell instance gf180mcu_fd_sc_mcu9t5v0__xnor3_1_6 r0 *1 0,0
Xgf180mcu_fd_sc_mcu9t5v0__xnor3_1_6 \$504 \$599 \$616 VDD VSS \$554
+ gf180mcu_fd_sc_mcu9t5v0__xnor3_1
* cell instance gf180mcu_fd_sc_mcu9t5v0__xnor3_2_0 r0 *1 0,0
Xgf180mcu_fd_sc_mcu9t5v0__xnor3_2_0 \$681 \$425 \$659 VDD VSS \$687
+ gf180mcu_fd_sc_mcu9t5v0__xnor3_2
* cell instance gf180mcu_fd_sc_mcu9t5v0__xnor3_2_1 r0 *1 0,0
Xgf180mcu_fd_sc_mcu9t5v0__xnor3_2_1 \$259 \$553 \$837 VDD VSS \$657
+ gf180mcu_fd_sc_mcu9t5v0__xnor3_2
* cell instance gf180mcu_fd_sc_mcu9t5v0__xnor3_4_0 r0 *1 0,0
Xgf180mcu_fd_sc_mcu9t5v0__xnor3_4_0 \$740 \$752 \$763 VDD VSS \$757
+ gf180mcu_fd_sc_mcu9t5v0__xnor3_4
* cell instance gf180mcu_fd_sc_mcu9t5v0__xor2_1_0 r0 *1 0,0
Xgf180mcu_fd_sc_mcu9t5v0__xor2_1_0 \$103 \$50 VDD VSS \$181
+ gf180mcu_fd_sc_mcu9t5v0__xor2_1
* cell instance gf180mcu_fd_sc_mcu9t5v0__xor2_1_1 r0 *1 0,0
Xgf180mcu_fd_sc_mcu9t5v0__xor2_1_1 \$60 \$156 VDD VSS \$275
+ gf180mcu_fd_sc_mcu9t5v0__xor2_1
* cell instance gf180mcu_fd_sc_mcu9t5v0__xor2_1_2 r0 *1 0,0
Xgf180mcu_fd_sc_mcu9t5v0__xor2_1_2 \$167 \$275 VDD VSS \$182
+ gf180mcu_fd_sc_mcu9t5v0__xor2_1
* cell instance gf180mcu_fd_sc_mcu9t5v0__xor2_1_3 r0 *1 0,0
Xgf180mcu_fd_sc_mcu9t5v0__xor2_1_3 \$228 \$363 VDD VSS \$401
+ gf180mcu_fd_sc_mcu9t5v0__xor2_1
* cell instance gf180mcu_fd_sc_mcu9t5v0__xor2_1_4 r0 *1 0,0
Xgf180mcu_fd_sc_mcu9t5v0__xor2_1_4 \$14 \$45 VDD VSS \$78
+ gf180mcu_fd_sc_mcu9t5v0__xor2_1
* cell instance gf180mcu_fd_sc_mcu9t5v0__xor2_1_5 r0 *1 0,0
Xgf180mcu_fd_sc_mcu9t5v0__xor2_1_5 \$62 \$145 VDD VSS \$143
+ gf180mcu_fd_sc_mcu9t5v0__xor2_1
* cell instance gf180mcu_fd_sc_mcu9t5v0__xor2_1_6 r0 *1 0,0
Xgf180mcu_fd_sc_mcu9t5v0__xor2_1_6 \$25 \$256 VDD VSS \$145
+ gf180mcu_fd_sc_mcu9t5v0__xor2_1
* cell instance gf180mcu_fd_sc_mcu9t5v0__xor2_1_7 r0 *1 0,0
Xgf180mcu_fd_sc_mcu9t5v0__xor2_1_7 \$303 \$247 VDD VSS \$286
+ gf180mcu_fd_sc_mcu9t5v0__xor2_1
* cell instance gf180mcu_fd_sc_mcu9t5v0__xor2_1_8 r0 *1 0,0
Xgf180mcu_fd_sc_mcu9t5v0__xor2_1_8 \$487 \$247 VDD VSS \$423
+ gf180mcu_fd_sc_mcu9t5v0__xor2_1
* cell instance gf180mcu_fd_sc_mcu9t5v0__xor2_1_9 r0 *1 0,0
Xgf180mcu_fd_sc_mcu9t5v0__xor2_1_9 \$425 \$247 VDD VSS \$358
+ gf180mcu_fd_sc_mcu9t5v0__xor2_1
* cell instance gf180mcu_fd_sc_mcu9t5v0__xor2_1_10 r0 *1 0,0
Xgf180mcu_fd_sc_mcu9t5v0__xor2_1_10 \$607 \$662 VDD VSS \$625
+ gf180mcu_fd_sc_mcu9t5v0__xor2_1
* cell instance gf180mcu_fd_sc_mcu9t5v0__xor2_1_11 r0 *1 0,0
Xgf180mcu_fd_sc_mcu9t5v0__xor2_1_11 \$101 \$148 VDD VSS \$151
+ gf180mcu_fd_sc_mcu9t5v0__xor2_1
* cell instance gf180mcu_fd_sc_mcu9t5v0__xor2_1_12 r0 *1 0,0
Xgf180mcu_fd_sc_mcu9t5v0__xor2_1_12 \$213 \$296 VDD VSS \$251
+ gf180mcu_fd_sc_mcu9t5v0__xor2_1
* cell instance gf180mcu_fd_sc_mcu9t5v0__xor2_1_13 r0 *1 0,0
Xgf180mcu_fd_sc_mcu9t5v0__xor2_1_13 \$453 \$260 VDD VSS \$395
+ gf180mcu_fd_sc_mcu9t5v0__xor2_1
* cell instance gf180mcu_fd_sc_mcu9t5v0__xor2_1_14 r0 *1 0,0
Xgf180mcu_fd_sc_mcu9t5v0__xor2_1_14 \$715 \$714 VDD VSS \$574
+ gf180mcu_fd_sc_mcu9t5v0__xor2_1
* cell instance gf180mcu_fd_sc_mcu9t5v0__xor2_1_15 r0 *1 0,0
Xgf180mcu_fd_sc_mcu9t5v0__xor2_1_15 \$250 \$260 VDD VSS \$238
+ gf180mcu_fd_sc_mcu9t5v0__xor2_1
* cell instance gf180mcu_fd_sc_mcu9t5v0__xor2_1_16 r0 *1 0,0
Xgf180mcu_fd_sc_mcu9t5v0__xor2_1_16 \$362 \$241 VDD VSS \$398
+ gf180mcu_fd_sc_mcu9t5v0__xor2_1
* cell instance gf180mcu_fd_sc_mcu9t5v0__xor2_2_0 r0 *1 0,0
Xgf180mcu_fd_sc_mcu9t5v0__xor2_2_0 \$856 \$816 VDD VSS \$621
+ gf180mcu_fd_sc_mcu9t5v0__xor2_2
* cell instance gf180mcu_fd_sc_mcu9t5v0__xor2_4_0 r0 *1 0,0
Xgf180mcu_fd_sc_mcu9t5v0__xor2_4_0 \$564 \$617 VDD VSS \$605
+ gf180mcu_fd_sc_mcu9t5v0__xor2_4
* cell instance gf180mcu_fd_sc_mcu9t5v0__xor2_4_1 r0 *1 0,0
Xgf180mcu_fd_sc_mcu9t5v0__xor2_4_1 \$631 \$657 VDD VSS \$619
+ gf180mcu_fd_sc_mcu9t5v0__xor2_4
* cell instance gf180mcu_fd_sc_mcu9t5v0__xor3_1_0 r0 *1 0,0
Xgf180mcu_fd_sc_mcu9t5v0__xor3_1_0 \$695 \$711 \$717 VDD VSS \$508
+ gf180mcu_fd_sc_mcu9t5v0__xor3_1
* cell instance gf180mcu_fd_sc_mcu9t5v0__xor3_2_0 r0 *1 0,0
Xgf180mcu_fd_sc_mcu9t5v0__xor3_2_0 \$364 \$343 \$303 VDD VSS \$617
+ gf180mcu_fd_sc_mcu9t5v0__xor3_2
.ENDS tmds_encoder

* cell gf180mcu_fd_sc_mcu9t5v0__xor3_2
* pin A1
* pin A2
* pin A3
* pin VDD
* pin VSS
* pin Z
.SUBCKT gf180mcu_fd_sc_mcu9t5v0__xor3_2 A1 A2 A3 VDD VSS Z
.ENDS gf180mcu_fd_sc_mcu9t5v0__xor3_2

* cell gf180mcu_fd_sc_mcu9t5v0__xor3_1
* pin A1
* pin A2
* pin A3
* pin VDD
* pin VSS
* pin Z
.SUBCKT gf180mcu_fd_sc_mcu9t5v0__xor3_1 A1 A2 A3 VDD VSS Z
.ENDS gf180mcu_fd_sc_mcu9t5v0__xor3_1

* cell gf180mcu_fd_sc_mcu9t5v0__xor2_4
* pin A1
* pin A2
* pin VDD
* pin VSS
* pin Z
.SUBCKT gf180mcu_fd_sc_mcu9t5v0__xor2_4 A1 A2 VDD VSS Z
.ENDS gf180mcu_fd_sc_mcu9t5v0__xor2_4

* cell gf180mcu_fd_sc_mcu9t5v0__xor2_2
* pin A1
* pin A2
* pin VDD
* pin VSS
* pin Z
.SUBCKT gf180mcu_fd_sc_mcu9t5v0__xor2_2 A1 A2 VDD VSS Z
.ENDS gf180mcu_fd_sc_mcu9t5v0__xor2_2

* cell gf180mcu_fd_sc_mcu9t5v0__xor2_1
* pin A1
* pin A2
* pin VDD
* pin VSS
* pin Z
.SUBCKT gf180mcu_fd_sc_mcu9t5v0__xor2_1 A1 A2 VDD VSS Z
.ENDS gf180mcu_fd_sc_mcu9t5v0__xor2_1

* cell gf180mcu_fd_sc_mcu9t5v0__xnor3_4
* pin A1
* pin A2
* pin A3
* pin VDD
* pin VSS
* pin ZN
.SUBCKT gf180mcu_fd_sc_mcu9t5v0__xnor3_4 A1 A2 A3 VDD VSS ZN
.ENDS gf180mcu_fd_sc_mcu9t5v0__xnor3_4

* cell gf180mcu_fd_sc_mcu9t5v0__xnor3_2
* pin A1
* pin A2
* pin A3
* pin VDD
* pin VSS
* pin ZN
.SUBCKT gf180mcu_fd_sc_mcu9t5v0__xnor3_2 A1 A2 A3 VDD VSS ZN
.ENDS gf180mcu_fd_sc_mcu9t5v0__xnor3_2

* cell gf180mcu_fd_sc_mcu9t5v0__xnor3_1
* pin A1
* pin A2
* pin A3
* pin VDD
* pin VSS
* pin ZN
.SUBCKT gf180mcu_fd_sc_mcu9t5v0__xnor3_1 A1 A2 A3 VDD VSS ZN
.ENDS gf180mcu_fd_sc_mcu9t5v0__xnor3_1

* cell gf180mcu_fd_sc_mcu9t5v0__xnor2_4
* pin A1
* pin A2
* pin VDD
* pin VSS
* pin ZN
.SUBCKT gf180mcu_fd_sc_mcu9t5v0__xnor2_4 A1 A2 VDD VSS ZN
.ENDS gf180mcu_fd_sc_mcu9t5v0__xnor2_4

* cell gf180mcu_fd_sc_mcu9t5v0__xnor2_2
* pin A1
* pin A2
* pin VDD
* pin VSS
* pin ZN
.SUBCKT gf180mcu_fd_sc_mcu9t5v0__xnor2_2 A1 A2 VDD VSS ZN
.ENDS gf180mcu_fd_sc_mcu9t5v0__xnor2_2

* cell gf180mcu_fd_sc_mcu9t5v0__xnor2_1
* pin A1
* pin A2
* pin VDD
* pin VSS
* pin ZN
.SUBCKT gf180mcu_fd_sc_mcu9t5v0__xnor2_1 A1 A2 VDD VSS ZN
.ENDS gf180mcu_fd_sc_mcu9t5v0__xnor2_1

* cell gf180mcu_fd_sc_mcu9t5v0__or4_1
* pin A1
* pin A2
* pin A3
* pin A4
* pin VDD
* pin VSS
* pin Z
.SUBCKT gf180mcu_fd_sc_mcu9t5v0__or4_1 A1 A2 A3 A4 VDD VSS Z
.ENDS gf180mcu_fd_sc_mcu9t5v0__or4_1

* cell gf180mcu_fd_sc_mcu9t5v0__or2_4
* pin A1
* pin A2
* pin VDD
* pin VSS
* pin Z
.SUBCKT gf180mcu_fd_sc_mcu9t5v0__or2_4 A1 A2 VDD VSS Z
.ENDS gf180mcu_fd_sc_mcu9t5v0__or2_4

* cell gf180mcu_fd_sc_mcu9t5v0__or2_2
* pin A1
* pin A2
* pin VDD
* pin VSS
* pin Z
.SUBCKT gf180mcu_fd_sc_mcu9t5v0__or2_2 A1 A2 VDD VSS Z
.ENDS gf180mcu_fd_sc_mcu9t5v0__or2_2

* cell gf180mcu_fd_sc_mcu9t5v0__or2_1
* pin A1
* pin A2
* pin VDD
* pin VSS
* pin Z
.SUBCKT gf180mcu_fd_sc_mcu9t5v0__or2_1 A1 A2 VDD VSS Z
.ENDS gf180mcu_fd_sc_mcu9t5v0__or2_1

* cell gf180mcu_fd_sc_mcu9t5v0__oai32_4
* pin A1
* pin A2
* pin A3
* pin B1
* pin B2
* pin VDD
* pin VSS
* pin ZN
.SUBCKT gf180mcu_fd_sc_mcu9t5v0__oai32_4 A1 A2 A3 B1 B2 VDD VSS ZN
.ENDS gf180mcu_fd_sc_mcu9t5v0__oai32_4

* cell gf180mcu_fd_sc_mcu9t5v0__oai32_1
* pin A1
* pin A2
* pin A3
* pin B1
* pin B2
* pin VDD
* pin VSS
* pin ZN
.SUBCKT gf180mcu_fd_sc_mcu9t5v0__oai32_1 A1 A2 A3 B1 B2 VDD VSS ZN
.ENDS gf180mcu_fd_sc_mcu9t5v0__oai32_1

* cell gf180mcu_fd_sc_mcu9t5v0__oai22_1
* pin A1
* pin A2
* pin B1
* pin B2
* pin VDD
* pin VSS
* pin ZN
.SUBCKT gf180mcu_fd_sc_mcu9t5v0__oai22_1 A1 A2 B1 B2 VDD VSS ZN
.ENDS gf180mcu_fd_sc_mcu9t5v0__oai22_1

* cell gf180mcu_fd_sc_mcu9t5v0__oai21_4
* pin A1
* pin A2
* pin B
* pin VDD
* pin VSS
* pin ZN
.SUBCKT gf180mcu_fd_sc_mcu9t5v0__oai21_4 A1 A2 B VDD VSS ZN
.ENDS gf180mcu_fd_sc_mcu9t5v0__oai21_4

* cell gf180mcu_fd_sc_mcu9t5v0__oai21_2
* pin A1
* pin A2
* pin B
* pin VDD
* pin VSS
* pin ZN
.SUBCKT gf180mcu_fd_sc_mcu9t5v0__oai21_2 A1 A2 B VDD VSS ZN
.ENDS gf180mcu_fd_sc_mcu9t5v0__oai21_2

* cell gf180mcu_fd_sc_mcu9t5v0__oai21_1
* pin A1
* pin A2
* pin B
* pin VDD
* pin VSS
* pin ZN
.SUBCKT gf180mcu_fd_sc_mcu9t5v0__oai21_1 A1 A2 B VDD VSS ZN
.ENDS gf180mcu_fd_sc_mcu9t5v0__oai21_1

* cell gf180mcu_fd_sc_mcu9t5v0__oai211_1
* pin A1
* pin A2
* pin B
* pin C
* pin VDD
* pin VSS
* pin ZN
.SUBCKT gf180mcu_fd_sc_mcu9t5v0__oai211_1 A1 A2 B C VDD VSS ZN
.ENDS gf180mcu_fd_sc_mcu9t5v0__oai211_1

* cell gf180mcu_fd_sc_mcu9t5v0__nor4_1
* pin A1
* pin A2
* pin A3
* pin A4
* pin VDD
* pin VSS
* pin ZN
.SUBCKT gf180mcu_fd_sc_mcu9t5v0__nor4_1 A1 A2 A3 A4 VDD VSS ZN
.ENDS gf180mcu_fd_sc_mcu9t5v0__nor4_1

* cell gf180mcu_fd_sc_mcu9t5v0__nor3_4
* pin A1
* pin A2
* pin A3
* pin VDD
* pin VSS
* pin ZN
.SUBCKT gf180mcu_fd_sc_mcu9t5v0__nor3_4 A1 A2 A3 VDD VSS ZN
.ENDS gf180mcu_fd_sc_mcu9t5v0__nor3_4

* cell gf180mcu_fd_sc_mcu9t5v0__nor3_2
* pin A1
* pin A2
* pin A3
* pin VDD
* pin VSS
* pin ZN
.SUBCKT gf180mcu_fd_sc_mcu9t5v0__nor3_2 A1 A2 A3 VDD VSS ZN
.ENDS gf180mcu_fd_sc_mcu9t5v0__nor3_2

* cell gf180mcu_fd_sc_mcu9t5v0__nor3_1
* pin A1
* pin A2
* pin A3
* pin VDD
* pin VSS
* pin ZN
.SUBCKT gf180mcu_fd_sc_mcu9t5v0__nor3_1 A1 A2 A3 VDD VSS ZN
.ENDS gf180mcu_fd_sc_mcu9t5v0__nor3_1

* cell gf180mcu_fd_sc_mcu9t5v0__nor2_4
* pin A1
* pin A2
* pin VDD
* pin VSS
* pin ZN
.SUBCKT gf180mcu_fd_sc_mcu9t5v0__nor2_4 A1 A2 VDD VSS ZN
.ENDS gf180mcu_fd_sc_mcu9t5v0__nor2_4

* cell gf180mcu_fd_sc_mcu9t5v0__nor2_2
* pin A1
* pin A2
* pin VDD
* pin VSS
* pin ZN
.SUBCKT gf180mcu_fd_sc_mcu9t5v0__nor2_2 A1 A2 VDD VSS ZN
.ENDS gf180mcu_fd_sc_mcu9t5v0__nor2_2

* cell gf180mcu_fd_sc_mcu9t5v0__nor2_1
* pin A1
* pin A2
* pin VDD
* pin VSS
* pin ZN
.SUBCKT gf180mcu_fd_sc_mcu9t5v0__nor2_1 A1 A2 VDD VSS ZN
.ENDS gf180mcu_fd_sc_mcu9t5v0__nor2_1

* cell gf180mcu_fd_sc_mcu9t5v0__nand4_1
* pin A1
* pin A2
* pin A3
* pin A4
* pin VDD
* pin VSS
* pin ZN
.SUBCKT gf180mcu_fd_sc_mcu9t5v0__nand4_1 A1 A2 A3 A4 VDD VSS ZN
.ENDS gf180mcu_fd_sc_mcu9t5v0__nand4_1

* cell gf180mcu_fd_sc_mcu9t5v0__nand3_1
* pin A1
* pin A2
* pin A3
* pin VDD
* pin VSS
* pin ZN
.SUBCKT gf180mcu_fd_sc_mcu9t5v0__nand3_1 A1 A2 A3 VDD VSS ZN
.ENDS gf180mcu_fd_sc_mcu9t5v0__nand3_1

* cell gf180mcu_fd_sc_mcu9t5v0__nand2_1
* pin A1
* pin A2
* pin VDD
* pin VSS
* pin ZN
.SUBCKT gf180mcu_fd_sc_mcu9t5v0__nand2_1 A1 A2 VDD VSS ZN
.ENDS gf180mcu_fd_sc_mcu9t5v0__nand2_1

* cell gf180mcu_fd_sc_mcu9t5v0__mux2_1
* pin I0
* pin I1
* pin S
* pin VDD
* pin VSS
* pin Z
.SUBCKT gf180mcu_fd_sc_mcu9t5v0__mux2_1 I0 I1 S VDD VSS Z
.ENDS gf180mcu_fd_sc_mcu9t5v0__mux2_1

* cell gf180mcu_fd_sc_mcu9t5v0__inv_2
* pin I
* pin VDD
* pin VSS
* pin ZN
.SUBCKT gf180mcu_fd_sc_mcu9t5v0__inv_2 I VDD VSS ZN
.ENDS gf180mcu_fd_sc_mcu9t5v0__inv_2

* cell gf180mcu_fd_sc_mcu9t5v0__filltie
* pin VDD
* pin VSS
.SUBCKT gf180mcu_fd_sc_mcu9t5v0__filltie VDD VSS
.ENDS gf180mcu_fd_sc_mcu9t5v0__filltie

* cell gf180mcu_fd_sc_mcu9t5v0__fill_8
* pin VDD
* pin VSS
.SUBCKT gf180mcu_fd_sc_mcu9t5v0__fill_8 VDD VSS
.ENDS gf180mcu_fd_sc_mcu9t5v0__fill_8

* cell gf180mcu_fd_sc_mcu9t5v0__fill_64
* pin VDD
* pin VSS
.SUBCKT gf180mcu_fd_sc_mcu9t5v0__fill_64 VDD VSS
.ENDS gf180mcu_fd_sc_mcu9t5v0__fill_64

* cell gf180mcu_fd_sc_mcu9t5v0__fill_4
* pin VDD
* pin VSS
.SUBCKT gf180mcu_fd_sc_mcu9t5v0__fill_4 VDD VSS
.ENDS gf180mcu_fd_sc_mcu9t5v0__fill_4

* cell gf180mcu_fd_sc_mcu9t5v0__fill_32
* pin VDD
* pin VSS
.SUBCKT gf180mcu_fd_sc_mcu9t5v0__fill_32 VDD VSS
.ENDS gf180mcu_fd_sc_mcu9t5v0__fill_32

* cell gf180mcu_fd_sc_mcu9t5v0__fill_2
* pin VDD
* pin VSS
.SUBCKT gf180mcu_fd_sc_mcu9t5v0__fill_2 VDD VSS
.ENDS gf180mcu_fd_sc_mcu9t5v0__fill_2

* cell gf180mcu_fd_sc_mcu9t5v0__fill_16
* pin VDD
* pin VSS
.SUBCKT gf180mcu_fd_sc_mcu9t5v0__fill_16 VDD VSS
.ENDS gf180mcu_fd_sc_mcu9t5v0__fill_16

* cell gf180mcu_fd_sc_mcu9t5v0__fill_1
* pin VDD
* pin VSS
.SUBCKT gf180mcu_fd_sc_mcu9t5v0__fill_1 VDD VSS
.ENDS gf180mcu_fd_sc_mcu9t5v0__fill_1

* cell gf180mcu_fd_sc_mcu9t5v0__endcap
* pin VDD
* pin VSS
.SUBCKT gf180mcu_fd_sc_mcu9t5v0__endcap VDD VSS
.ENDS gf180mcu_fd_sc_mcu9t5v0__endcap

* cell gf180mcu_fd_sc_mcu9t5v0__dlyc_1
* pin I
* pin VDD
* pin VSS
* pin Z
.SUBCKT gf180mcu_fd_sc_mcu9t5v0__dlyc_1 I VDD VSS Z
.ENDS gf180mcu_fd_sc_mcu9t5v0__dlyc_1

* cell gf180mcu_fd_sc_mcu9t5v0__dffq_1
* pin CLK
* pin D
* pin Q
* pin VDD
* pin VSS
.SUBCKT gf180mcu_fd_sc_mcu9t5v0__dffq_1 CLK D Q VDD VSS
.ENDS gf180mcu_fd_sc_mcu9t5v0__dffq_1

* cell gf180mcu_fd_sc_mcu9t5v0__clkinv_1
* pin I
* pin VDD
* pin VSS
* pin ZN
.SUBCKT gf180mcu_fd_sc_mcu9t5v0__clkinv_1 I VDD VSS ZN
.ENDS gf180mcu_fd_sc_mcu9t5v0__clkinv_1

* cell gf180mcu_fd_sc_mcu9t5v0__clkbuf_1
* pin I
* pin VDD
* pin VSS
* pin Z
.SUBCKT gf180mcu_fd_sc_mcu9t5v0__clkbuf_1 I VDD VSS Z
.ENDS gf180mcu_fd_sc_mcu9t5v0__clkbuf_1

* cell gf180mcu_fd_sc_mcu9t5v0__buf_2
* pin I
* pin VDD
* pin VSS
* pin Z
.SUBCKT gf180mcu_fd_sc_mcu9t5v0__buf_2 I VDD VSS Z
.ENDS gf180mcu_fd_sc_mcu9t5v0__buf_2

* cell gf180mcu_fd_sc_mcu9t5v0__buf_1
* pin I
* pin VDD
* pin VSS
* pin Z
.SUBCKT gf180mcu_fd_sc_mcu9t5v0__buf_1 I VDD VSS Z
.ENDS gf180mcu_fd_sc_mcu9t5v0__buf_1

* cell gf180mcu_fd_sc_mcu9t5v0__aoi22_4
* pin A1
* pin A2
* pin B1
* pin B2
* pin VDD
* pin VSS
* pin ZN
.SUBCKT gf180mcu_fd_sc_mcu9t5v0__aoi22_4 A1 A2 B1 B2 VDD VSS ZN
.ENDS gf180mcu_fd_sc_mcu9t5v0__aoi22_4

* cell gf180mcu_fd_sc_mcu9t5v0__aoi22_1
* pin A1
* pin A2
* pin B1
* pin B2
* pin VDD
* pin VSS
* pin ZN
.SUBCKT gf180mcu_fd_sc_mcu9t5v0__aoi22_1 A1 A2 B1 B2 VDD VSS ZN
.ENDS gf180mcu_fd_sc_mcu9t5v0__aoi22_1

* cell gf180mcu_fd_sc_mcu9t5v0__aoi221_2
* pin A1
* pin A2
* pin B1
* pin B2
* pin C
* pin VDD
* pin VSS
* pin ZN
.SUBCKT gf180mcu_fd_sc_mcu9t5v0__aoi221_2 A1 A2 B1 B2 C VDD VSS ZN
.ENDS gf180mcu_fd_sc_mcu9t5v0__aoi221_2

* cell gf180mcu_fd_sc_mcu9t5v0__aoi21_1
* pin A1
* pin A2
* pin B
* pin VDD
* pin VSS
* pin ZN
.SUBCKT gf180mcu_fd_sc_mcu9t5v0__aoi21_1 A1 A2 B VDD VSS ZN
.ENDS gf180mcu_fd_sc_mcu9t5v0__aoi21_1

* cell gf180mcu_fd_sc_mcu9t5v0__aoi211_1
* pin A1
* pin A2
* pin B
* pin C
* pin VDD
* pin VSS
* pin ZN
.SUBCKT gf180mcu_fd_sc_mcu9t5v0__aoi211_1 A1 A2 B C VDD VSS ZN
.ENDS gf180mcu_fd_sc_mcu9t5v0__aoi211_1

* cell gf180mcu_fd_sc_mcu9t5v0__and3_1
* pin A1
* pin A2
* pin A3
* pin VDD
* pin VSS
* pin Z
.SUBCKT gf180mcu_fd_sc_mcu9t5v0__and3_1 A1 A2 A3 VDD VSS Z
.ENDS gf180mcu_fd_sc_mcu9t5v0__and3_1

* cell gf180mcu_fd_sc_mcu9t5v0__and2_1
* pin A1
* pin A2
* pin VDD
* pin VSS
* pin Z
.SUBCKT gf180mcu_fd_sc_mcu9t5v0__and2_1 A1 A2 VDD VSS Z
.ENDS gf180mcu_fd_sc_mcu9t5v0__and2_1
