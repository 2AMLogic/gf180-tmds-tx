* extracted by klt extract --deck gf180mcu
* parasitic model (--parasitics):
* - capacitance: net-to-ground for every net's own (non-coupled) area/perimeter, plus net-to-net for the vertical-overlap coupling `coupling` describes below -- a coupled net pair gets a direct capacitor between their two hub nodes, not just capacitors to the deck's ground/substrate net
* - coupling: vertical overlap (crossover) unconditionally -- where one net's conductor on an adjacent metal level sits directly over another *distinct* net's conductor, that overlap area is charged between the two nets instead of to ground (issue #760) -- plus lateral (same-layer, sidewall) coupling, but only for a net pair naming one of the caller's declared `--critical-net` nets (issue #976): facing-edge length within that layer's own minimum-spacing lookback is charged between the two nets, *additively* (not deducted from either net's substrate fringe term, unlike the vertical case -- a known simplification). Any same-layer pair with neither side named `--critical-net`, and fringe shielding in general, are still not modelled
* - resistance: single lumped series resistance per net, distributed as a star across that net's device terminals (issue #592) -- not a per-segment, distributed RC ladder, *unless* `--distributed-rc` names this net via `--critical-net` (issue #977, Epic #709 Phase 2b): then the net's terminals are ordered along their approximate physical spread and its total R/C is broken into a chain of per-segment resistors (segment length proportional to inter-terminal distance) with a ground capacitor at each terminal node (proportional to its adjacent segment length/2), instead of one star hub -- still an approximation (terminal position is a device-placement proxy, not true per-segment routing geometry), but a strictly finer-grained one than the single-hub star
* - frequency: quasi-static -- one frequency-independent R and C per net; no skin effect, no distributed transmission-line behavior

* cell gf180_tmds_pad_ring_assembly
* pin IBIAS
* pin INN
* pin INP
* pin OUTN
* pin OUTP
* pin TAIL
* pin VSS
.SUBCKT gf180_tmds_pad_ring_assembly IBIAS INN INP OUTN OUTP TAIL VSS
* device instance $1 r0 *1 326.925,-28.18 nfet
X$1 TAIL__t186 IBIAS__t118 VSS__t163 VSS__t349 nfet_03v3 L=0.5U W=2U AS=0.42P
+ AD=0.42P PS=2.42U PD=2.42U
* device instance $2 r0 *1 327.845,-28.18 nfet
X$2 VSS__t60 IBIAS__t117 TAIL__t286 VSS__t350 nfet_03v3 L=0.5U W=2U AS=0.42P
+ AD=0.42P PS=2.42U PD=2.42U
* device instance $3 r0 *1 328.765,-28.18 nfet
X$3 TAIL__t197 IBIAS__t140 VSS__t174 VSS__t351 nfet_03v3 L=0.5U W=2U AS=0.42P
+ AD=0.42P PS=2.42U PD=2.42U
* device instance $4 r0 *1 329.685,-28.18 nfet
X$4 VSS__t68 IBIAS__t133 TAIL__t294 VSS__t352 nfet_03v3 L=0.5U W=2U AS=0.42P
+ AD=0.42P PS=2.42U PD=2.42U
* device instance $5 r0 *1 330.605,-28.18 nfet
X$5 TAIL__t193 IBIAS__t132 VSS__t170 VSS__t353 nfet_03v3 L=0.5U W=2U AS=0.42P
+ AD=0.42P PS=2.42U PD=2.42U
* device instance $6 r0 *1 331.525,-28.18 nfet
X$6 VSS__t67 IBIAS__t131 TAIL__t293 VSS__t354 nfet_03v3 L=0.5U W=2U AS=0.42P
+ AD=0.42P PS=2.42U PD=2.42U
* device instance $7 r0 *1 332.445,-28.18 nfet
X$7 TAIL__t192 IBIAS__t130 VSS__t169 VSS__t355 nfet_03v3 L=0.5U W=2U AS=0.42P
+ AD=0.42P PS=2.42U PD=2.42U
* device instance $8 r0 *1 333.365,-28.18 nfet
X$8 VSS__t74 IBIAS__t145 TAIL__t300 VSS__t356 nfet_03v3 L=0.5U W=2U AS=0.42P
+ AD=0.42P PS=2.42U PD=2.42U
* device instance $9 r0 *1 334.285,-28.18 nfet
X$9 TAIL__t191 IBIAS__t128 VSS__t168 VSS__t357 nfet_03v3 L=0.5U W=2U AS=0.42P
+ AD=0.42P PS=2.42U PD=2.42U
* device instance $10 r0 *1 335.205,-28.18 nfet
X$10 VSS__t65 IBIAS__t127 TAIL__t291 VSS__t358 nfet_03v3 L=0.5U W=2U AS=0.42P
+ AD=0.42P PS=2.42U PD=2.42U
* device instance $11 r0 *1 336.125,-28.18 nfet
X$11 TAIL__t190 IBIAS__t126 VSS__t167 VSS__t359 nfet_03v3 L=0.5U W=2U AS=0.42P
+ AD=0.42P PS=2.42U PD=2.42U
* device instance $12 r0 *1 337.045,-28.18 nfet
X$12 VSS__t64 IBIAS__t125 TAIL__t290 VSS__t360 nfet_03v3 L=0.5U W=2U AS=0.42P
+ AD=0.42P PS=2.42U PD=2.42U
* device instance $13 r0 *1 337.965,-28.18 nfet
X$13 TAIL__t189 IBIAS__t124 VSS__t166 VSS__t361 nfet_03v3 L=0.5U W=2U AS=0.42P
+ AD=0.42P PS=2.42U PD=2.42U
* device instance $14 r0 *1 338.885,-28.18 nfet
X$14 VSS__t63 IBIAS__t123 TAIL__t289 VSS__t362 nfet_03v3 L=0.5U W=2U AS=0.42P
+ AD=0.42P PS=2.42U PD=2.42U
* device instance $15 r0 *1 339.805,-28.18 nfet
X$15 TAIL__t188 IBIAS__t122 VSS__t165 VSS__t363 nfet_03v3 L=0.5U W=2U AS=0.42P
+ AD=0.42P PS=2.42U PD=2.42U
* device instance $16 r0 *1 340.725,-28.18 nfet
X$16 VSS__t62 IBIAS__t121 TAIL__t288 VSS__t364 nfet_03v3 L=0.5U W=2U AS=0.42P
+ AD=0.42P PS=2.42U PD=2.42U
* device instance $17 r0 *1 341.645,-28.18 nfet
X$17 TAIL__t187 IBIAS__t120 VSS__t164 VSS__t365 nfet_03v3 L=0.5U W=2U AS=0.42P
+ AD=0.42P PS=2.42U PD=2.42U
* device instance $18 r0 *1 342.565,-28.18 nfet
X$18 VSS__t26 IBIAS__t0 TAIL__t252 VSS__t366 nfet_03v3 L=0.5U W=2U AS=0.42P
+ AD=0.42P PS=2.42U PD=2.42U
* device instance $19 r0 *1 343.485,-28.18 nfet
X$19 TAIL__t175 IBIAS__t97 VSS__t152 VSS__t367 nfet_03v3 L=0.5U W=2U AS=0.42P
+ AD=0.42P PS=2.42U PD=2.42U
* device instance $20 r0 *1 344.405,-28.18 nfet
X$20 VSS__t42 IBIAS__t78 TAIL__t268 VSS__t368 nfet_03v3 L=0.5U W=2U AS=0.42P
+ AD=0.42P PS=2.42U PD=2.42U
* device instance $21 r0 *1 345.325,-28.18 nfet
X$21 TAIL__t164 IBIAS__t77 VSS__t141 VSS__t369 nfet_03v3 L=0.5U W=2U AS=0.42P
+ AD=0.42P PS=2.42U PD=2.42U
* device instance $22 r0 *1 346.245,-28.18 nfet
X$22 VSS__t37 IBIAS__t70 TAIL__t263 VSS__t370 nfet_03v3 L=0.5U W=2U AS=0.42P
+ AD=0.42P PS=2.42U PD=2.42U
* device instance $23 r0 *1 347.165,-28.18 nfet
X$23 TAIL__t167 IBIAS__t82 VSS__t144 VSS__t371 nfet_03v3 L=0.5U W=2U AS=0.42P
+ AD=0.42P PS=2.42U PD=2.42U
* device instance $24 r0 *1 348.085,-28.18 nfet
X$24 VSS__t39 IBIAS__t72 TAIL__t265 VSS__t372 nfet_03v3 L=0.5U W=2U AS=0.42P
+ AD=0.42P PS=2.42U PD=2.42U
* device instance $25 r0 *1 349.005,-28.18 nfet
X$25 TAIL__t162 IBIAS__t73 VSS__t139 VSS__t373 nfet_03v3 L=0.5U W=2U AS=0.42P
+ AD=0.42P PS=2.42U PD=2.42U
* device instance $26 r0 *1 349.925,-28.18 nfet
X$26 VSS__t40 IBIAS__t74 TAIL__t266 VSS__t374 nfet_03v3 L=0.5U W=2U AS=0.42P
+ AD=0.42P PS=2.42U PD=2.42U
* device instance $27 r0 *1 350.845,-28.18 nfet
X$27 TAIL__t163 IBIAS__t75 VSS__t140 VSS__t375 nfet_03v3 L=0.5U W=2U AS=0.42P
+ AD=0.42P PS=2.42U PD=2.42U
* device instance $28 r0 *1 351.765,-28.18 nfet
X$28 VSS__t41 IBIAS__t76 TAIL__t267 VSS__t376 nfet_03v3 L=0.5U W=2U AS=0.42P
+ AD=0.42P PS=2.42U PD=2.42U
* device instance $29 r0 *1 352.685,-28.18 nfet
X$29 TAIL__t129 IBIAS__t9 VSS__t107 VSS__t377 nfet_03v3 L=0.5U W=2U AS=0.42P
+ AD=0.42P PS=2.42U PD=2.42U
* device instance $30 r0 *1 353.605,-28.18 nfet
X$30 VSS__t6 IBIAS__t8 TAIL__t232 VSS__t378 nfet_03v3 L=0.5U W=2U AS=0.42P
+ AD=0.42P PS=2.42U PD=2.42U
* device instance $31 r0 *1 354.525,-28.18 nfet
X$31 TAIL__t128 IBIAS__t7 VSS__t106 VSS__t379 nfet_03v3 L=0.5U W=2U AS=0.42P
+ AD=0.42P PS=2.42U PD=2.42U
* device instance $32 r0 *1 355.445,-28.18 nfet
X$32 VSS__t5 IBIAS__t6 TAIL__t231 VSS__t380 nfet_03v3 L=0.5U W=2U AS=0.42P
+ AD=0.42P PS=2.42U PD=2.42U
* device instance $33 r0 *1 356.365,-28.18 nfet
X$33 TAIL__t141 IBIAS__t31 VSS__t119 VSS__t381 nfet_03v3 L=0.5U W=2U AS=0.42P
+ AD=0.42P PS=2.42U PD=2.42U
* device instance $34 r0 *1 357.285,-28.18 nfet
X$34 VSS__t4 IBIAS__t5 TAIL__t230 VSS__t382 nfet_03v3 L=0.5U W=2U AS=0.42P
+ AD=0.42P PS=2.42U PD=2.42U
* device instance $35 r0 *1 358.205,-28.18 nfet
X$35 TAIL__t158 IBIAS__t62 VSS__t135 VSS__t383 nfet_03v3 L=0.5U W=2U AS=0.42P
+ AD=0.42P PS=2.42U PD=2.42U
* device instance $36 r0 *1 359.125,-28.18 nfet
X$36 VSS__t33 IBIAS__t63 TAIL__t259 VSS__t384 nfet_03v3 L=0.5U W=2U AS=0.42P
+ AD=0.42P PS=2.42U PD=2.42U
* device instance $37 r0 *1 360.045,-28.18 nfet
X$37 TAIL__t159 IBIAS__t64 VSS__t136 VSS__t385 nfet_03v3 L=0.5U W=2U AS=0.42P
+ AD=0.42P PS=2.42U PD=2.42U
* device instance $38 r0 *1 360.965,-28.18 nfet
X$38 VSS__t34 IBIAS__t65 TAIL__t260 VSS__t386 nfet_03v3 L=0.5U W=2U AS=0.42P
+ AD=0.42P PS=2.42U PD=2.42U
* device instance $39 r0 *1 361.885,-28.18 nfet
X$39 TAIL__t160 IBIAS__t66 VSS__t137 VSS__t387 nfet_03v3 L=0.5U W=2U AS=0.42P
+ AD=0.42P PS=2.42U PD=2.42U
* device instance $40 r0 *1 362.805,-28.18 nfet
X$40 VSS__t35 IBIAS__t67 TAIL__t261 VSS__t388 nfet_03v3 L=0.5U W=2U AS=0.42P
+ AD=0.42P PS=2.42U PD=2.42U
* device instance $41 r0 *1 363.725,-28.18 nfet
X$41 TAIL__t161 IBIAS__t68 VSS__t138 VSS__t389 nfet_03v3 L=0.5U W=2U AS=0.42P
+ AD=0.42P PS=2.42U PD=2.42U
* device instance $42 r0 *1 364.645,-28.18 nfet
X$42 VSS__t36 IBIAS__t69 TAIL__t262 VSS__t390 nfet_03v3 L=0.5U W=2U AS=0.42P
+ AD=0.42P PS=2.42U PD=2.42U
* device instance $43 r0 *1 365.565,-28.18 nfet
X$43 TAIL__t130 IBIAS__t10 VSS__t108 VSS__t391 nfet_03v3 L=0.5U W=2U AS=0.42P
+ AD=0.42P PS=2.42U PD=2.42U
* device instance $44 r0 *1 366.485,-28.18 nfet
X$44 VSS__t13 IBIAS__t23 TAIL__t239 VSS__t392 nfet_03v3 L=0.5U W=2U AS=0.42P
+ AD=0.42P PS=2.42U PD=2.42U
* device instance $45 r0 *1 367.405,-28.18 nfet
X$45 TAIL__t137 IBIAS__t24 VSS__t115 VSS__t393 nfet_03v3 L=0.5U W=2U AS=0.42P
+ AD=0.42P PS=2.42U PD=2.42U
* device instance $46 r0 *1 368.325,-28.18 nfet
X$46 VSS__t14 IBIAS__t25 TAIL__t240 VSS__t394 nfet_03v3 L=0.5U W=2U AS=0.42P
+ AD=0.42P PS=2.42U PD=2.42U
* device instance $47 r0 *1 369.245,-28.18 nfet
X$47 TAIL__t138 IBIAS__t26 VSS__t116 VSS__t395 nfet_03v3 L=0.5U W=2U AS=0.42P
+ AD=0.42P PS=2.42U PD=2.42U
* device instance $48 r0 *1 370.165,-28.18 nfet
X$48 VSS__t15 IBIAS__t27 TAIL__t241 VSS__t396 nfet_03v3 L=0.5U W=2U AS=0.42P
+ AD=0.42P PS=2.42U PD=2.42U
* device instance $49 r0 *1 371.085,-28.18 nfet
X$49 TAIL__t139 IBIAS__t28 VSS__t117 VSS__t397 nfet_03v3 L=0.5U W=2U AS=0.42P
+ AD=0.42P PS=2.42U PD=2.42U
* device instance $50 r0 *1 372.005,-28.18 nfet
X$50 VSS__t16 IBIAS__t29 TAIL__t242 VSS__t398 nfet_03v3 L=0.5U W=2U AS=0.42P
+ AD=0.42P PS=2.42U PD=2.42U
* device instance $51 r0 *1 372.925,-28.18 nfet
X$51 TAIL__t140 IBIAS__t30 VSS__t118 VSS__t399 nfet_03v3 L=0.5U W=2U AS=0.42P
+ AD=0.42P PS=2.42U PD=2.42U
* device instance $52 r0 *1 373.845,-28.18 nfet
X$52 VSS__t21 IBIAS__t41 TAIL__t247 VSS__t400 nfet_03v3 L=0.5U W=2U AS=0.42P
+ AD=0.42P PS=2.42U PD=2.42U
* device instance $53 r0 *1 374.765,-28.18 nfet
X$53 TAIL__t142 IBIAS__t32 VSS__t120 VSS__t401 nfet_03v3 L=0.5U W=2U AS=0.42P
+ AD=0.42P PS=2.42U PD=2.42U
* device instance $54 r0 *1 375.685,-28.18 nfet
X$54 VSS__t17 IBIAS__t33 TAIL__t243 VSS__t402 nfet_03v3 L=0.5U W=2U AS=0.42P
+ AD=0.42P PS=2.42U PD=2.42U
* device instance $55 r0 *1 376.605,-28.18 nfet
X$55 TAIL__t143 IBIAS__t34 VSS__t121 VSS__t403 nfet_03v3 L=0.5U W=2U AS=0.42P
+ AD=0.42P PS=2.42U PD=2.42U
* device instance $56 r0 *1 377.525,-28.18 nfet
X$56 VSS__t18 IBIAS__t35 TAIL__t244 VSS__t404 nfet_03v3 L=0.5U W=2U AS=0.42P
+ AD=0.42P PS=2.42U PD=2.42U
* device instance $57 r0 *1 378.445,-28.18 nfet
X$57 TAIL__t144 IBIAS__t36 VSS__t122 VSS__t405 nfet_03v3 L=0.5U W=2U AS=0.42P
+ AD=0.42P PS=2.42U PD=2.42U
* device instance $58 r0 *1 379.365,-28.18 nfet
X$58 VSS__t19 IBIAS__t37 TAIL__t245 VSS__t406 nfet_03v3 L=0.5U W=2U AS=0.42P
+ AD=0.42P PS=2.42U PD=2.42U
* device instance $59 r0 *1 380.285,-28.18 nfet
X$59 TAIL__t145 IBIAS__t38 VSS__t123 VSS__t407 nfet_03v3 L=0.5U W=2U AS=0.42P
+ AD=0.42P PS=2.42U PD=2.42U
* device instance $60 r0 *1 381.205,-28.18 nfet
X$60 VSS__t20 IBIAS__t39 TAIL__t246 VSS__t408 nfet_03v3 L=0.5U W=2U AS=0.42P
+ AD=0.42P PS=2.42U PD=2.42U
* device instance $61 r0 *1 382.125,-28.18 nfet
X$61 TAIL__t146 IBIAS__t40 VSS__t124 VSS__t409 nfet_03v3 L=0.5U W=2U AS=0.42P
+ AD=0.42P PS=2.42U PD=2.42U
* device instance $62 r0 *1 383.045,-28.18 nfet
X$62 VSS__t8 IBIAS__t12 TAIL__t234 VSS__t410 nfet_03v3 L=0.5U W=2U AS=0.42P
+ AD=0.42P PS=2.42U PD=2.42U
* device instance $63 r0 *1 383.965,-28.18 nfet
X$63 TAIL__t135 IBIAS__t21 VSS__t113 VSS__t411 nfet_03v3 L=0.5U W=2U AS=0.42P
+ AD=0.42P PS=2.42U PD=2.42U
* device instance $64 r0 *1 384.885,-28.18 nfet
X$64 VSS__t9 IBIAS__t13 TAIL__t235 VSS__t412 nfet_03v3 L=0.5U W=2U AS=0.42P
+ AD=0.42P PS=2.42U PD=2.42U
* device instance $65 r0 *1 385.805,-28.18 nfet
X$65 TAIL__t131 IBIAS__t14 VSS__t109 VSS__t413 nfet_03v3 L=0.5U W=2U AS=0.42P
+ AD=0.42P PS=2.42U PD=2.42U
* device instance $66 r0 *1 386.725,-28.18 nfet
X$66 VSS__t10 IBIAS__t15 TAIL__t236 VSS__t414 nfet_03v3 L=0.5U W=2U AS=0.42P
+ AD=0.42P PS=2.42U PD=2.42U
* device instance $67 r0 *1 387.645,-28.18 nfet
X$67 TAIL__t134 IBIAS__t20 VSS__t112 VSS__t415 nfet_03v3 L=0.5U W=2U AS=0.42P
+ AD=0.42P PS=2.42U PD=2.42U
* device instance $68 r0 *1 388.565,-28.18 nfet
X$68 VSS__t12 IBIAS__t19 TAIL__t238 VSS__t416 nfet_03v3 L=0.5U W=2U AS=0.42P
+ AD=0.42P PS=2.42U PD=2.42U
* device instance $69 r0 *1 389.485,-28.18 nfet
X$69 TAIL__t133 IBIAS__t18 VSS__t111 VSS__t417 nfet_03v3 L=0.5U W=2U AS=0.42P
+ AD=0.42P PS=2.42U PD=2.42U
* device instance $70 r0 *1 390.405,-28.18 nfet
X$70 VSS__t11 IBIAS__t17 TAIL__t237 VSS__t418 nfet_03v3 L=0.5U W=2U AS=0.42P
+ AD=0.42P PS=2.42U PD=2.42U
* device instance $71 r0 *1 391.325,-28.18 nfet
X$71 TAIL__t132 IBIAS__t16 VSS__t110 VSS__t419 nfet_03v3 L=0.5U W=2U AS=0.42P
+ AD=0.42P PS=2.42U PD=2.42U
* device instance $72 r0 *1 392.245,-28.18 nfet
X$72 VSS__t7 IBIAS__t11 TAIL__t233 VSS__t420 nfet_03v3 L=0.5U W=2U AS=0.42P
+ AD=0.42P PS=2.42U PD=2.42U
* device instance $73 r0 *1 393.165,-28.18 nfet
X$73 TAIL__t136 IBIAS__t22 VSS__t114 VSS__t421 nfet_03v3 L=0.5U W=2U AS=0.42P
+ AD=0.42P PS=2.42U PD=2.42U
* device instance $74 r0 *1 394.085,-28.18 nfet
X$74 VSS__t23 IBIAS__t45 TAIL__t249 VSS__t422 nfet_03v3 L=0.5U W=2U AS=0.42P
+ AD=0.42P PS=2.42U PD=2.42U
* device instance $75 r0 *1 395.005,-28.18 nfet
X$75 TAIL__t150 IBIAS__t46 VSS__t127 VSS__t423 nfet_03v3 L=0.5U W=2U AS=0.42P
+ AD=0.42P PS=2.42U PD=2.42U
* device instance $76 r0 *1 395.925,-28.18 nfet
X$76 VSS__t24 IBIAS__t47 TAIL__t250 VSS__t424 nfet_03v3 L=0.5U W=2U AS=0.42P
+ AD=0.42P PS=2.42U PD=2.42U
* device instance $77 r0 *1 396.845,-28.18 nfet
X$77 TAIL__t151 IBIAS__t48 VSS__t128 VSS__t425 nfet_03v3 L=0.5U W=2U AS=0.42P
+ AD=0.42P PS=2.42U PD=2.42U
* device instance $78 r0 *1 397.765,-28.18 nfet
X$78 VSS__t25 IBIAS__t49 TAIL__t251 VSS__t426 nfet_03v3 L=0.5U W=2U AS=0.42P
+ AD=0.42P PS=2.42U PD=2.42U
* device instance $79 r0 *1 398.685,-28.18 nfet
X$79 TAIL__t152 IBIAS__t50 VSS__t129 VSS__t427 nfet_03v3 L=0.5U W=2U AS=0.42P
+ AD=0.42P PS=2.42U PD=2.42U
* device instance $80 r0 *1 399.605,-28.18 nfet
X$80 VSS__t32 IBIAS__t61 TAIL__t258 VSS__t428 nfet_03v3 L=0.5U W=2U AS=0.42P
+ AD=0.42P PS=2.42U PD=2.42U
* device instance $81 r0 *1 400.525,-28.18 nfet
X$81 TAIL__t153 IBIAS__t51 VSS__t130 VSS__t429 nfet_03v3 L=0.5U W=2U AS=0.42P
+ AD=0.42P PS=2.42U PD=2.42U
* device instance $82 r0 *1 401.445,-28.18 nfet
X$82 VSS__t27 IBIAS__t52 TAIL__t253 VSS__t430 nfet_03v3 L=0.5U W=2U AS=0.42P
+ AD=0.42P PS=2.42U PD=2.42U
* device instance $83 r0 *1 402.365,-28.18 nfet
X$83 TAIL__t154 IBIAS__t53 VSS__t131 VSS__t431 nfet_03v3 L=0.5U W=2U AS=0.42P
+ AD=0.42P PS=2.42U PD=2.42U
* device instance $84 r0 *1 403.285,-28.18 nfet
X$84 VSS__t28 IBIAS__t54 TAIL__t254 VSS__t432 nfet_03v3 L=0.5U W=2U AS=0.42P
+ AD=0.42P PS=2.42U PD=2.42U
* device instance $85 r0 *1 404.205,-28.18 nfet
X$85 TAIL__t155 IBIAS__t55 VSS__t132 VSS__t433 nfet_03v3 L=0.5U W=2U AS=0.42P
+ AD=0.42P PS=2.42U PD=2.42U
* device instance $86 r0 *1 405.125,-28.18 nfet
X$86 VSS__t29 IBIAS__t56 TAIL__t255 VSS__t434 nfet_03v3 L=0.5U W=2U AS=0.42P
+ AD=0.42P PS=2.42U PD=2.42U
* device instance $87 r0 *1 406.045,-28.18 nfet
X$87 TAIL__t156 IBIAS__t57 VSS__t133 VSS__t435 nfet_03v3 L=0.5U W=2U AS=0.42P
+ AD=0.42P PS=2.42U PD=2.42U
* device instance $88 r0 *1 406.965,-28.18 nfet
X$88 VSS__t30 IBIAS__t58 TAIL__t256 VSS__t436 nfet_03v3 L=0.5U W=2U AS=0.42P
+ AD=0.42P PS=2.42U PD=2.42U
* device instance $89 r0 *1 407.885,-28.18 nfet
X$89 TAIL__t157 IBIAS__t59 VSS__t134 VSS__t437 nfet_03v3 L=0.5U W=2U AS=0.42P
+ AD=0.42P PS=2.42U PD=2.42U
* device instance $90 r0 *1 408.805,-28.18 nfet
X$90 VSS__t31 IBIAS__t60 TAIL__t257 VSS__t438 nfet_03v3 L=0.5U W=2U AS=0.42P
+ AD=0.42P PS=2.42U PD=2.42U
* device instance $91 r0 *1 409.725,-28.18 nfet
X$91 TAIL__t211 IBIAS__t176 VSS__t193 VSS__t439 nfet_03v3 L=0.5U W=2U AS=0.42P
+ AD=0.42P PS=2.42U PD=2.42U
* device instance $92 r0 *1 410.645,-28.18 nfet
X$92 VSS__t88 IBIAS__t175 TAIL__t311 VSS__t440 nfet_03v3 L=0.5U W=2U AS=0.42P
+ AD=0.42P PS=2.42U PD=2.42U
* device instance $93 r0 *1 411.565,-28.18 nfet
X$93 TAIL__t165 IBIAS__t79 VSS__t142 VSS__t441 nfet_03v3 L=0.5U W=2U AS=0.42P
+ AD=0.42P PS=2.42U PD=2.42U
* device instance $94 r0 *1 412.485,-28.18 nfet
X$94 VSS__t43 IBIAS__t80 TAIL__t269 VSS__t442 nfet_03v3 L=0.5U W=2U AS=0.42P
+ AD=0.42P PS=2.42U PD=2.42U
* device instance $95 r0 *1 413.405,-28.18 nfet
X$95 TAIL__t166 IBIAS__t81 VSS__t143 VSS__t443 nfet_03v3 L=0.5U W=2U AS=0.42P
+ AD=0.42P PS=2.42U PD=2.42U
* device instance $96 r0 *1 414.325,-28.18 nfet
X$96 VSS__t38 IBIAS__t71 TAIL__t264 VSS__t444 nfet_03v3 L=0.5U W=2U AS=0.42P
+ AD=0.42P PS=2.42U PD=2.42U
* device instance $97 r0 *1 415.245,-28.18 nfet
X$97 TAIL__t147 IBIAS__t42 VSS__t125 VSS__t445 nfet_03v3 L=0.5U W=2U AS=0.42P
+ AD=0.42P PS=2.42U PD=2.42U
* device instance $98 r0 *1 416.165,-28.18 nfet
X$98 VSS__t22 IBIAS__t43 TAIL__t248 VSS__t446 nfet_03v3 L=0.5U W=2U AS=0.42P
+ AD=0.42P PS=2.42U PD=2.42U
* device instance $99 r0 *1 417.085,-28.18 nfet
X$99 TAIL__t148 IBIAS__t44 VSS__t126 VSS__t447 nfet_03v3 L=0.5U W=2U AS=0.42P
+ AD=0.42P PS=2.42U PD=2.42U
* device instance $100 r0 *1 418.005,-28.18 nfet
X$100 VSS__t0 IBIAS__t1 TAIL__t149 VSS__t456 nfet_03v3 L=0.5U W=2U AS=0.42P
+ AD=0.84P PS=2.42U PD=4.84U
* device instance $101 r0 *1 234.925,-28.18 nfet
X$101 TAIL__t229 IBIAS__t2 VSS__t1 VSS__t458 nfet_03v3 L=0.5U W=2U AS=0.84P
+ AD=0.42P PS=4.84U PD=2.42U
* device instance $102 r0 *1 235.845,-28.18 nfet
X$102 VSS__t189 IBIAS__t170 TAIL__t228 VSS__t250 nfet_03v3 L=0.5U W=2U AS=0.42P
+ AD=0.42P PS=2.42U PD=2.42U
* device instance $103 r0 *1 236.765,-28.18 nfet
X$103 TAIL__t209 IBIAS__t169 VSS__t188 VSS__t251 nfet_03v3 L=0.5U W=2U AS=0.42P
+ AD=0.42P PS=2.42U PD=2.42U
* device instance $104 r0 *1 237.685,-28.18 nfet
X$104 VSS__t86 IBIAS__t168 TAIL__t309 VSS__t252 nfet_03v3 L=0.5U W=2U AS=0.42P
+ AD=0.42P PS=2.42U PD=2.42U
* device instance $105 r0 *1 238.605,-28.18 nfet
X$105 TAIL__t208 IBIAS__t167 VSS__t187 VSS__t253 nfet_03v3 L=0.5U W=2U AS=0.42P
+ AD=0.42P PS=2.42U PD=2.42U
* device instance $106 r0 *1 239.525,-28.18 nfet
X$106 VSS__t85 IBIAS__t166 TAIL__t308 VSS__t254 nfet_03v3 L=0.5U W=2U AS=0.42P
+ AD=0.42P PS=2.42U PD=2.42U
* device instance $107 r0 *1 240.445,-28.18 nfet
X$107 TAIL__t207 IBIAS__t165 VSS__t186 VSS__t255 nfet_03v3 L=0.5U W=2U AS=0.42P
+ AD=0.42P PS=2.42U PD=2.42U
* device instance $108 r0 *1 241.365,-28.18 nfet
X$108 VSS__t84 IBIAS__t164 TAIL__t307 VSS__t256 nfet_03v3 L=0.5U W=2U AS=0.42P
+ AD=0.42P PS=2.42U PD=2.42U
* device instance $109 r0 *1 242.285,-28.18 nfet
X$109 TAIL__t210 IBIAS__t173 VSS__t191 VSS__t257 nfet_03v3 L=0.5U W=2U AS=0.42P
+ AD=0.42P PS=2.42U PD=2.42U
* device instance $110 r0 *1 243.205,-28.18 nfet
X$110 VSS__t87 IBIAS__t172 TAIL__t310 VSS__t258 nfet_03v3 L=0.5U W=2U AS=0.42P
+ AD=0.42P PS=2.42U PD=2.42U
* device instance $111 r0 *1 244.125,-28.18 nfet
X$111 TAIL__t219 IBIAS__t195 VSS__t201 VSS__t259 nfet_03v3 L=0.5U W=2U AS=0.42P
+ AD=0.42P PS=2.42U PD=2.42U
* device instance $112 r0 *1 245.045,-28.18 nfet
X$112 VSS__t99 IBIAS__t194 TAIL__t321 VSS__t260 nfet_03v3 L=0.5U W=2U AS=0.42P
+ AD=0.42P PS=2.42U PD=2.42U
* device instance $113 r0 *1 245.965,-28.18 nfet
X$113 TAIL__t227 IBIAS__t209 VSS__t209 VSS__t261 nfet_03v3 L=0.5U W=2U AS=0.42P
+ AD=0.42P PS=2.42U PD=2.42U
* device instance $114 r0 *1 246.885,-28.18 nfet
X$114 VSS__t97 IBIAS__t192 TAIL__t319 VSS__t262 nfet_03v3 L=0.5U W=2U AS=0.42P
+ AD=0.42P PS=2.42U PD=2.42U
* device instance $115 r0 *1 247.805,-28.18 nfet
X$115 TAIL__t218 IBIAS__t191 VSS__t200 VSS__t263 nfet_03v3 L=0.5U W=2U AS=0.42P
+ AD=0.42P PS=2.42U PD=2.42U
* device instance $116 r0 *1 248.725,-28.18 nfet
X$116 VSS__t96 IBIAS__t190 TAIL__t318 VSS__t264 nfet_03v3 L=0.5U W=2U AS=0.42P
+ AD=0.42P PS=2.42U PD=2.42U
* device instance $117 r0 *1 249.645,-28.18 nfet
X$117 TAIL__t217 IBIAS__t189 VSS__t199 VSS__t265 nfet_03v3 L=0.5U W=2U AS=0.42P
+ AD=0.42P PS=2.42U PD=2.42U
* device instance $118 r0 *1 250.565,-28.18 nfet
X$118 VSS__t95 IBIAS__t188 TAIL__t317 VSS__t266 nfet_03v3 L=0.5U W=2U AS=0.42P
+ AD=0.42P PS=2.42U PD=2.42U
* device instance $119 r0 *1 251.485,-28.18 nfet
X$119 TAIL__t216 IBIAS__t187 VSS__t198 VSS__t267 nfet_03v3 L=0.5U W=2U AS=0.42P
+ AD=0.42P PS=2.42U PD=2.42U
* device instance $120 r0 *1 252.405,-28.18 nfet
X$120 VSS__t94 IBIAS__t186 TAIL__t316 VSS__t268 nfet_03v3 L=0.5U W=2U AS=0.42P
+ AD=0.42P PS=2.42U PD=2.42U
* device instance $121 r0 *1 253.325,-28.18 nfet
X$121 TAIL__t215 IBIAS__t185 VSS__t197 VSS__t269 nfet_03v3 L=0.5U W=2U AS=0.42P
+ AD=0.42P PS=2.42U PD=2.42U
* device instance $122 r0 *1 254.245,-28.18 nfet
X$122 VSS__t93 IBIAS__t184 TAIL__t315 VSS__t270 nfet_03v3 L=0.5U W=2U AS=0.42P
+ AD=0.42P PS=2.42U PD=2.42U
* device instance $123 r0 *1 255.165,-28.18 nfet
X$123 TAIL__t214 IBIAS__t183 VSS__t196 VSS__t271 nfet_03v3 L=0.5U W=2U AS=0.42P
+ AD=0.42P PS=2.42U PD=2.42U
* device instance $124 r0 *1 256.085,-28.18 nfet
X$124 VSS__t92 IBIAS__t182 TAIL__t314 VSS__t272 nfet_03v3 L=0.5U W=2U AS=0.42P
+ AD=0.42P PS=2.42U PD=2.42U
* device instance $125 r0 *1 257.005,-28.18 nfet
X$125 TAIL__t213 IBIAS__t181 VSS__t195 VSS__t273 nfet_03v3 L=0.5U W=2U AS=0.42P
+ AD=0.42P PS=2.42U PD=2.42U
* device instance $126 r0 *1 257.925,-28.18 nfet
X$126 VSS__t91 IBIAS__t180 TAIL__t313 VSS__t274 nfet_03v3 L=0.5U W=2U AS=0.42P
+ AD=0.42P PS=2.42U PD=2.42U
* device instance $127 r0 *1 258.845,-28.18 nfet
X$127 TAIL__t212 IBIAS__t179 VSS__t194 VSS__t275 nfet_03v3 L=0.5U W=2U AS=0.42P
+ AD=0.42P PS=2.42U PD=2.42U
* device instance $128 r0 *1 259.765,-28.18 nfet
X$128 VSS__t90 IBIAS__t178 TAIL__t312 VSS__t276 nfet_03v3 L=0.5U W=2U AS=0.42P
+ AD=0.42P PS=2.42U PD=2.42U
* device instance $129 r0 *1 260.685,-28.18 nfet
X$129 TAIL__t206 IBIAS__t161 VSS__t184 VSS__t277 nfet_03v3 L=0.5U W=2U AS=0.42P
+ AD=0.42P PS=2.42U PD=2.42U
* device instance $130 r0 *1 261.605,-28.18 nfet
X$130 VSS__t57 IBIAS__t112 TAIL__t283 VSS__t278 nfet_03v3 L=0.5U W=2U AS=0.42P
+ AD=0.42P PS=2.42U PD=2.42U
* device instance $131 r0 *1 262.525,-28.18 nfet
X$131 TAIL__t183 IBIAS__t111 VSS__t160 VSS__t279 nfet_03v3 L=0.5U W=2U AS=0.42P
+ AD=0.42P PS=2.42U PD=2.42U
* device instance $132 r0 *1 263.445,-28.18 nfet
X$132 VSS__t56 IBIAS__t110 TAIL__t282 VSS__t280 nfet_03v3 L=0.5U W=2U AS=0.42P
+ AD=0.42P PS=2.42U PD=2.42U
* device instance $133 r0 *1 264.365,-28.18 nfet
X$133 TAIL__t182 IBIAS__t109 VSS__t159 VSS__t281 nfet_03v3 L=0.5U W=2U AS=0.42P
+ AD=0.42P PS=2.42U PD=2.42U
* device instance $134 r0 *1 265.285,-28.18 nfet
X$134 VSS__t55 IBIAS__t108 TAIL__t281 VSS__t282 nfet_03v3 L=0.5U W=2U AS=0.42P
+ AD=0.42P PS=2.42U PD=2.42U
* device instance $135 r0 *1 266.205,-28.18 nfet
X$135 TAIL__t181 IBIAS__t107 VSS__t158 VSS__t283 nfet_03v3 L=0.5U W=2U AS=0.42P
+ AD=0.42P PS=2.42U PD=2.42U
* device instance $136 r0 *1 267.125,-28.18 nfet
X$136 VSS__t54 IBIAS__t106 TAIL__t280 VSS__t284 nfet_03v3 L=0.5U W=2U AS=0.42P
+ AD=0.42P PS=2.42U PD=2.42U
* device instance $137 r0 *1 268.045,-28.18 nfet
X$137 TAIL__t180 IBIAS__t105 VSS__t157 VSS__t285 nfet_03v3 L=0.5U W=2U AS=0.42P
+ AD=0.42P PS=2.42U PD=2.42U
* device instance $138 r0 *1 268.965,-28.18 nfet
X$138 VSS__t53 IBIAS__t104 TAIL__t279 VSS__t286 nfet_03v3 L=0.5U W=2U AS=0.42P
+ AD=0.42P PS=2.42U PD=2.42U
* device instance $139 r0 *1 269.885,-28.18 nfet
X$139 TAIL__t205 IBIAS__t156 VSS__t182 VSS__t287 nfet_03v3 L=0.5U W=2U AS=0.42P
+ AD=0.42P PS=2.42U PD=2.42U
* device instance $140 r0 *1 270.805,-28.18 nfet
X$140 VSS__t79 IBIAS__t155 TAIL__t305 VSS__t288 nfet_03v3 L=0.5U W=2U AS=0.42P
+ AD=0.42P PS=2.42U PD=2.42U
* device instance $141 r0 *1 271.725,-28.18 nfet
X$141 TAIL__t204 IBIAS__t154 VSS__t181 VSS__t289 nfet_03v3 L=0.5U W=2U AS=0.42P
+ AD=0.42P PS=2.42U PD=2.42U
* device instance $142 r0 *1 272.645,-28.18 nfet
X$142 VSS__t78 IBIAS__t153 TAIL__t304 VSS__t290 nfet_03v3 L=0.5U W=2U AS=0.42P
+ AD=0.42P PS=2.42U PD=2.42U
* device instance $143 r0 *1 273.565,-28.18 nfet
X$143 TAIL__t203 IBIAS__t152 VSS__t180 VSS__t291 nfet_03v3 L=0.5U W=2U AS=0.42P
+ AD=0.42P PS=2.42U PD=2.42U
* device instance $144 r0 *1 274.485,-28.18 nfet
X$144 VSS__t77 IBIAS__t151 TAIL__t303 VSS__t292 nfet_03v3 L=0.5U W=2U AS=0.42P
+ AD=0.42P PS=2.42U PD=2.42U
* device instance $145 r0 *1 275.405,-28.18 nfet
X$145 TAIL__t202 IBIAS__t150 VSS__t179 VSS__t293 nfet_03v3 L=0.5U W=2U AS=0.42P
+ AD=0.42P PS=2.42U PD=2.42U
* device instance $146 r0 *1 276.325,-28.18 nfet
X$146 VSS__t76 IBIAS__t149 TAIL__t302 VSS__t294 nfet_03v3 L=0.5U W=2U AS=0.42P
+ AD=0.42P PS=2.42U PD=2.42U
* device instance $147 r0 *1 277.245,-28.18 nfet
X$147 TAIL__t201 IBIAS__t148 VSS__t178 VSS__t295 nfet_03v3 L=0.5U W=2U AS=0.42P
+ AD=0.42P PS=2.42U PD=2.42U
* device instance $148 r0 *1 278.165,-28.18 nfet
X$148 VSS__t75 IBIAS__t147 TAIL__t301 VSS__t296 nfet_03v3 L=0.5U W=2U AS=0.42P
+ AD=0.42P PS=2.42U PD=2.42U
* device instance $149 r0 *1 279.085,-28.18 nfet
X$149 TAIL__t200 IBIAS__t146 VSS__t177 VSS__t297 nfet_03v3 L=0.5U W=2U AS=0.42P
+ AD=0.42P PS=2.42U PD=2.42U
* device instance $150 r0 *1 280.005,-28.18 nfet
X$150 VSS__t98 IBIAS__t193 TAIL__t320 VSS__t298 nfet_03v3 L=0.5U W=2U AS=0.42P
+ AD=0.42P PS=2.42U PD=2.42U
* device instance $151 r0 *1 280.925,-28.18 nfet
X$151 TAIL__t226 IBIAS__t208 VSS__t208 VSS__t299 nfet_03v3 L=0.5U W=2U AS=0.42P
+ AD=0.42P PS=2.42U PD=2.42U
* device instance $152 r0 *1 281.845,-28.18 nfet
X$152 VSS__t105 IBIAS__t207 TAIL__t327 VSS__t300 nfet_03v3 L=0.5U W=2U AS=0.42P
+ AD=0.42P PS=2.42U PD=2.42U
* device instance $153 r0 *1 282.765,-28.18 nfet
X$153 TAIL__t225 IBIAS__t206 VSS__t207 VSS__t301 nfet_03v3 L=0.5U W=2U AS=0.42P
+ AD=0.42P PS=2.42U PD=2.42U
* device instance $154 r0 *1 283.685,-28.18 nfet
X$154 VSS__t104 IBIAS__t205 TAIL__t326 VSS__t302 nfet_03v3 L=0.5U W=2U AS=0.42P
+ AD=0.42P PS=2.42U PD=2.42U
* device instance $155 r0 *1 284.605,-28.18 nfet
X$155 TAIL__t224 IBIAS__t204 VSS__t206 VSS__t303 nfet_03v3 L=0.5U W=2U AS=0.42P
+ AD=0.42P PS=2.42U PD=2.42U
* device instance $156 r0 *1 285.525,-28.18 nfet
X$156 VSS__t103 IBIAS__t203 TAIL__t325 VSS__t304 nfet_03v3 L=0.5U W=2U AS=0.42P
+ AD=0.42P PS=2.42U PD=2.42U
* device instance $157 r0 *1 286.445,-28.18 nfet
X$157 TAIL__t223 IBIAS__t202 VSS__t205 VSS__t305 nfet_03v3 L=0.5U W=2U AS=0.42P
+ AD=0.42P PS=2.42U PD=2.42U
* device instance $158 r0 *1 287.365,-28.18 nfet
X$158 VSS__t102 IBIAS__t201 TAIL__t324 VSS__t306 nfet_03v3 L=0.5U W=2U AS=0.42P
+ AD=0.42P PS=2.42U PD=2.42U
* device instance $159 r0 *1 288.285,-28.18 nfet
X$159 TAIL__t222 IBIAS__t200 VSS__t204 VSS__t307 nfet_03v3 L=0.5U W=2U AS=0.42P
+ AD=0.42P PS=2.42U PD=2.42U
* device instance $160 r0 *1 289.205,-28.18 nfet
X$160 VSS__t101 IBIAS__t199 TAIL__t323 VSS__t308 nfet_03v3 L=0.5U W=2U AS=0.42P
+ AD=0.42P PS=2.42U PD=2.42U
* device instance $161 r0 *1 290.125,-28.18 nfet
X$161 TAIL__t221 IBIAS__t198 VSS__t203 VSS__t309 nfet_03v3 L=0.5U W=2U AS=0.42P
+ AD=0.42P PS=2.42U PD=2.42U
* device instance $162 r0 *1 291.045,-28.18 nfet
X$162 VSS__t100 IBIAS__t197 TAIL__t322 VSS__t310 nfet_03v3 L=0.5U W=2U AS=0.42P
+ AD=0.42P PS=2.42U PD=2.42U
* device instance $163 r0 *1 291.965,-28.18 nfet
X$163 TAIL__t220 IBIAS__t196 VSS__t202 VSS__t311 nfet_03v3 L=0.5U W=2U AS=0.42P
+ AD=0.42P PS=2.42U PD=2.42U
* device instance $164 r0 *1 292.885,-28.18 nfet
X$164 VSS__t80 IBIAS__t157 TAIL__t306 VSS__t312 nfet_03v3 L=0.5U W=2U AS=0.42P
+ AD=0.42P PS=2.42U PD=2.42U
* device instance $165 r0 *1 293.805,-28.18 nfet
X$165 TAIL__t185 IBIAS__t116 VSS__t162 VSS__t313 nfet_03v3 L=0.5U W=2U AS=0.42P
+ AD=0.42P PS=2.42U PD=2.42U
* device instance $166 r0 *1 294.725,-28.18 nfet
X$166 VSS__t59 IBIAS__t115 TAIL__t285 VSS__t314 nfet_03v3 L=0.5U W=2U AS=0.42P
+ AD=0.42P PS=2.42U PD=2.42U
* device instance $167 r0 *1 295.645,-28.18 nfet
X$167 TAIL__t184 IBIAS__t114 VSS__t161 VSS__t315 nfet_03v3 L=0.5U W=2U AS=0.42P
+ AD=0.42P PS=2.42U PD=2.42U
* device instance $168 r0 *1 296.565,-28.18 nfet
X$168 VSS__t71 IBIAS__t139 TAIL__t297 VSS__t316 nfet_03v3 L=0.5U W=2U AS=0.42P
+ AD=0.42P PS=2.42U PD=2.42U
* device instance $169 r0 *1 297.485,-28.18 nfet
X$169 TAIL__t196 IBIAS__t138 VSS__t173 VSS__t317 nfet_03v3 L=0.5U W=2U AS=0.42P
+ AD=0.42P PS=2.42U PD=2.42U
* device instance $170 r0 *1 298.405,-28.18 nfet
X$170 VSS__t70 IBIAS__t137 TAIL__t296 VSS__t318 nfet_03v3 L=0.5U W=2U AS=0.42P
+ AD=0.42P PS=2.42U PD=2.42U
* device instance $171 r0 *1 299.325,-28.18 nfet
X$171 TAIL__t195 IBIAS__t136 VSS__t172 VSS__t319 nfet_03v3 L=0.5U W=2U AS=0.42P
+ AD=0.42P PS=2.42U PD=2.42U
* device instance $172 r0 *1 300.245,-28.18 nfet
X$172 VSS__t69 IBIAS__t135 TAIL__t295 VSS__t320 nfet_03v3 L=0.5U W=2U AS=0.42P
+ AD=0.42P PS=2.42U PD=2.42U
* device instance $173 r0 *1 301.165,-28.18 nfet
X$173 TAIL__t194 IBIAS__t134 VSS__t171 VSS__t321 nfet_03v3 L=0.5U W=2U AS=0.42P
+ AD=0.42P PS=2.42U PD=2.42U
* device instance $174 r0 *1 302.085,-28.18 nfet
X$174 VSS__t61 IBIAS__t119 TAIL__t287 VSS__t322 nfet_03v3 L=0.5U W=2U AS=0.42P
+ AD=0.42P PS=2.42U PD=2.42U
* device instance $175 r0 *1 303.005,-28.18 nfet
X$175 TAIL__t179 IBIAS__t103 VSS__t156 VSS__t323 nfet_03v3 L=0.5U W=2U AS=0.42P
+ AD=0.42P PS=2.42U PD=2.42U
* device instance $176 r0 *1 303.925,-28.18 nfet
X$176 VSS__t48 IBIAS__t92 TAIL__t274 VSS__t324 nfet_03v3 L=0.5U W=2U AS=0.42P
+ AD=0.42P PS=2.42U PD=2.42U
* device instance $177 r0 *1 304.845,-28.18 nfet
X$177 TAIL__t178 IBIAS__t102 VSS__t155 VSS__t325 nfet_03v3 L=0.5U W=2U AS=0.42P
+ AD=0.42P PS=2.42U PD=2.42U
* device instance $178 r0 *1 305.765,-28.18 nfet
X$178 VSS__t52 IBIAS__t101 TAIL__t278 VSS__t326 nfet_03v3 L=0.5U W=2U AS=0.42P
+ AD=0.42P PS=2.42U PD=2.42U
* device instance $179 r0 *1 306.685,-28.18 nfet
X$179 TAIL__t177 IBIAS__t100 VSS__t154 VSS__t327 nfet_03v3 L=0.5U W=2U AS=0.42P
+ AD=0.42P PS=2.42U PD=2.42U
* device instance $180 r0 *1 307.605,-28.18 nfet
X$180 VSS__t51 IBIAS__t99 TAIL__t277 VSS__t328 nfet_03v3 L=0.5U W=2U AS=0.42P
+ AD=0.42P PS=2.42U PD=2.42U
* device instance $181 r0 *1 308.525,-28.18 nfet
X$181 TAIL__t176 IBIAS__t98 VSS__t153 VSS__t329 nfet_03v3 L=0.5U W=2U AS=0.42P
+ AD=0.42P PS=2.42U PD=2.42U
* device instance $182 r0 *1 309.445,-28.18 nfet
X$182 VSS__t58 IBIAS__t113 TAIL__t284 VSS__t330 nfet_03v3 L=0.5U W=2U AS=0.42P
+ AD=0.42P PS=2.42U PD=2.42U
* device instance $183 r0 *1 310.365,-28.18 nfet
X$183 TAIL__t174 IBIAS__t96 VSS__t151 VSS__t331 nfet_03v3 L=0.5U W=2U AS=0.42P
+ AD=0.42P PS=2.42U PD=2.42U
* device instance $184 r0 *1 311.285,-28.18 nfet
X$184 VSS__t50 IBIAS__t95 TAIL__t276 VSS__t332 nfet_03v3 L=0.5U W=2U AS=0.42P
+ AD=0.42P PS=2.42U PD=2.42U
* device instance $185 r0 *1 312.205,-28.18 nfet
X$185 TAIL__t173 IBIAS__t94 VSS__t150 VSS__t333 nfet_03v3 L=0.5U W=2U AS=0.42P
+ AD=0.42P PS=2.42U PD=2.42U
* device instance $186 r0 *1 313.125,-28.18 nfet
X$186 VSS__t49 IBIAS__t93 TAIL__t275 VSS__t334 nfet_03v3 L=0.5U W=2U AS=0.42P
+ AD=0.42P PS=2.42U PD=2.42U
* device instance $187 r0 *1 314.045,-28.18 nfet
X$187 TAIL__t172 IBIAS__t91 VSS__t149 VSS__t335 nfet_03v3 L=0.5U W=2U AS=0.42P
+ AD=0.42P PS=2.42U PD=2.42U
* device instance $188 r0 *1 314.965,-28.18 nfet
X$188 VSS__t47 IBIAS__t90 TAIL__t273 VSS__t336 nfet_03v3 L=0.5U W=2U AS=0.42P
+ AD=0.42P PS=2.42U PD=2.42U
* device instance $189 r0 *1 315.885,-28.18 nfet
X$189 TAIL__t171 IBIAS__t89 VSS__t148 VSS__t337 nfet_03v3 L=0.5U W=2U AS=0.42P
+ AD=0.42P PS=2.42U PD=2.42U
* device instance $190 r0 *1 316.805,-28.18 nfet
X$190 VSS__t46 IBIAS__t88 TAIL__t272 VSS__t338 nfet_03v3 L=0.5U W=2U AS=0.42P
+ AD=0.42P PS=2.42U PD=2.42U
* device instance $191 r0 *1 317.725,-28.18 nfet
X$191 TAIL__t170 IBIAS__t87 VSS__t147 VSS__t339 nfet_03v3 L=0.5U W=2U AS=0.42P
+ AD=0.42P PS=2.42U PD=2.42U
* device instance $192 r0 *1 318.645,-28.18 nfet
X$192 VSS__t45 IBIAS__t86 TAIL__t271 VSS__t340 nfet_03v3 L=0.5U W=2U AS=0.42P
+ AD=0.42P PS=2.42U PD=2.42U
* device instance $193 r0 *1 319.565,-28.18 nfet
X$193 TAIL__t169 IBIAS__t85 VSS__t146 VSS__t341 nfet_03v3 L=0.5U W=2U AS=0.42P
+ AD=0.42P PS=2.42U PD=2.42U
* device instance $194 r0 *1 320.485,-28.18 nfet
X$194 VSS__t44 IBIAS__t84 TAIL__t270 VSS__t342 nfet_03v3 L=0.5U W=2U AS=0.42P
+ AD=0.42P PS=2.42U PD=2.42U
* device instance $195 r0 *1 321.405,-28.18 nfet
X$195 TAIL__t168 IBIAS__t83 VSS__t145 VSS__t343 nfet_03v3 L=0.5U W=2U AS=0.42P
+ AD=0.42P PS=2.42U PD=2.42U
* device instance $196 r0 *1 322.325,-28.18 nfet
X$196 VSS__t66 IBIAS__t129 TAIL__t292 VSS__t344 nfet_03v3 L=0.5U W=2U AS=0.42P
+ AD=0.42P PS=2.42U PD=2.42U
* device instance $197 r0 *1 323.245,-28.18 nfet
X$197 TAIL__t199 IBIAS__t144 VSS__t176 VSS__t345 nfet_03v3 L=0.5U W=2U AS=0.42P
+ AD=0.42P PS=2.42U PD=2.42U
* device instance $198 r0 *1 324.165,-28.18 nfet
X$198 VSS__t73 IBIAS__t143 TAIL__t299 VSS__t346 nfet_03v3 L=0.5U W=2U AS=0.42P
+ AD=0.42P PS=2.42U PD=2.42U
* device instance $199 r0 *1 325.085,-28.18 nfet
X$199 TAIL__t198 IBIAS__t142 VSS__t175 VSS__t347 nfet_03v3 L=0.5U W=2U AS=0.42P
+ AD=0.42P PS=2.42U PD=2.42U
* device instance $200 r0 *1 326.005,-28.18 nfet
X$200 VSS__t72 IBIAS__t141 TAIL__t298 VSS__t348 nfet_03v3 L=0.5U W=2U AS=0.42P
+ AD=0.42P PS=2.42U PD=2.42U
* device instance $201 r0 *1 424.235,-28.18 nfet
X$201 OUTP__t53 INP__t1 TAIL__t0 VSS__t460 nfet_03v3 L=0.28U W=2U AS=0.84P
+ AD=0.42P PS=4.84U PD=2.42U
* device instance $202 r0 *1 424.935,-28.18 nfet
X$202 TAIL__t119 INP__t53 OUTP__t52 VSS__t462 nfet_03v3 L=0.28U W=2U AS=0.42P
+ AD=0.42P PS=2.42U PD=2.42U
* device instance $203 r0 *1 425.635,-28.18 nfet
X$203 OUTP__t46 INP__t52 TAIL__t118 VSS__t463 nfet_03v3 L=0.28U W=2U AS=0.42P
+ AD=0.42P PS=2.42U PD=2.42U
* device instance $204 r0 *1 426.335,-28.18 nfet
X$204 TAIL__t58 INP__t61 OUTP__t82 VSS__t464 nfet_03v3 L=0.28U W=2U AS=0.42P
+ AD=0.42P PS=2.42U PD=2.42U
* device instance $205 r0 *1 427.035,-28.18 nfet
X$205 OUTP__t30 INP__t24 TAIL__t98 VSS__t465 nfet_03v3 L=0.28U W=2U AS=0.42P
+ AD=0.42P PS=2.42U PD=2.42U
* device instance $206 r0 *1 427.735,-28.18 nfet
X$206 TAIL__t38 INP__t23 OUTP__t64 VSS__t466 nfet_03v3 L=0.28U W=2U AS=0.42P
+ AD=0.42P PS=2.42U PD=2.42U
* device instance $207 r0 *1 428.435,-28.18 nfet
X$207 OUTP__t29 INP__t22 TAIL__t97 VSS__t467 nfet_03v3 L=0.28U W=2U AS=0.42P
+ AD=0.42P PS=2.42U PD=2.42U
* device instance $208 r0 *1 429.135,-28.18 nfet
X$208 TAIL__t37 INP__t21 OUTP__t63 VSS__t468 nfet_03v3 L=0.28U W=2U AS=0.42P
+ AD=0.42P PS=2.42U PD=2.42U
* device instance $209 r0 *1 429.835,-28.18 nfet
X$209 OUTP__t28 INP__t20 TAIL__t96 VSS__t469 nfet_03v3 L=0.28U W=2U AS=0.42P
+ AD=0.42P PS=2.42U PD=2.42U
* device instance $210 r0 *1 430.535,-28.18 nfet
X$210 TAIL__t36 INP__t19 OUTP__t62 VSS__t470 nfet_03v3 L=0.28U W=2U AS=0.42P
+ AD=0.42P PS=2.42U PD=2.42U
* device instance $211 r0 *1 431.235,-28.18 nfet
X$211 OUTP__t27 INP__t18 TAIL__t95 VSS__t471 nfet_03v3 L=0.28U W=2U AS=0.42P
+ AD=0.42P PS=2.42U PD=2.42U
* device instance $212 r0 *1 431.935,-28.18 nfet
X$212 TAIL__t35 INP__t17 OUTP__t61 VSS__t472 nfet_03v3 L=0.28U W=2U AS=0.42P
+ AD=0.42P PS=2.42U PD=2.42U
* device instance $213 r0 *1 432.635,-28.18 nfet
X$213 OUTP__t26 INP__t16 TAIL__t94 VSS__t473 nfet_03v3 L=0.28U W=2U AS=0.42P
+ AD=0.42P PS=2.42U PD=2.42U
* device instance $214 r0 *1 433.335,-28.18 nfet
X$214 TAIL__t33 INP__t15 OUTP__t60 VSS__t474 nfet_03v3 L=0.28U W=2U AS=0.42P
+ AD=0.42P PS=2.42U PD=2.42U
* device instance $215 r0 *1 434.035,-28.18 nfet
X$215 OUTP__t47 INP__t54 TAIL__t120 VSS__t475 nfet_03v3 L=0.28U W=2U AS=0.42P
+ AD=0.42P PS=2.42U PD=2.42U
* device instance $216 r0 *1 434.735,-28.18 nfet
X$216 TAIL__t54 INP__t55 OUTP__t78 VSS__t476 nfet_03v3 L=0.28U W=2U AS=0.42P
+ AD=0.42P PS=2.42U PD=2.42U
* device instance $217 r0 *1 435.435,-28.18 nfet
X$217 OUTP__t51 INP__t63 TAIL__t126 VSS__t477 nfet_03v3 L=0.28U W=2U AS=0.42P
+ AD=0.42P PS=2.42U PD=2.42U
* device instance $218 r0 *1 436.135,-28.18 nfet
X$218 TAIL__t57 INP__t60 OUTP__t81 VSS__t478 nfet_03v3 L=0.28U W=2U AS=0.42P
+ AD=0.42P PS=2.42U PD=2.42U
* device instance $219 r0 *1 436.835,-28.18 nfet
X$219 OUTP__t49 INP__t59 TAIL__t122 VSS__t479 nfet_03v3 L=0.28U W=2U AS=0.42P
+ AD=0.42P PS=2.42U PD=2.42U
* device instance $220 r0 *1 437.535,-28.18 nfet
X$220 TAIL__t56 INP__t58 OUTP__t80 VSS__t480 nfet_03v3 L=0.28U W=2U AS=0.42P
+ AD=0.42P PS=2.42U PD=2.42U
* device instance $221 r0 *1 438.235,-28.18 nfet
X$221 OUTP__t48 INP__t57 TAIL__t121 VSS__t481 nfet_03v3 L=0.28U W=2U AS=0.42P
+ AD=0.42P PS=2.42U PD=2.42U
* device instance $222 r0 *1 438.935,-28.18 nfet
X$222 TAIL__t55 INP__t56 OUTP__t79 VSS__t482 nfet_03v3 L=0.28U W=2U AS=0.42P
+ AD=0.42P PS=2.42U PD=2.42U
* device instance $223 r0 *1 439.635,-28.18 nfet
X$223 OUTP__t24 INP__t11 TAIL__t92 VSS__t483 nfet_03v3 L=0.28U W=2U AS=0.42P
+ AD=0.42P PS=2.42U PD=2.42U
* device instance $224 r0 *1 440.335,-28.18 nfet
X$224 TAIL__t30 INP__t10 OUTP__t57 VSS__t484 nfet_03v3 L=0.28U W=2U AS=0.42P
+ AD=0.42P PS=2.42U PD=2.42U
* device instance $225 r0 *1 441.035,-28.18 nfet
X$225 OUTP__t23 INP__t9 TAIL__t88 VSS__t485 nfet_03v3 L=0.28U W=2U AS=0.42P
+ AD=0.42P PS=2.42U PD=2.42U
* device instance $226 r0 *1 441.735,-28.18 nfet
X$226 TAIL__t32 INP__t14 OUTP__t59 VSS__t486 nfet_03v3 L=0.28U W=2U AS=0.42P
+ AD=0.42P PS=2.42U PD=2.42U
* device instance $227 r0 *1 442.435,-28.18 nfet
X$227 OUTP__t25 INP__t13 TAIL__t93 VSS__t487 nfet_03v3 L=0.28U W=2U AS=0.42P
+ AD=0.42P PS=2.42U PD=2.42U
* device instance $228 r0 *1 443.135,-28.18 nfet
X$228 TAIL__t60 INP__t0 OUTP__t83 VSS__t488 nfet_03v3 L=0.28U W=2U AS=0.42P
+ AD=0.42P PS=2.42U PD=2.42U
* device instance $229 r0 *1 443.835,-28.18 nfet
X$229 OUTP__t50 INP__t62 TAIL__t123 VSS__t489 nfet_03v3 L=0.28U W=2U AS=0.42P
+ AD=0.42P PS=2.42U PD=2.42U
* device instance $230 r0 *1 444.535,-28.18 nfet
X$230 TAIL__t42 INP__t29 OUTP__t67 VSS__t490 nfet_03v3 L=0.28U W=2U AS=0.42P
+ AD=0.42P PS=2.42U PD=2.42U
* device instance $231 r0 *1 445.235,-28.18 nfet
X$231 OUTP__t32 INP__t28 TAIL__t102 VSS__t491 nfet_03v3 L=0.28U W=2U AS=0.42P
+ AD=0.42P PS=2.42U PD=2.42U
* device instance $232 r0 *1 445.935,-28.18 nfet
X$232 TAIL__t41 INP__t27 OUTP__t66 VSS__t492 nfet_03v3 L=0.28U W=2U AS=0.42P
+ AD=0.42P PS=2.42U PD=2.42U
* device instance $233 r0 *1 446.635,-28.18 nfet
X$233 OUTP__t31 INP__t26 TAIL__t101 VSS__t493 nfet_03v3 L=0.28U W=2U AS=0.42P
+ AD=0.42P PS=2.42U PD=2.42U
* device instance $234 r0 *1 447.335,-28.18 nfet
X$234 TAIL__t40 INP__t25 OUTP__t65 VSS__t494 nfet_03v3 L=0.28U W=2U AS=0.42P
+ AD=0.42P PS=2.42U PD=2.42U
* device instance $235 r0 *1 448.035,-28.18 nfet
X$235 OUTP__t20 INP__t4 TAIL__t74 VSS__t495 nfet_03v3 L=0.28U W=2U AS=0.42P
+ AD=0.42P PS=2.42U PD=2.42U
* device instance $236 r0 *1 448.735,-28.18 nfet
X$236 TAIL__t14 INP__t3 OUTP__t54 VSS__t496 nfet_03v3 L=0.28U W=2U AS=0.42P
+ AD=0.42P PS=2.42U PD=2.42U
* device instance $237 r0 *1 449.435,-28.18 nfet
X$237 OUTP__t22 INP__t7 TAIL__t76 VSS__t497 nfet_03v3 L=0.28U W=2U AS=0.42P
+ AD=0.42P PS=2.42U PD=2.42U
* device instance $238 r0 *1 450.135,-28.18 nfet
X$238 TAIL__t16 INP__t6 OUTP__t55 VSS__t498 nfet_03v3 L=0.28U W=2U AS=0.42P
+ AD=0.42P PS=2.42U PD=2.42U
* device instance $239 r0 *1 450.835,-28.18 nfet
X$239 OUTP__t21 INP__t5 TAIL__t75 VSS__t499 nfet_03v3 L=0.28U W=2U AS=0.42P
+ AD=0.42P PS=2.42U PD=2.42U
* device instance $240 r0 *1 451.535,-28.18 nfet
X$240 TAIL__t19 INP__t8 OUTP__t56 VSS__t500 nfet_03v3 L=0.28U W=2U AS=0.42P
+ AD=0.42P PS=2.42U PD=2.42U
* device instance $241 r0 *1 452.235,-28.18 nfet
X$241 OUTP__t45 INP__t50 TAIL__t116 VSS__t501 nfet_03v3 L=0.28U W=2U AS=0.42P
+ AD=0.42P PS=2.42U PD=2.42U
* device instance $242 r0 *1 452.935,-28.18 nfet
X$242 TAIL__t51 INP__t49 OUTP__t76 VSS__t502 nfet_03v3 L=0.28U W=2U AS=0.42P
+ AD=0.42P PS=2.42U PD=2.42U
* device instance $243 r0 *1 453.635,-28.18 nfet
X$243 OUTP__t44 INP__t48 TAIL__t115 VSS__t503 nfet_03v3 L=0.28U W=2U AS=0.42P
+ AD=0.42P PS=2.42U PD=2.42U
* device instance $244 r0 *1 454.335,-28.18 nfet
X$244 TAIL__t50 INP__t47 OUTP__t75 VSS__t504 nfet_03v3 L=0.28U W=2U AS=0.42P
+ AD=0.42P PS=2.42U PD=2.42U
* device instance $245 r0 *1 455.035,-28.18 nfet
X$245 OUTP__t43 INP__t46 TAIL__t114 VSS__t505 nfet_03v3 L=0.28U W=2U AS=0.42P
+ AD=0.42P PS=2.42U PD=2.42U
* device instance $246 r0 *1 455.735,-28.18 nfet
X$246 TAIL__t49 INP__t45 OUTP__t74 VSS__t506 nfet_03v3 L=0.28U W=2U AS=0.42P
+ AD=0.42P PS=2.42U PD=2.42U
* device instance $247 r0 *1 456.435,-28.18 nfet
X$247 OUTP__t42 INP__t44 TAIL__t113 VSS__t507 nfet_03v3 L=0.28U W=2U AS=0.42P
+ AD=0.42P PS=2.42U PD=2.42U
* device instance $248 r0 *1 457.135,-28.18 nfet
X$248 TAIL__t48 INP__t43 OUTP__t73 VSS__t508 nfet_03v3 L=0.28U W=2U AS=0.42P
+ AD=0.42P PS=2.42U PD=2.42U
* device instance $249 r0 *1 457.835,-28.18 nfet
X$249 OUTP__t41 INP__t42 TAIL__t112 VSS__t509 nfet_03v3 L=0.28U W=2U AS=0.42P
+ AD=0.42P PS=2.42U PD=2.42U
* device instance $250 r0 *1 458.535,-28.18 nfet
X$250 TAIL__t47 INP__t41 OUTP__t72 VSS__t510 nfet_03v3 L=0.28U W=2U AS=0.42P
+ AD=0.42P PS=2.42U PD=2.42U
* device instance $251 r0 *1 459.235,-28.18 nfet
X$251 OUTP__t40 INP__t40 TAIL__t111 VSS__t511 nfet_03v3 L=0.28U W=2U AS=0.42P
+ AD=0.42P PS=2.42U PD=2.42U
* device instance $252 r0 *1 459.935,-28.18 nfet
X$252 TAIL__t46 INP__t39 OUTP__t71 VSS__t512 nfet_03v3 L=0.28U W=2U AS=0.42P
+ AD=0.42P PS=2.42U PD=2.42U
* device instance $253 r0 *1 460.635,-28.18 nfet
X$253 OUTP__t39 INP__t38 TAIL__t110 VSS__t513 nfet_03v3 L=0.28U W=2U AS=0.42P
+ AD=0.42P PS=2.42U PD=2.42U
* device instance $254 r0 *1 461.335,-28.18 nfet
X$254 TAIL__t53 INP__t51 OUTP__t77 VSS__t514 nfet_03v3 L=0.28U W=2U AS=0.42P
+ AD=0.42P PS=2.42U PD=2.42U
* device instance $255 r0 *1 462.035,-28.18 nfet
X$255 OUTP__t38 INP__t37 TAIL__t108 VSS__t515 nfet_03v3 L=0.28U W=2U AS=0.42P
+ AD=0.42P PS=2.42U PD=2.42U
* device instance $256 r0 *1 462.735,-28.18 nfet
X$256 TAIL__t45 INP__t36 OUTP__t70 VSS__t516 nfet_03v3 L=0.28U W=2U AS=0.42P
+ AD=0.42P PS=2.42U PD=2.42U
* device instance $257 r0 *1 463.435,-28.18 nfet
X$257 OUTP__t37 INP__t35 TAIL__t107 VSS__t517 nfet_03v3 L=0.28U W=2U AS=0.42P
+ AD=0.42P PS=2.42U PD=2.42U
* device instance $258 r0 *1 464.135,-28.18 nfet
X$258 TAIL__t44 INP__t34 OUTP__t69 VSS__t518 nfet_03v3 L=0.28U W=2U AS=0.42P
+ AD=0.42P PS=2.42U PD=2.42U
* device instance $259 r0 *1 464.835,-28.18 nfet
X$259 OUTP__t36 INP__t33 TAIL__t106 VSS__t519 nfet_03v3 L=0.28U W=2U AS=0.42P
+ AD=0.42P PS=2.42U PD=2.42U
* device instance $260 r0 *1 465.535,-28.18 nfet
X$260 TAIL__t31 INP__t12 OUTP__t58 VSS__t520 nfet_03v3 L=0.28U W=2U AS=0.42P
+ AD=0.42P PS=2.42U PD=2.42U
* device instance $261 r0 *1 466.235,-28.18 nfet
X$261 OUTP__t35 INP__t32 TAIL__t104 VSS__t521 nfet_03v3 L=0.28U W=2U AS=0.42P
+ AD=0.42P PS=2.42U PD=2.42U
* device instance $262 r0 *1 466.935,-28.18 nfet
X$262 TAIL__t43 INP__t31 OUTP__t68 VSS__t522 nfet_03v3 L=0.28U W=2U AS=0.42P
+ AD=0.42P PS=2.42U PD=2.42U
* device instance $263 r0 *1 467.635,-28.18 nfet
X$263 OUTP__t33 INP__t30 TAIL__t103 VSS__t523 nfet_03v3 L=0.28U W=2U AS=0.42P
+ AD=0.42P PS=2.42U PD=2.42U
* device instance $264 r0 *1 468.335,-28.18 nfet
X$264 TAIL__t1 INP__t2 OUTP__t34 VSS__t586 nfet_03v3 L=0.28U W=2U AS=0.42P
+ AD=0.84P PS=2.42U PD=4.84U
* device instance $265 r0 *1 234.925,-18.72 nfet
X$265 IBIAS__t215 IBIAS__t3 VSS__t2 VSS__t459 nfet_03v3 L=0.5U W=2U AS=0.84P
+ AD=0.42P PS=4.84U PD=2.42U
* device instance $266 r0 *1 235.845,-18.72 nfet
X$266 VSS__t81 IBIAS__t158 IBIAS__t216 VSS__t448 nfet_03v3 L=0.5U W=2U AS=0.42P
+ AD=0.42P PS=2.42U PD=2.42U
* device instance $267 r0 *1 236.765,-18.72 nfet
X$267 IBIAS__t213 IBIAS__t171 VSS__t190 VSS__t449 nfet_03v3 L=0.5U W=2U
+ AS=0.42P AD=0.42P PS=2.42U PD=2.42U
* device instance $268 r0 *1 237.685,-18.72 nfet
X$268 VSS__t83 IBIAS__t163 IBIAS__t218 VSS__t450 nfet_03v3 L=0.5U W=2U AS=0.42P
+ AD=0.42P PS=2.42U PD=2.42U
* device instance $269 r0 *1 238.605,-18.72 nfet
X$269 IBIAS__t212 IBIAS__t162 VSS__t185 VSS__t451 nfet_03v3 L=0.5U W=2U
+ AS=0.42P AD=0.42P PS=2.42U PD=2.42U
* device instance $270 r0 *1 239.525,-18.72 nfet
X$270 VSS__t89 IBIAS__t177 IBIAS__t219 VSS__t452 nfet_03v3 L=0.5U W=2U AS=0.42P
+ AD=0.42P PS=2.42U PD=2.42U
* device instance $271 r0 *1 240.445,-18.72 nfet
X$271 IBIAS__t211 IBIAS__t160 VSS__t183 VSS__t453 nfet_03v3 L=0.5U W=2U
+ AS=0.42P AD=0.42P PS=2.42U PD=2.42U
* device instance $272 r0 *1 241.365,-18.72 nfet
X$272 VSS__t82 IBIAS__t159 IBIAS__t217 VSS__t454 nfet_03v3 L=0.5U W=2U AS=0.42P
+ AD=0.42P PS=2.42U PD=2.42U
* device instance $273 r0 *1 242.285,-18.72 nfet
X$273 IBIAS__t214 IBIAS__t174 VSS__t192 VSS__t455 nfet_03v3 L=0.5U W=2U
+ AS=0.42P AD=0.42P PS=2.42U PD=2.42U
* device instance $274 r0 *1 243.205,-18.72 nfet
X$274 VSS__t3 IBIAS__t4 IBIAS__t210 VSS__t457 nfet_03v3 L=0.5U W=2U AS=0.42P
+ AD=0.84P PS=2.42U PD=4.84U
* device instance $275 r0 *1 424.235,-18.72 nfet
X$275 OUTN__t52 INN__t1 TAIL__t3 VSS__t461 nfet_03v3 L=0.28U W=2U AS=0.84P
+ AD=0.42P PS=4.84U PD=2.42U
* device instance $276 r0 *1 424.935,-18.72 nfet
X$276 TAIL__t62 INN__t58 OUTN__t81 VSS__t524 nfet_03v3 L=0.28U W=2U AS=0.42P
+ AD=0.42P PS=2.42U PD=2.42U
* device instance $277 r0 *1 425.635,-18.72 nfet
X$277 OUTN__t49 INN__t59 TAIL__t124 VSS__t525 nfet_03v3 L=0.28U W=2U AS=0.42P
+ AD=0.42P PS=2.42U PD=2.42U
* device instance $278 r0 *1 426.335,-18.72 nfet
X$278 TAIL__t63 INN__t60 OUTN__t82 VSS__t526 nfet_03v3 L=0.28U W=2U AS=0.42P
+ AD=0.42P PS=2.42U PD=2.42U
* device instance $279 r0 *1 427.035,-18.72 nfet
X$279 OUTN__t50 INN__t61 TAIL__t125 VSS__t527 nfet_03v3 L=0.28U W=2U AS=0.42P
+ AD=0.42P PS=2.42U PD=2.42U
* device instance $280 r0 *1 427.735,-18.72 nfet
X$280 TAIL__t64 INN__t62 OUTN__t83 VSS__t528 nfet_03v3 L=0.28U W=2U AS=0.42P
+ AD=0.42P PS=2.42U PD=2.42U
* device instance $281 r0 *1 428.435,-18.72 nfet
X$281 OUTN__t46 INN__t52 TAIL__t105 VSS__t529 nfet_03v3 L=0.28U W=2U AS=0.42P
+ AD=0.42P PS=2.42U PD=2.42U
* device instance $282 r0 *1 429.135,-18.72 nfet
X$282 TAIL__t15 INN__t21 OUTN__t63 VSS__t530 nfet_03v3 L=0.28U W=2U AS=0.42P
+ AD=0.42P PS=2.42U PD=2.42U
* device instance $283 r0 *1 429.835,-18.72 nfet
X$283 OUTN__t45 INN__t51 TAIL__t100 VSS__t531 nfet_03v3 L=0.28U W=2U AS=0.42P
+ AD=0.42P PS=2.42U PD=2.42U
* device instance $284 r0 *1 430.535,-18.72 nfet
X$284 TAIL__t34 INN__t48 OUTN__t76 VSS__t532 nfet_03v3 L=0.28U W=2U AS=0.42P
+ AD=0.42P PS=2.42U PD=2.42U
* device instance $285 r0 *1 431.235,-18.72 nfet
X$285 OUTN__t44 INN__t50 TAIL__t99 VSS__t533 nfet_03v3 L=0.28U W=2U AS=0.42P
+ AD=0.42P PS=2.42U PD=2.42U
* device instance $286 r0 *1 431.935,-18.72 nfet
X$286 TAIL__t61 INN__t57 OUTN__t80 VSS__t534 nfet_03v3 L=0.28U W=2U AS=0.42P
+ AD=0.42P PS=2.42U PD=2.42U
* device instance $287 r0 *1 432.635,-18.72 nfet
X$287 OUTN__t40 INN__t42 TAIL__t87 VSS__t535 nfet_03v3 L=0.28U W=2U AS=0.42P
+ AD=0.42P PS=2.42U PD=2.42U
* device instance $288 r0 *1 433.335,-18.72 nfet
X$288 TAIL__t27 INN__t41 OUTN__t73 VSS__t536 nfet_03v3 L=0.28U W=2U AS=0.42P
+ AD=0.42P PS=2.42U PD=2.42U
* device instance $289 r0 *1 434.035,-18.72 nfet
X$289 OUTN__t39 INN__t40 TAIL__t86 VSS__t537 nfet_03v3 L=0.28U W=2U AS=0.42P
+ AD=0.42P PS=2.42U PD=2.42U
* device instance $290 r0 *1 434.735,-18.72 nfet
X$290 TAIL__t26 INN__t39 OUTN__t72 VSS__t538 nfet_03v3 L=0.28U W=2U AS=0.42P
+ AD=0.42P PS=2.42U PD=2.42U
* device instance $291 r0 *1 435.435,-18.72 nfet
X$291 OUTN__t38 INN__t38 TAIL__t85 VSS__t539 nfet_03v3 L=0.28U W=2U AS=0.42P
+ AD=0.42P PS=2.42U PD=2.42U
* device instance $292 r0 *1 436.135,-18.72 nfet
X$292 TAIL__t25 INN__t37 OUTN__t71 VSS__t540 nfet_03v3 L=0.28U W=2U AS=0.42P
+ AD=0.42P PS=2.42U PD=2.42U
* device instance $293 r0 *1 436.835,-18.72 nfet
X$293 OUTN__t47 INN__t53 TAIL__t109 VSS__t541 nfet_03v3 L=0.28U W=2U AS=0.42P
+ AD=0.42P PS=2.42U PD=2.42U
* device instance $294 r0 *1 437.535,-18.72 nfet
X$294 TAIL__t52 INN__t55 OUTN__t78 VSS__t542 nfet_03v3 L=0.28U W=2U AS=0.42P
+ AD=0.42P PS=2.42U PD=2.42U
* device instance $295 r0 *1 438.235,-18.72 nfet
X$295 OUTN__t48 INN__t54 TAIL__t117 VSS__t543 nfet_03v3 L=0.28U W=2U AS=0.42P
+ AD=0.42P PS=2.42U PD=2.42U
* device instance $296 r0 *1 438.935,-18.72 nfet
X$296 TAIL__t39 INN__t49 OUTN__t77 VSS__t544 nfet_03v3 L=0.28U W=2U AS=0.42P
+ AD=0.42P PS=2.42U PD=2.42U
* device instance $297 r0 *1 439.635,-18.72 nfet
X$297 OUTN__t41 INN__t43 TAIL__t89 VSS__t545 nfet_03v3 L=0.28U W=2U AS=0.42P
+ AD=0.42P PS=2.42U PD=2.42U
* device instance $298 r0 *1 440.335,-18.72 nfet
X$298 TAIL__t29 INN__t47 OUTN__t75 VSS__t546 nfet_03v3 L=0.28U W=2U AS=0.42P
+ AD=0.42P PS=2.42U PD=2.42U
* device instance $299 r0 *1 441.035,-18.72 nfet
X$299 OUTN__t43 INN__t46 TAIL__t91 VSS__t547 nfet_03v3 L=0.28U W=2U AS=0.42P
+ AD=0.42P PS=2.42U PD=2.42U
* device instance $300 r0 *1 441.735,-18.72 nfet
X$300 TAIL__t28 INN__t45 OUTN__t74 VSS__t548 nfet_03v3 L=0.28U W=2U AS=0.42P
+ AD=0.42P PS=2.42U PD=2.42U
* device instance $301 r0 *1 442.435,-18.72 nfet
X$301 OUTN__t42 INN__t44 TAIL__t90 VSS__t549 nfet_03v3 L=0.28U W=2U AS=0.42P
+ AD=0.42P PS=2.42U PD=2.42U
* device instance $302 r0 *1 443.135,-18.72 nfet
X$302 TAIL__t59 INN__t56 OUTN__t79 VSS__t550 nfet_03v3 L=0.28U W=2U AS=0.42P
+ AD=0.42P PS=2.42U PD=2.42U
* device instance $303 r0 *1 443.835,-18.72 nfet
X$303 OUTN__t51 INN__t63 TAIL__t127 VSS__t551 nfet_03v3 L=0.28U W=2U AS=0.42P
+ AD=0.42P PS=2.42U PD=2.42U
* device instance $304 r0 *1 444.535,-18.72 nfet
X$304 TAIL__t13 INN__t19 OUTN__t62 VSS__t552 nfet_03v3 L=0.28U W=2U AS=0.42P
+ AD=0.42P PS=2.42U PD=2.42U
* device instance $305 r0 *1 445.235,-18.72 nfet
X$305 OUTN__t28 INN__t18 TAIL__t72 VSS__t553 nfet_03v3 L=0.28U W=2U AS=0.42P
+ AD=0.42P PS=2.42U PD=2.42U
* device instance $306 r0 *1 445.935,-18.72 nfet
X$306 TAIL__t12 INN__t17 OUTN__t61 VSS__t554 nfet_03v3 L=0.28U W=2U AS=0.42P
+ AD=0.42P PS=2.42U PD=2.42U
* device instance $307 r0 *1 446.635,-18.72 nfet
X$307 OUTN__t27 INN__t16 TAIL__t71 VSS__t555 nfet_03v3 L=0.28U W=2U AS=0.42P
+ AD=0.42P PS=2.42U PD=2.42U
* device instance $308 r0 *1 447.335,-18.72 nfet
X$308 TAIL__t11 INN__t15 OUTN__t60 VSS__t556 nfet_03v3 L=0.28U W=2U AS=0.42P
+ AD=0.42P PS=2.42U PD=2.42U
* device instance $309 r0 *1 448.035,-18.72 nfet
X$309 OUTN__t26 INN__t14 TAIL__t70 VSS__t557 nfet_03v3 L=0.28U W=2U AS=0.42P
+ AD=0.42P PS=2.42U PD=2.42U
* device instance $310 r0 *1 448.735,-18.72 nfet
X$310 TAIL__t10 INN__t13 OUTN__t59 VSS__t558 nfet_03v3 L=0.28U W=2U AS=0.42P
+ AD=0.42P PS=2.42U PD=2.42U
* device instance $311 r0 *1 449.435,-18.72 nfet
X$311 OUTN__t25 INN__t12 TAIL__t69 VSS__t559 nfet_03v3 L=0.28U W=2U AS=0.42P
+ AD=0.42P PS=2.42U PD=2.42U
* device instance $312 r0 *1 450.135,-18.72 nfet
X$312 TAIL__t6 INN__t5 OUTN__t55 VSS__t560 nfet_03v3 L=0.28U W=2U AS=0.42P
+ AD=0.42P PS=2.42U PD=2.42U
* device instance $313 r0 *1 450.835,-18.72 nfet
X$313 OUTN__t24 INN__t11 TAIL__t68 VSS__t561 nfet_03v3 L=0.28U W=2U AS=0.42P
+ AD=0.42P PS=2.42U PD=2.42U
* device instance $314 r0 *1 451.535,-18.72 nfet
X$314 TAIL__t4 INN__t2 OUTN__t53 VSS__t562 nfet_03v3 L=0.28U W=2U AS=0.42P
+ AD=0.42P PS=2.42U PD=2.42U
* device instance $315 r0 *1 452.235,-18.72 nfet
X$315 OUTN__t21 INN__t3 TAIL__t65 VSS__t563 nfet_03v3 L=0.28U W=2U AS=0.42P
+ AD=0.42P PS=2.42U PD=2.42U
* device instance $316 r0 *1 452.935,-18.72 nfet
X$316 TAIL__t5 INN__t4 OUTN__t54 VSS__t564 nfet_03v3 L=0.28U W=2U AS=0.42P
+ AD=0.42P PS=2.42U PD=2.42U
* device instance $317 r0 *1 453.635,-18.72 nfet
X$317 OUTN__t22 INN__t6 TAIL__t66 VSS__t565 nfet_03v3 L=0.28U W=2U AS=0.42P
+ AD=0.42P PS=2.42U PD=2.42U
* device instance $318 r0 *1 454.335,-18.72 nfet
X$318 TAIL__t7 INN__t7 OUTN__t56 VSS__t566 nfet_03v3 L=0.28U W=2U AS=0.42P
+ AD=0.42P PS=2.42U PD=2.42U
* device instance $319 r0 *1 455.035,-18.72 nfet
X$319 OUTN__t23 INN__t8 TAIL__t67 VSS__t567 nfet_03v3 L=0.28U W=2U AS=0.42P
+ AD=0.42P PS=2.42U PD=2.42U
* device instance $320 r0 *1 455.735,-18.72 nfet
X$320 TAIL__t8 INN__t9 OUTN__t57 VSS__t568 nfet_03v3 L=0.28U W=2U AS=0.42P
+ AD=0.42P PS=2.42U PD=2.42U
* device instance $321 r0 *1 456.435,-18.72 nfet
X$321 OUTN__t29 INN__t20 TAIL__t73 VSS__t569 nfet_03v3 L=0.28U W=2U AS=0.42P
+ AD=0.42P PS=2.42U PD=2.42U
* device instance $322 r0 *1 457.135,-18.72 nfet
X$322 TAIL__t9 INN__t10 OUTN__t58 VSS__t570 nfet_03v3 L=0.28U W=2U AS=0.42P
+ AD=0.42P PS=2.42U PD=2.42U
* device instance $323 r0 *1 457.835,-18.72 nfet
X$323 OUTN__t36 INN__t35 TAIL__t83 VSS__t571 nfet_03v3 L=0.28U W=2U AS=0.42P
+ AD=0.42P PS=2.42U PD=2.42U
* device instance $324 r0 *1 458.535,-18.72 nfet
X$324 TAIL__t24 INN__t34 OUTN__t70 VSS__t572 nfet_03v3 L=0.28U W=2U AS=0.42P
+ AD=0.42P PS=2.42U PD=2.42U
* device instance $325 r0 *1 459.235,-18.72 nfet
X$325 OUTN__t35 INN__t33 TAIL__t82 VSS__t573 nfet_03v3 L=0.28U W=2U AS=0.42P
+ AD=0.42P PS=2.42U PD=2.42U
* device instance $326 r0 *1 459.935,-18.72 nfet
X$326 TAIL__t23 INN__t32 OUTN__t69 VSS__t574 nfet_03v3 L=0.28U W=2U AS=0.42P
+ AD=0.42P PS=2.42U PD=2.42U
* device instance $327 r0 *1 460.635,-18.72 nfet
X$327 OUTN__t34 INN__t31 TAIL__t81 VSS__t575 nfet_03v3 L=0.28U W=2U AS=0.42P
+ AD=0.42P PS=2.42U PD=2.42U
* device instance $328 r0 *1 461.335,-18.72 nfet
X$328 TAIL__t22 INN__t30 OUTN__t68 VSS__t576 nfet_03v3 L=0.28U W=2U AS=0.42P
+ AD=0.42P PS=2.42U PD=2.42U
* device instance $329 r0 *1 462.035,-18.72 nfet
X$329 OUTN__t33 INN__t29 TAIL__t80 VSS__t577 nfet_03v3 L=0.28U W=2U AS=0.42P
+ AD=0.42P PS=2.42U PD=2.42U
* device instance $330 r0 *1 462.735,-18.72 nfet
X$330 TAIL__t21 INN__t28 OUTN__t67 VSS__t578 nfet_03v3 L=0.28U W=2U AS=0.42P
+ AD=0.42P PS=2.42U PD=2.42U
* device instance $331 r0 *1 463.435,-18.72 nfet
X$331 OUTN__t32 INN__t27 TAIL__t79 VSS__t579 nfet_03v3 L=0.28U W=2U AS=0.42P
+ AD=0.42P PS=2.42U PD=2.42U
* device instance $332 r0 *1 464.135,-18.72 nfet
X$332 TAIL__t20 INN__t26 OUTN__t66 VSS__t580 nfet_03v3 L=0.28U W=2U AS=0.42P
+ AD=0.42P PS=2.42U PD=2.42U
* device instance $333 r0 *1 464.835,-18.72 nfet
X$333 OUTN__t37 INN__t36 TAIL__t84 VSS__t581 nfet_03v3 L=0.28U W=2U AS=0.42P
+ AD=0.42P PS=2.42U PD=2.42U
* device instance $334 r0 *1 465.535,-18.72 nfet
X$334 TAIL__t18 INN__t25 OUTN__t65 VSS__t582 nfet_03v3 L=0.28U W=2U AS=0.42P
+ AD=0.42P PS=2.42U PD=2.42U
* device instance $335 r0 *1 466.235,-18.72 nfet
X$335 OUTN__t31 INN__t24 TAIL__t78 VSS__t583 nfet_03v3 L=0.28U W=2U AS=0.42P
+ AD=0.42P PS=2.42U PD=2.42U
* device instance $336 r0 *1 466.935,-18.72 nfet
X$336 TAIL__t17 INN__t23 OUTN__t64 VSS__t584 nfet_03v3 L=0.28U W=2U AS=0.42P
+ AD=0.42P PS=2.42U PD=2.42U
* device instance $337 r0 *1 467.635,-18.72 nfet
X$337 OUTN__t30 INN__t22 TAIL__t77 VSS__t585 nfet_03v3 L=0.28U W=2U AS=0.42P
+ AD=0.42P PS=2.42U PD=2.42U
* device instance $338 r0 *1 468.335,-18.72 nfet
X$338 TAIL__t2 INN__t0 OUTN__t20 VSS__t587 nfet_03v3 L=0.28U W=2U AS=0.42P
+ AD=0.84P PS=2.42U PD=4.84U
* device instance $339 r0 *1 143.3,30.5 diode_nd2ps_06v0
D$339 VSS__t210 OUTP__t16 diode_nd2ps_06v0 A=2P P=6U
* device instance $340 r0 *1 145.9,30.5 diode_nd2ps_06v0
D$340 VSS__t211 OUTP__t17 diode_nd2ps_06v0 A=2P P=6U
* device instance $341 r0 *1 148.5,30.5 diode_nd2ps_06v0
D$341 VSS__t212 OUTP__t18 diode_nd2ps_06v0 A=2P P=6U
* device instance $342 r0 *1 151.1,30.5 diode_nd2ps_06v0
D$342 VSS__t213 OUTP__t19 diode_nd2ps_06v0 A=2P P=6U
* device instance $343 r0 *1 153.7,30.5 diode_nd2ps_06v0
D$343 VSS__t214 OUTP__t0 diode_nd2ps_06v0 A=2P P=6U
* device instance $344 r0 *1 156.3,30.5 diode_nd2ps_06v0
D$344 VSS__t215 OUTP__t1 diode_nd2ps_06v0 A=2P P=6U
* device instance $345 r0 *1 158.9,30.5 diode_nd2ps_06v0
D$345 VSS__t216 OUTP__t2 diode_nd2ps_06v0 A=2P P=6U
* device instance $346 r0 *1 161.5,30.5 diode_nd2ps_06v0
D$346 VSS__t217 OUTP__t3 diode_nd2ps_06v0 A=2P P=6U
* device instance $347 r0 *1 164.1,30.5 diode_nd2ps_06v0
D$347 VSS__t218 OUTP__t4 diode_nd2ps_06v0 A=2P P=6U
* device instance $348 r0 *1 166.7,30.5 diode_nd2ps_06v0
D$348 VSS__t219 OUTP__t15 diode_nd2ps_06v0 A=2P P=6U
* device instance $349 r0 *1 169.3,30.5 diode_nd2ps_06v0
D$349 VSS__t220 OUTP__t6 diode_nd2ps_06v0 A=2P P=6U
* device instance $350 r0 *1 171.9,30.5 diode_nd2ps_06v0
D$350 VSS__t221 OUTP__t7 diode_nd2ps_06v0 A=2P P=6U
* device instance $351 r0 *1 174.5,30.5 diode_nd2ps_06v0
D$351 VSS__t222 OUTP__t8 diode_nd2ps_06v0 A=2P P=6U
* device instance $352 r0 *1 177.1,30.5 diode_nd2ps_06v0
D$352 VSS__t223 OUTP__t9 diode_nd2ps_06v0 A=2P P=6U
* device instance $353 r0 *1 179.7,30.5 diode_nd2ps_06v0
D$353 VSS__t224 OUTP__t10 diode_nd2ps_06v0 A=2P P=6U
* device instance $354 r0 *1 182.3,30.5 diode_nd2ps_06v0
D$354 VSS__t225 OUTP__t11 diode_nd2ps_06v0 A=2P P=6U
* device instance $355 r0 *1 184.9,30.5 diode_nd2ps_06v0
D$355 VSS__t226 OUTP__t12 diode_nd2ps_06v0 A=2P P=6U
* device instance $356 r0 *1 187.5,30.5 diode_nd2ps_06v0
D$356 VSS__t227 OUTP__t13 diode_nd2ps_06v0 A=2P P=6U
* device instance $357 r0 *1 190.1,30.5 diode_nd2ps_06v0
D$357 VSS__t228 OUTP__t14 diode_nd2ps_06v0 A=2P P=6U
* device instance $358 r0 *1 192.7,30.5 diode_nd2ps_06v0
D$358 VSS__t229 OUTP__t5 diode_nd2ps_06v0 A=2P P=6U
* device instance $359 r0 *1 493.3,30.5 diode_nd2ps_06v0
D$359 VSS__t230 OUTN__t0 diode_nd2ps_06v0 A=2P P=6U
* device instance $360 r0 *1 495.9,30.5 diode_nd2ps_06v0
D$360 VSS__t231 OUTN__t5 diode_nd2ps_06v0 A=2P P=6U
* device instance $361 r0 *1 498.5,30.5 diode_nd2ps_06v0
D$361 VSS__t232 OUTN__t6 diode_nd2ps_06v0 A=2P P=6U
* device instance $362 r0 *1 501.1,30.5 diode_nd2ps_06v0
D$362 VSS__t233 OUTN__t7 diode_nd2ps_06v0 A=2P P=6U
* device instance $363 r0 *1 503.7,30.5 diode_nd2ps_06v0
D$363 VSS__t234 OUTN__t8 diode_nd2ps_06v0 A=2P P=6U
* device instance $364 r0 *1 506.3,30.5 diode_nd2ps_06v0
D$364 VSS__t235 OUTN__t9 diode_nd2ps_06v0 A=2P P=6U
* device instance $365 r0 *1 508.9,30.5 diode_nd2ps_06v0
D$365 VSS__t236 OUTN__t10 diode_nd2ps_06v0 A=2P P=6U
* device instance $366 r0 *1 511.5,30.5 diode_nd2ps_06v0
D$366 VSS__t237 OUTN__t11 diode_nd2ps_06v0 A=2P P=6U
* device instance $367 r0 *1 514.1,30.5 diode_nd2ps_06v0
D$367 VSS__t238 OUTN__t12 diode_nd2ps_06v0 A=2P P=6U
* device instance $368 r0 *1 516.7,30.5 diode_nd2ps_06v0
D$368 VSS__t239 OUTN__t13 diode_nd2ps_06v0 A=2P P=6U
* device instance $369 r0 *1 519.3,30.5 diode_nd2ps_06v0
D$369 VSS__t240 OUTN__t14 diode_nd2ps_06v0 A=2P P=6U
* device instance $370 r0 *1 521.9,30.5 diode_nd2ps_06v0
D$370 VSS__t241 OUTN__t15 diode_nd2ps_06v0 A=2P P=6U
* device instance $371 r0 *1 524.5,30.5 diode_nd2ps_06v0
D$371 VSS__t242 OUTN__t16 diode_nd2ps_06v0 A=2P P=6U
* device instance $372 r0 *1 527.1,30.5 diode_nd2ps_06v0
D$372 VSS__t243 OUTN__t17 diode_nd2ps_06v0 A=2P P=6U
* device instance $373 r0 *1 529.7,30.5 diode_nd2ps_06v0
D$373 VSS__t244 OUTN__t19 diode_nd2ps_06v0 A=2P P=6U
* device instance $374 r0 *1 532.3,30.5 diode_nd2ps_06v0
D$374 VSS__t245 OUTN__t18 diode_nd2ps_06v0 A=2P P=6U
* device instance $375 r0 *1 534.9,30.5 diode_nd2ps_06v0
D$375 VSS__t246 OUTN__t1 diode_nd2ps_06v0 A=2P P=6U
* device instance $376 r0 *1 537.5,30.5 diode_nd2ps_06v0
D$376 VSS__t247 OUTN__t2 diode_nd2ps_06v0 A=2P P=6U
* device instance $377 r0 *1 540.1,30.5 diode_nd2ps_06v0
D$377 VSS__t248 OUTN__t3 diode_nd2ps_06v0 A=2P P=6U
* device instance $378 r0 *1 542.7,30.5 diode_nd2ps_06v0
D$378 VSS__t249 OUTN__t4 diode_nd2ps_06v0 A=2P P=6U
* device instance IBIAS_t0 r0 *1 0,0
RIBIAS_t0 IBIAS__t0 IBIAS 15.6583103769
* device instance IBIAS_t1 r0 *1 0,0
RIBIAS_t1 IBIAS__t1 IBIAS 64.7455804069
* device instance IBIAS_t2 r0 *1 0,0
RIBIAS_t2 IBIAS__t2 IBIAS 54.4045516387
* device instance IBIAS_t3 r0 *1 0,0
RIBIAS_t3 IBIAS__t3 IBIAS 54.6888029181
* device instance IBIAS_t4 r0 *1 0,0
RIBIAS_t4 IBIAS__t4 IBIAS 49.3317160189
* device instance IBIAS_t5 r0 *1 0,0
RIBIAS_t5 IBIAS__t5 IBIAS 25.233996557
* device instance IBIAS_t6 r0 *1 0,0
RIBIAS_t6 IBIAS__t6 IBIAS 24.0368702656
* device instance IBIAS_t7 r0 *1 0,0
RIBIAS_t7 IBIAS__t7 IBIAS 23.438318967
* device instance IBIAS_t8 r0 *1 0,0
RIBIAS_t8 IBIAS__t8 IBIAS 22.8397763943
* device instance IBIAS_t9 r0 *1 0,0
RIBIAS_t9 IBIAS__t9 IBIAS 22.2412432521
* device instance IBIAS_t10 r0 *1 0,0
RIBIAS_t10 IBIAS__t10 IBIAS 30.6213641145
* device instance IBIAS_t11 r0 *1 0,0
RIBIAS_t11 IBIAS__t11 IBIAS 47.9823282792
* device instance IBIAS_t12 r0 *1 0,0
RIBIAS_t12 IBIAS__t12 IBIAS 41.9956160389
* device instance IBIAS_t13 r0 *1 0,0
RIBIAS_t13 IBIAS__t13 IBIAS 43.1929481665
* device instance IBIAS_t14 r0 *1 0,0
RIBIAS_t14 IBIAS__t14 IBIAS 43.7916163505
* device instance IBIAS_t15 r0 *1 0,0
RIBIAS_t15 IBIAS__t15 IBIAS 44.3902858718
* device instance IBIAS_t16 r0 *1 0,0
RIBIAS_t16 IBIAS__t16 IBIAS 47.3836517633
* device instance IBIAS_t17 r0 *1 0,0
RIBIAS_t17 IBIAS__t17 IBIAS 46.784976303
* device instance IBIAS_t18 r0 *1 0,0
RIBIAS_t18 IBIAS__t18 IBIAS 46.1863019393
* device instance IBIAS_t19 r0 *1 0,0
RIBIAS_t19 IBIAS__t19 IBIAS 45.5876287155
* device instance IBIAS_t20 r0 *1 0,0
RIBIAS_t20 IBIAS__t20 IBIAS 44.988956677
* device instance IBIAS_t21 r0 *1 0,0
RIBIAS_t21 IBIAS__t21 IBIAS 42.5942813761
* device instance IBIAS_t22 r0 *1 0,0
RIBIAS_t22 IBIAS__t22 IBIAS 48.5810058117
* device instance IBIAS_t23 r0 *1 0,0
RIBIAS_t23 IBIAS__t23 IBIAS 31.219983782
* device instance IBIAS_t24 r0 *1 0,0
RIBIAS_t24 IBIAS__t24 IBIAS 31.8186071407
* device instance IBIAS_t25 r0 *1 0,0
RIBIAS_t25 IBIAS__t25 IBIAS 32.4172339863
* device instance IBIAS_t26 r0 *1 0,0
RIBIAS_t26 IBIAS__t26 IBIAS 33.0158641288
* device instance IBIAS_t27 r0 *1 0,0
RIBIAS_t27 IBIAS__t27 IBIAS 33.6144973924
* device instance IBIAS_t28 r0 *1 0,0
RIBIAS_t28 IBIAS__t28 IBIAS 34.213133613
* device instance IBIAS_t29 r0 *1 0,0
RIBIAS_t29 IBIAS__t29 IBIAS 34.8117726382
* device instance IBIAS_t30 r0 *1 0,0
RIBIAS_t30 IBIAS__t30 IBIAS 35.4104143257
* device instance IBIAS_t31 r0 *1 0,0
RIBIAS_t31 IBIAS__t31 IBIAS 24.6354296542
* device instance IBIAS_t32 r0 *1 0,0
RIBIAS_t32 IBIAS__t32 IBIAS 36.6077051652
* device instance IBIAS_t33 r0 *1 0,0
RIBIAS_t33 IBIAS__t33 IBIAS 37.206354077
* device instance IBIAS_t34 r0 *1 0,0
RIBIAS_t34 IBIAS__t34 IBIAS 37.8050051694
* device instance IBIAS_t35 r0 *1 0,0
RIBIAS_t35 IBIAS__t35 IBIAS 38.4036583404
* device instance IBIAS_t36 r0 *1 0,0
RIBIAS_t36 IBIAS__t36 IBIAS 39.0023134943
* device instance IBIAS_t37 r0 *1 0,0
RIBIAS_t37 IBIAS__t37 IBIAS 39.6009705411
* device instance IBIAS_t38 r0 *1 0,0
RIBIAS_t38 IBIAS__t38 IBIAS 40.1996293963
* device instance IBIAS_t39 r0 *1 0,0
RIBIAS_t39 IBIAS__t39 IBIAS 40.7982899803
* device instance IBIAS_t40 r0 *1 0,0
RIBIAS_t40 IBIAS__t40 IBIAS 41.3969522181
* device instance IBIAS_t41 r0 *1 0,0
RIBIAS_t41 IBIAS__t41 IBIAS 36.0090585427
* device instance IBIAS_t42 r0 *1 0,0
RIBIAS_t42 IBIAS__t42 IBIAS 62.9494961482
* device instance IBIAS_t43 r0 *1 0,0
RIBIAS_t43 IBIAS__t43 IBIAS 63.5481904676
* device instance IBIAS_t44 r0 *1 0,0
RIBIAS_t44 IBIAS__t44 IBIAS 64.1468852245
* device instance IBIAS_t45 r0 *1 0,0
RIBIAS_t45 IBIAS__t45 IBIAS 49.1796843235
* device instance IBIAS_t46 r0 *1 0,0
RIBIAS_t46 IBIAS__t46 IBIAS 49.7783637795
* device instance IBIAS_t47 r0 *1 0,0
RIBIAS_t47 IBIAS__t47 IBIAS 50.377044146
* device instance IBIAS_t48 r0 *1 0,0
RIBIAS_t48 IBIAS__t48 IBIAS 50.9757253908
* device instance IBIAS_t49 r0 *1 0,0
RIBIAS_t49 IBIAS__t49 IBIAS 51.5744074833
* device instance IBIAS_t50 r0 *1 0,0
RIBIAS_t50 IBIAS__t50 IBIAS 52.1730903945
* device instance IBIAS_t51 r0 *1 0,0
RIBIAS_t51 IBIAS__t51 IBIAS 53.3704585623
* device instance IBIAS_t52 r0 *1 0,0
RIBIAS_t52 IBIAS__t52 IBIAS 53.969143767
* device instance IBIAS_t53 r0 *1 0,0
RIBIAS_t53 IBIAS__t53 IBIAS 54.5678296861
* device instance IBIAS_t54 r0 *1 0,0
RIBIAS_t54 IBIAS__t54 IBIAS 55.1665162963
* device instance IBIAS_t55 r0 *1 0,0
RIBIAS_t55 IBIAS__t55 IBIAS 55.7652035753
* device instance IBIAS_t56 r0 *1 0,0
RIBIAS_t56 IBIAS__t56 IBIAS 56.3638915019
* device instance IBIAS_t57 r0 *1 0,0
RIBIAS_t57 IBIAS__t57 IBIAS 56.9625800556
* device instance IBIAS_t58 r0 *1 0,0
RIBIAS_t58 IBIAS__t58 IBIAS 57.5612692169
* device instance IBIAS_t59 r0 *1 0,0
RIBIAS_t59 IBIAS__t59 IBIAS 58.1599589669
* device instance IBIAS_t60 r0 *1 0,0
RIBIAS_t60 IBIAS__t60 IBIAS 58.7586492878
* device instance IBIAS_t61 r0 *1 0,0
RIBIAS_t61 IBIAS__t61 IBIAS 52.7717740963
* device instance IBIAS_t62 r0 *1 0,0
RIBIAS_t62 IBIAS__t62 IBIAS 25.8325704517
* device instance IBIAS_t63 r0 *1 0,0
RIBIAS_t63 IBIAS__t63 IBIAS 26.4311508633
* device instance IBIAS_t64 r0 *1 0,0
RIBIAS_t64 IBIAS__t64 IBIAS 27.0297373589
* device instance IBIAS_t65 r0 *1 0,0
RIBIAS_t65 IBIAS__t65 IBIAS 27.6283295429
* device instance IBIAS_t66 r0 *1 0,0
RIBIAS_t66 IBIAS__t66 IBIAS 28.2269270536
* device instance IBIAS_t67 r0 *1 0,0
RIBIAS_t67 IBIAS__t67 IBIAS 28.825529559
* device instance IBIAS_t68 r0 *1 0,0
RIBIAS_t68 IBIAS__t68 IBIAS 29.4241367543
* device instance IBIAS_t69 r0 *1 0,0
RIBIAS_t69 IBIAS__t69 IBIAS 30.022748359
* device instance IBIAS_t70 r0 *1 0,0
RIBIAS_t70 IBIAS__t70 IBIAS 18.0518541029
* device instance IBIAS_t71 r0 *1 0,0
RIBIAS_t71 IBIAS__t71 IBIAS 62.350802279
* device instance IBIAS_t72 r0 *1 0,0
RIBIAS_t72 IBIAS__t72 IBIAS 19.2487497874
* device instance IBIAS_t73 r0 *1 0,0
RIBIAS_t73 IBIAS__t73 IBIAS 19.8472220514
* device instance IBIAS_t74 r0 *1 0,0
RIBIAS_t74 IBIAS__t74 IBIAS 20.4457086903
* device instance IBIAS_t75 r0 *1 0,0
RIBIAS_t75 IBIAS__t75 IBIAS 21.0442084777
* device instance IBIAS_t76 r0 *1 0,0
RIBIAS_t76 IBIAS__t76 IBIAS 21.6427203228
* device instance IBIAS_t77 r0 *1 0,0
RIBIAS_t77 IBIAS__t77 IBIAS 17.4534340321
* device instance IBIAS_t78 r0 *1 0,0
RIBIAS_t78 IBIAS__t78 IBIAS 16.8550351047
* device instance IBIAS_t79 r0 *1 0,0
RIBIAS_t79 IBIAS__t79 IBIAS 60.5547235059
* device instance IBIAS_t80 r0 *1 0,0
RIBIAS_t80 IBIAS__t80 IBIAS 61.153415944
* device instance IBIAS_t81 r0 *1 0,0
RIBIAS_t81 IBIAS__t81 IBIAS 61.752108873
* device instance IBIAS_t82 r0 *1 0,0
RIBIAS_t82 IBIAS__t82 IBIAS 18.6502932821
* device instance IBIAS_t83 r0 *1 0,0
RIBIAS_t83 IBIAS__t83 IBIAS 1.95942636626
* device instance IBIAS_t84 r0 *1 0,0
RIBIAS_t84 IBIAS__t84 IBIAS 1.39616413046
* device instance IBIAS_t85 r0 *1 0,0
RIBIAS_t85 IBIAS__t85 IBIAS 0.880978311894
* device instance IBIAS_t86 r0 *1 0,0
RIBIAS_t86 IBIAS__t86 IBIAS 0.565594559166
* device instance IBIAS_t87 r0 *1 0,0
RIBIAS_t87 IBIAS__t87 IBIAS 0.761969511968
* device instance IBIAS_t88 r0 *1 0,0
RIBIAS_t88 IBIAS__t88 IBIAS 1.24828834067
* device instance IBIAS_t89 r0 *1 0,0
RIBIAS_t89 IBIAS__t89 IBIAS 1.80354538014
* device instance IBIAS_t90 r0 *1 0,0
RIBIAS_t90 IBIAS__t90 IBIAS 2.3799693291
* device instance IBIAS_t91 r0 *1 0,0
RIBIAS_t91 IBIAS__t91 IBIAS 2.96524164095
* device instance IBIAS_t92 r0 *1 0,0
RIBIAS_t92 IBIAS__t92 IBIAS 9.51431616102
* device instance IBIAS_t93 r0 *1 0,0
RIBIAS_t93 IBIAS__t93 IBIAS 3.55499477966
* device instance IBIAS_t94 r0 *1 0,0
RIBIAS_t94 IBIAS__t94 IBIAS 4.14731765001
* device instance IBIAS_t95 r0 *1 0,0
RIBIAS_t95 IBIAS__t95 IBIAS 4.74124724195
* device instance IBIAS_t96 r0 *1 0,0
RIBIAS_t96 IBIAS__t96 IBIAS 5.33624709331
* device instance IBIAS_t97 r0 *1 0,0
RIBIAS_t97 IBIAS__t97 IBIAS 16.2566596558
* device instance IBIAS_t98 r0 *1 0,0
RIBIAS_t98 IBIAS__t98 IBIAS 6.52828660842
* device instance IBIAS_t99 r0 *1 0,0
RIBIAS_t99 IBIAS__t99 IBIAS 7.12498501126
* device instance IBIAS_t100 r0 *1 0,0
RIBIAS_t100 IBIAS__t100 IBIAS 7.72199603032
* device instance IBIAS_t101 r0 *1 0,0
RIBIAS_t101 IBIAS__t101 IBIAS 8.31925236342
* device instance IBIAS_t102 r0 *1 0,0
RIBIAS_t102 IBIAS__t102 IBIAS 8.91670471603
* device instance IBIAS_t103 r0 *1 0,0
RIBIAS_t103 IBIAS__t103 IBIAS 10.1120584919
* device instance IBIAS_t104 r0 *1 0,0
RIBIAS_t104 IBIAS__t104 IBIAS 32.2539717846
* device instance IBIAS_t105 r0 *1 0,0
RIBIAS_t105 IBIAS__t105 IBIAS 32.852601046
* device instance IBIAS_t106 r0 *1 0,0
RIBIAS_t106 IBIAS__t106 IBIAS 33.4512334751
* device instance IBIAS_t107 r0 *1 0,0
RIBIAS_t107 IBIAS__t107 IBIAS 34.0498689048
* device instance IBIAS_t108 r0 *1 0,0
RIBIAS_t108 IBIAS__t108 IBIAS 34.6485071797
* device instance IBIAS_t109 r0 *1 0,0
RIBIAS_t109 IBIAS__t109 IBIAS 35.2471481546
* device instance IBIAS_t110 r0 *1 0,0
RIBIAS_t110 IBIAS__t110 IBIAS 35.8457916945
* device instance IBIAS_t111 r0 *1 0,0
RIBIAS_t111 IBIAS__t111 IBIAS 36.4444376727
* device instance IBIAS_t112 r0 *1 0,0
RIBIAS_t112 IBIAS__t112 IBIAS 37.0430859713
* device instance IBIAS_t113 r0 *1 0,0
RIBIAS_t113 IBIAS__t113 IBIAS 5.93199516057
* device instance IBIAS_t114 r0 *1 0,0
RIBIAS_t114 IBIAS__t114 IBIAS 14.8968177556
* device instance IBIAS_t115 r0 *1 0,0
RIBIAS_t115 IBIAS__t115 IBIAS 15.4951291504
* device instance IBIAS_t116 r0 *1 0,0
RIBIAS_t116 IBIAS__t116 IBIAS 16.0934707706
* device instance IBIAS_t117 r0 *1 0,0
RIBIAS_t117 IBIAS__t117 IBIAS 6.09457291971
* device instance IBIAS_t118 r0 *1 0,0
RIBIAS_t118 IBIAS__t118 IBIAS 5.49865986224
* device instance IBIAS_t119 r0 *1 0,0
RIBIAS_t119 IBIAS__t119 IBIAS 10.7099097936
* device instance IBIAS_t120 r0 *1 0,0
RIBIAS_t120 IBIAS__t120 IBIAS 15.0599903873
* device instance IBIAS_t121 r0 *1 0,0
RIBIAS_t121 IBIAS__t121 IBIAS 14.4617033224
* device instance IBIAS_t122 r0 *1 0,0
RIBIAS_t122 IBIAS__t122 IBIAS 13.8634534449
* device instance IBIAS_t123 r0 *1 0,0
RIBIAS_t123 IBIAS__t123 IBIAS 13.265245786
* device instance IBIAS_t124 r0 *1 0,0
RIBIAS_t124 IBIAS__t124 IBIAS 12.6670863272
* device instance IBIAS_t125 r0 *1 0,0
RIBIAS_t125 IBIAS__t125 IBIAS 12.068982235
* device instance IBIAS_t126 r0 *1 0,0
RIBIAS_t126 IBIAS__t126 IBIAS 11.4709421702
* device instance IBIAS_t127 r0 *1 0,0
RIBIAS_t127 IBIAS__t127 IBIAS 10.8729766976
* device instance IBIAS_t128 r0 *1 0,0
RIBIAS_t128 IBIAS__t128 IBIAS 10.2750988401
* device instance IBIAS_t129 r0 *1 0,0
RIBIAS_t129 IBIAS__t129 IBIAS 2.53896731033
* device instance IBIAS_t130 r0 *1 0,0
RIBIAS_t130 IBIAS__t130 IBIAS 9.07967519935
* device instance IBIAS_t131 r0 *1 0,0
RIBIAS_t131 IBIAS__t131 IBIAS 8.48217621665
* device instance IBIAS_t132 r0 *1 0,0
RIBIAS_t132 IBIAS__t132 IBIAS 7.8848621375
* device instance IBIAS_t133 r0 *1 0,0
RIBIAS_t133 IBIAS__t133 IBIAS 7.28777842672
* device instance IBIAS_t134 r0 *1 0,0
RIBIAS_t134 IBIAS__t134 IBIAS 11.3078527822
* device instance IBIAS_t135 r0 *1 0,0
RIBIAS_t135 IBIAS__t135 IBIAS 11.9058736434
* device instance IBIAS_t136 r0 *1 0,0
RIBIAS_t136 IBIAS__t136 IBIAS 12.5039612041
* device instance IBIAS_t137 r0 *1 0,0
RIBIAS_t137 IBIAS__t137 IBIAS 13.1021063302
* device instance IBIAS_t138 r0 *1 0,0
RIBIAS_t138 IBIAS__t138 IBIAS 13.7003014819
* device instance IBIAS_t139 r0 *1 0,0
RIBIAS_t139 IBIAS__t139 IBIAS 14.2985403805
* device instance IBIAS_t140 r0 *1 0,0
RIBIAS_t140 IBIAS__t140 IBIAS 6.69098675676
* device instance IBIAS_t141 r0 *1 0,0
RIBIAS_t141 IBIAS__t141 IBIAS 4.90343016674
* device instance IBIAS_t142 r0 *1 0,0
RIBIAS_t142 IBIAS__t142 IBIAS 4.309167023
* device instance IBIAS_t143 r0 *1 0,0
RIBIAS_t143 IBIAS__t143 IBIAS 3.71633413145
* device instance IBIAS_t144 r0 *1 0,0
RIBIAS_t144 IBIAS__t144 IBIAS 3.12574538846
* device instance IBIAS_t145 r0 *1 0,0
RIBIAS_t145 IBIAS__t145 IBIAS 9.67732483663
* device instance IBIAS_t146 r0 *1 0,0
RIBIAS_t146 IBIAS__t146 IBIAS 25.6693223604
* device instance IBIAS_t147 r0 *1 0,0
RIBIAS_t147 IBIAS__t147 IBIAS 26.2679010393
* device instance IBIAS_t148 r0 *1 0,0
RIBIAS_t148 IBIAS__t148 IBIAS 26.8664859163
* device instance IBIAS_t149 r0 *1 0,0
RIBIAS_t149 IBIAS__t149 IBIAS 27.4650765862
* device instance IBIAS_t150 r0 *1 0,0
RIBIAS_t150 IBIAS__t150 IBIAS 28.0636726782
* device instance IBIAS_t151 r0 *1 0,0
RIBIAS_t151 IBIAS__t151 IBIAS 28.6622738527
* device instance IBIAS_t152 r0 *1 0,0
RIBIAS_t152 IBIAS__t152 IBIAS 29.2608797978
* device instance IBIAS_t153 r0 *1 0,0
RIBIAS_t153 IBIAS__t153 IBIAS 29.8594902264
* device instance IBIAS_t154 r0 *1 0,0
RIBIAS_t154 IBIAS__t154 IBIAS 30.4581048744
* device instance IBIAS_t155 r0 *1 0,0
RIBIAS_t155 IBIAS__t155 IBIAS 31.0567234976
* device instance IBIAS_t156 r0 *1 0,0
RIBIAS_t156 IBIAS__t156 IBIAS 31.6553458706
* device instance IBIAS_t157 r0 *1 0,0
RIBIAS_t157 IBIAS__t157 IBIAS 16.6918393658
* device instance IBIAS_t158 r0 *1 0,0
RIBIAS_t158 IBIAS__t158 IBIAS 54.0932632789
* device instance IBIAS_t159 r0 *1 0,0
RIBIAS_t159 IBIAS__t159 IBIAS 50.5216031178
* device instance IBIAS_t160 r0 *1 0,0
RIBIAS_t160 IBIAS__t160 IBIAS 51.1166788688
* device instance IBIAS_t161 r0 *1 0,0
RIBIAS_t161 IBIAS__t161 IBIAS 37.6417364794
* device instance IBIAS_t162 r0 *1 0,0
RIBIAS_t162 IBIAS__t162 IBIAS 52.3070797338
* device instance IBIAS_t163 r0 *1 0,0
RIBIAS_t163 IBIAS__t163 IBIAS 52.9023992366
* device instance IBIAS_t164 r0 *1 0,0
RIBIAS_t164 IBIAS__t164 IBIAS 50.213767594
* device instance IBIAS_t165 r0 *1 0,0
RIBIAS_t165 IBIAS__t165 IBIAS 50.8124486023
* device instance IBIAS_t166 r0 *1 0,0
RIBIAS_t166 IBIAS__t166 IBIAS 51.4111304666
* device instance IBIAS_t167 r0 *1 0,0
RIBIAS_t167 IBIAS__t167 IBIAS 52.0098131573
* device instance IBIAS_t168 r0 *1 0,0
RIBIAS_t168 IBIAS__t168 IBIAS 52.6084966462
* device instance IBIAS_t169 r0 *1 0,0
RIBIAS_t169 IBIAS__t169 IBIAS 53.2071809064
* device instance IBIAS_t170 r0 *1 0,0
RIBIAS_t170 IBIAS__t170 IBIAS 53.8058659121
* device instance IBIAS_t171 r0 *1 0,0
RIBIAS_t171 IBIAS__t171 IBIAS 53.4977945865
* device instance IBIAS_t172 r0 *1 0,0
RIBIAS_t172 IBIAS__t172 IBIAS 49.0164082707
* device instance IBIAS_t173 r0 *1 0,0
RIBIAS_t173 IBIAS__t173 IBIAS 49.6150874726
* device instance IBIAS_t174 r0 *1 0,0
RIBIAS_t174 IBIAS__t174 IBIAS 49.9266144509
* device instance IBIAS_t175 r0 *1 0,0
RIBIAS_t175 IBIAS__t175 IBIAS 59.9560315735
* device instance IBIAS_t176 r0 *1 0,0
RIBIAS_t176 IBIAS__t176 IBIAS 59.3573401622
* device instance IBIAS_t177 r0 *1 0,0
RIBIAS_t177 IBIAS__t177 IBIAS 51.7118386974
* device instance IBIAS_t178 r0 *1 0,0
RIBIAS_t178 IBIAS__t178 IBIAS 38.2403890932
* device instance IBIAS_t179 r0 *1 0,0
RIBIAS_t179 IBIAS__t179 IBIAS 38.8390437154
* device instance IBIAS_t180 r0 *1 0,0
RIBIAS_t180 IBIAS__t180 IBIAS 39.4377002546
* device instance IBIAS_t181 r0 *1 0,0
RIBIAS_t181 IBIAS__t181 IBIAS 40.0363586247
* device instance IBIAS_t182 r0 *1 0,0
RIBIAS_t182 IBIAS__t182 IBIAS 40.6350187449
* device instance IBIAS_t183 r0 *1 0,0
RIBIAS_t183 IBIAS__t183 IBIAS 41.2336805388
* device instance IBIAS_t184 r0 *1 0,0
RIBIAS_t184 IBIAS__t184 IBIAS 41.8323439347
* device instance IBIAS_t185 r0 *1 0,0
RIBIAS_t185 IBIAS__t185 IBIAS 42.4310088647
* device instance IBIAS_t186 r0 *1 0,0
RIBIAS_t186 IBIAS__t186 IBIAS 43.0296752648
* device instance IBIAS_t187 r0 *1 0,0
RIBIAS_t187 IBIAS__t187 IBIAS 43.6283430745
* device instance IBIAS_t188 r0 *1 0,0
RIBIAS_t188 IBIAS__t188 IBIAS 44.2270122365
* device instance IBIAS_t189 r0 *1 0,0
RIBIAS_t189 IBIAS__t189 IBIAS 44.8256826967
* device instance IBIAS_t190 r0 *1 0,0
RIBIAS_t190 IBIAS__t190 IBIAS 45.4243544037
* device instance IBIAS_t191 r0 *1 0,0
RIBIAS_t191 IBIAS__t191 IBIAS 46.0230273088
* device instance IBIAS_t192 r0 *1 0,0
RIBIAS_t192 IBIAS__t192 IBIAS 46.621701366
* device instance IBIAS_t193 r0 *1 0,0
RIBIAS_t193 IBIAS__t193 IBIAS 25.0707503236
* device instance IBIAS_t194 r0 *1 0,0
RIBIAS_t194 IBIAS__t194 IBIAS 47.8190527634
* device instance IBIAS_t195 r0 *1 0,0
RIBIAS_t195 IBIAS__t195 IBIAS 48.4177300223
* device instance IBIAS_t196 r0 *1 0,0
RIBIAS_t196 IBIAS__t196 IBIAS 17.2902321354
* device instance IBIAS_t197 r0 *1 0,0
RIBIAS_t197 IBIAS__t197 IBIAS 17.8886466533
* device instance IBIAS_t198 r0 *1 0,0
RIBIAS_t198 IBIAS__t198 IBIAS 18.4870808078
* device instance IBIAS_t199 r0 *1 0,0
RIBIAS_t199 IBIAS__t199 IBIAS 19.0855327516
* device instance IBIAS_t200 r0 *1 0,0
RIBIAS_t200 IBIAS__t200 IBIAS 19.6840008622
* device instance IBIAS_t201 r0 *1 0,0
RIBIAS_t201 IBIAS__t201 IBIAS 20.2824837086
* device instance IBIAS_t202 r0 *1 0,0
RIBIAS_t202 IBIAS__t202 IBIAS 20.8809800236
* device instance IBIAS_t203 r0 *1 0,0
RIBIAS_t203 IBIAS__t203 IBIAS 21.4794886814
* device instance IBIAS_t204 r0 *1 0,0
RIBIAS_t204 IBIAS__t204 IBIAS 22.0780086782
* device instance IBIAS_t205 r0 *1 0,0
RIBIAS_t205 IBIAS__t205 IBIAS 22.6765391162
* device instance IBIAS_t206 r0 *1 0,0
RIBIAS_t206 IBIAS__t206 IBIAS 23.2750791898
* device instance IBIAS_t207 r0 *1 0,0
RIBIAS_t207 IBIAS__t207 IBIAS 23.8736281744
* device instance IBIAS_t208 r0 *1 0,0
RIBIAS_t208 IBIAS__t208 IBIAS 24.4721854162
* device instance IBIAS_t209 r0 *1 0,0
RIBIAS_t209 IBIAS__t209 IBIAS 47.2203765314
* device instance IBIAS_t210 r0 *1 0,0
RIBIAS_t210 IBIAS__t210 IBIAS 49.3317160189
* device instance IBIAS_t211 r0 *1 0,0
RIBIAS_t211 IBIAS__t211 IBIAS 51.1166788688
* device instance IBIAS_t212 r0 *1 0,0
RIBIAS_t212 IBIAS__t212 IBIAS 52.3070797338
* device instance IBIAS_t213 r0 *1 0,0
RIBIAS_t213 IBIAS__t213 IBIAS 53.4977945865
* device instance IBIAS_t214 r0 *1 0,0
RIBIAS_t214 IBIAS__t214 IBIAS 49.9266144509
* device instance IBIAS_t215 r0 *1 0,0
RIBIAS_t215 IBIAS__t215 IBIAS 54.6888029181
* device instance IBIAS_t216 r0 *1 0,0
RIBIAS_t216 IBIAS__t216 IBIAS 54.0932632789
* device instance IBIAS_t217 r0 *1 0,0
RIBIAS_t217 IBIAS__t217 IBIAS 50.5216031178
* device instance IBIAS_t218 r0 *1 0,0
RIBIAS_t218 IBIAS__t218 IBIAS 52.9023992366
* device instance IBIAS_t219 r0 *1 0,0
RIBIAS_t219 IBIAS__t219 IBIAS 51.7118386974
* device instance IBIAS r0 *1 0,0
CIBIAS IBIAS vsubs 7.8205174e-14
* device instance INN_t0 r0 *1 0,0
RINN_t0 INN__t0 INN 83.2711482422
* device instance INN_t1 r0 *1 0,0
RINN_t1 INN__t1 INN 83.2711482422
* device instance INN_t2 r0 *1 0,0
RINN_t2 INN__t2 INN 19.8264638672
* device instance INN_t3 r0 *1 0,0
RINN_t3 INN__t3 INN 22.4699923828
* device instance INN_t4 r0 *1 0,0
RINN_t4 INN__t4 INN 25.1135208984
* device instance INN_t5 r0 *1 0,0
RINN_t5 INN__t5 INN 14.5394068359
* device instance INN_t6 r0 *1 0,0
RINN_t6 INN__t6 INN 27.7570494141
* device instance INN_t7 r0 *1 0,0
RINN_t7 INN__t7 INN 30.4005779297
* device instance INN_t8 r0 *1 0,0
RINN_t8 INN__t8 INN 33.0441064453
* device instance INN_t9 r0 *1 0,0
RINN_t9 INN__t9 INN 35.6876349609
* device instance INN_t10 r0 *1 0,0
RINN_t10 INN__t10 INN 40.9746919922
* device instance INN_t11 r0 *1 0,0
RINN_t11 INN__t11 INN 17.1829353516
* device instance INN_t12 r0 *1 0,0
RINN_t12 INN__t12 INN 11.8958783203
* device instance INN_t13 r0 *1 0,0
RINN_t13 INN__t13 INN 9.25234980469
* device instance INN_t14 r0 *1 0,0
RINN_t14 INN__t14 INN 6.60882128906
* device instance INN_t15 r0 *1 0,0
RINN_t15 INN__t15 INN 3.96529277344
* device instance INN_t16 r0 *1 0,0
RINN_t16 INN__t16 INN 1.32176425781
* device instance INN_t17 r0 *1 0,0
RINN_t17 INN__t17 INN 1.32176425781
* device instance INN_t18 r0 *1 0,0
RINN_t18 INN__t18 INN 3.96529277344
* device instance INN_t19 r0 *1 0,0
RINN_t19 INN__t19 INN 6.60882128906
* device instance INN_t20 r0 *1 0,0
RINN_t20 INN__t20 INN 38.3311634766
* device instance INN_t21 r0 *1 0,0
RINN_t21 INN__t21 INN 64.7664486328
* device instance INN_t22 r0 *1 0,0
RINN_t22 INN__t22 INN 80.6276197266
* device instance INN_t23 r0 *1 0,0
RINN_t23 INN__t23 INN 77.9840912109
* device instance INN_t24 r0 *1 0,0
RINN_t24 INN__t24 INN 75.3405626953
* device instance INN_t25 r0 *1 0,0
RINN_t25 INN__t25 INN 72.6970341797
* device instance INN_t26 r0 *1 0,0
RINN_t26 INN__t26 INN 67.4099771484
* device instance INN_t27 r0 *1 0,0
RINN_t27 INN__t27 INN 64.7664486328
* device instance INN_t28 r0 *1 0,0
RINN_t28 INN__t28 INN 62.1229201172
* device instance INN_t29 r0 *1 0,0
RINN_t29 INN__t29 INN 59.4793916016
* device instance INN_t30 r0 *1 0,0
RINN_t30 INN__t30 INN 56.8358630859
* device instance INN_t31 r0 *1 0,0
RINN_t31 INN__t31 INN 54.1923345703
* device instance INN_t32 r0 *1 0,0
RINN_t32 INN__t32 INN 51.5488060547
* device instance INN_t33 r0 *1 0,0
RINN_t33 INN__t33 INN 48.9052775391
* device instance INN_t34 r0 *1 0,0
RINN_t34 INN__t34 INN 46.2617490234
* device instance INN_t35 r0 *1 0,0
RINN_t35 INN__t35 INN 43.6182205078
* device instance INN_t36 r0 *1 0,0
RINN_t36 INN__t36 INN 70.0535056641
* device instance INN_t37 r0 *1 0,0
RINN_t37 INN__t37 INN 38.3311634766
* device instance INN_t38 r0 *1 0,0
RINN_t38 INN__t38 INN 40.9746919922
* device instance INN_t39 r0 *1 0,0
RINN_t39 INN__t39 INN 43.6182205078
* device instance INN_t40 r0 *1 0,0
RINN_t40 INN__t40 INN 46.2617490234
* device instance INN_t41 r0 *1 0,0
RINN_t41 INN__t41 INN 48.9052775391
* device instance INN_t42 r0 *1 0,0
RINN_t42 INN__t42 INN 51.5488060547
* device instance INN_t43 r0 *1 0,0
RINN_t43 INN__t43 INN 25.1135208984
* device instance INN_t44 r0 *1 0,0
RINN_t44 INN__t44 INN 14.5394068359
* device instance INN_t45 r0 *1 0,0
RINN_t45 INN__t45 INN 17.1829353516
* device instance INN_t46 r0 *1 0,0
RINN_t46 INN__t46 INN 19.8264638672
* device instance INN_t47 r0 *1 0,0
RINN_t47 INN__t47 INN 22.4699923828
* device instance INN_t48 r0 *1 0,0
RINN_t48 INN__t48 INN 59.4793916016
* device instance INN_t49 r0 *1 0,0
RINN_t49 INN__t49 INN 27.7570494141
* device instance INN_t50 r0 *1 0,0
RINN_t50 INN__t50 INN 56.8358630859
* device instance INN_t51 r0 *1 0,0
RINN_t51 INN__t51 INN 62.1229201172
* device instance INN_t52 r0 *1 0,0
RINN_t52 INN__t52 INN 67.4099771484
* device instance INN_t53 r0 *1 0,0
RINN_t53 INN__t53 INN 35.6876349609
* device instance INN_t54 r0 *1 0,0
RINN_t54 INN__t54 INN 30.4005779297
* device instance INN_t55 r0 *1 0,0
RINN_t55 INN__t55 INN 33.0441064453
* device instance INN_t56 r0 *1 0,0
RINN_t56 INN__t56 INN 11.8958783203
* device instance INN_t57 r0 *1 0,0
RINN_t57 INN__t57 INN 54.1923345703
* device instance INN_t58 r0 *1 0,0
RINN_t58 INN__t58 INN 80.6276197266
* device instance INN_t59 r0 *1 0,0
RINN_t59 INN__t59 INN 77.9840912109
* device instance INN_t60 r0 *1 0,0
RINN_t60 INN__t60 INN 75.3405626953
* device instance INN_t61 r0 *1 0,0
RINN_t61 INN__t61 INN 72.6970341797
* device instance INN_t62 r0 *1 0,0
RINN_t62 INN__t62 INN 70.0535056641
* device instance INN_t63 r0 *1 0,0
RINN_t63 INN__t63 INN 9.25234980469
* device instance INN r0 *1 0,0
CINN INN vsubs 1.6841892e-14
* device instance INP_t0 r0 *1 0,0
RINP_t0 INP__t0 INP 11.8958783203
* device instance INP_t1 r0 *1 0,0
RINP_t1 INP__t1 INP 83.2711482422
* device instance INP_t2 r0 *1 0,0
RINP_t2 INP__t2 INP 83.2711482422
* device instance INP_t3 r0 *1 0,0
RINP_t3 INP__t3 INP 9.25234980469
* device instance INP_t4 r0 *1 0,0
RINP_t4 INP__t4 INP 6.60882128906
* device instance INP_t5 r0 *1 0,0
RINP_t5 INP__t5 INP 17.1829353516
* device instance INP_t6 r0 *1 0,0
RINP_t6 INP__t6 INP 14.5394068359
* device instance INP_t7 r0 *1 0,0
RINP_t7 INP__t7 INP 11.8958783203
* device instance INP_t8 r0 *1 0,0
RINP_t8 INP__t8 INP 19.8264638672
* device instance INP_t9 r0 *1 0,0
RINP_t9 INP__t9 INP 19.8264638672
* device instance INP_t10 r0 *1 0,0
RINP_t10 INP__t10 INP 22.4699923828
* device instance INP_t11 r0 *1 0,0
RINP_t11 INP__t11 INP 25.1135208984
* device instance INP_t12 r0 *1 0,0
RINP_t12 INP__t12 INP 72.6970341797
* device instance INP_t13 r0 *1 0,0
RINP_t13 INP__t13 INP 14.5394068359
* device instance INP_t14 r0 *1 0,0
RINP_t14 INP__t14 INP 17.1829353516
* device instance INP_t15 r0 *1 0,0
RINP_t15 INP__t15 INP 48.9052775391
* device instance INP_t16 r0 *1 0,0
RINP_t16 INP__t16 INP 51.5488060547
* device instance INP_t17 r0 *1 0,0
RINP_t17 INP__t17 INP 54.1923345703
* device instance INP_t18 r0 *1 0,0
RINP_t18 INP__t18 INP 56.8358630859
* device instance INP_t19 r0 *1 0,0
RINP_t19 INP__t19 INP 59.4793916016
* device instance INP_t20 r0 *1 0,0
RINP_t20 INP__t20 INP 62.1229201172
* device instance INP_t21 r0 *1 0,0
RINP_t21 INP__t21 INP 64.7664486328
* device instance INP_t22 r0 *1 0,0
RINP_t22 INP__t22 INP 67.4099771484
* device instance INP_t23 r0 *1 0,0
RINP_t23 INP__t23 INP 70.0535056641
* device instance INP_t24 r0 *1 0,0
RINP_t24 INP__t24 INP 72.6970341797
* device instance INP_t25 r0 *1 0,0
RINP_t25 INP__t25 INP 3.96529277344
* device instance INP_t26 r0 *1 0,0
RINP_t26 INP__t26 INP 1.32176425781
* device instance INP_t27 r0 *1 0,0
RINP_t27 INP__t27 INP 1.32176425781
* device instance INP_t28 r0 *1 0,0
RINP_t28 INP__t28 INP 3.96529277344
* device instance INP_t29 r0 *1 0,0
RINP_t29 INP__t29 INP 6.60882128906
* device instance INP_t30 r0 *1 0,0
RINP_t30 INP__t30 INP 80.6276197266
* device instance INP_t31 r0 *1 0,0
RINP_t31 INP__t31 INP 77.9840912109
* device instance INP_t32 r0 *1 0,0
RINP_t32 INP__t32 INP 75.3405626953
* device instance INP_t33 r0 *1 0,0
RINP_t33 INP__t33 INP 70.0535056641
* device instance INP_t34 r0 *1 0,0
RINP_t34 INP__t34 INP 67.4099771484
* device instance INP_t35 r0 *1 0,0
RINP_t35 INP__t35 INP 64.7664486328
* device instance INP_t36 r0 *1 0,0
RINP_t36 INP__t36 INP 62.1229201172
* device instance INP_t37 r0 *1 0,0
RINP_t37 INP__t37 INP 59.4793916016
* device instance INP_t38 r0 *1 0,0
RINP_t38 INP__t38 INP 54.1923345703
* device instance INP_t39 r0 *1 0,0
RINP_t39 INP__t39 INP 51.5488060547
* device instance INP_t40 r0 *1 0,0
RINP_t40 INP__t40 INP 48.9052775391
* device instance INP_t41 r0 *1 0,0
RINP_t41 INP__t41 INP 46.2617490234
* device instance INP_t42 r0 *1 0,0
RINP_t42 INP__t42 INP 43.6182205078
* device instance INP_t43 r0 *1 0,0
RINP_t43 INP__t43 INP 40.9746919922
* device instance INP_t44 r0 *1 0,0
RINP_t44 INP__t44 INP 38.3311634766
* device instance INP_t45 r0 *1 0,0
RINP_t45 INP__t45 INP 35.6876349609
* device instance INP_t46 r0 *1 0,0
RINP_t46 INP__t46 INP 33.0441064453
* device instance INP_t47 r0 *1 0,0
RINP_t47 INP__t47 INP 30.4005779297
* device instance INP_t48 r0 *1 0,0
RINP_t48 INP__t48 INP 27.7570494141
* device instance INP_t49 r0 *1 0,0
RINP_t49 INP__t49 INP 25.1135208984
* device instance INP_t50 r0 *1 0,0
RINP_t50 INP__t50 INP 22.4699923828
* device instance INP_t51 r0 *1 0,0
RINP_t51 INP__t51 INP 56.8358630859
* device instance INP_t52 r0 *1 0,0
RINP_t52 INP__t52 INP 77.9840912109
* device instance INP_t53 r0 *1 0,0
RINP_t53 INP__t53 INP 80.6276197266
* device instance INP_t54 r0 *1 0,0
RINP_t54 INP__t54 INP 46.2617490234
* device instance INP_t55 r0 *1 0,0
RINP_t55 INP__t55 INP 43.6182205078
* device instance INP_t56 r0 *1 0,0
RINP_t56 INP__t56 INP 27.7570494141
* device instance INP_t57 r0 *1 0,0
RINP_t57 INP__t57 INP 30.4005779297
* device instance INP_t58 r0 *1 0,0
RINP_t58 INP__t58 INP 33.0441064453
* device instance INP_t59 r0 *1 0,0
RINP_t59 INP__t59 INP 35.6876349609
* device instance INP_t60 r0 *1 0,0
RINP_t60 INP__t60 INP 38.3311634766
* device instance INP_t61 r0 *1 0,0
RINP_t61 INP__t61 INP 75.3405626953
* device instance INP_t62 r0 *1 0,0
RINP_t62 INP__t62 INP 9.25234980469
* device instance INP_t63 r0 *1 0,0
RINP_t63 INP__t63 INP 40.9746919922
* device instance INP r0 *1 0,0
CINP INP vsubs 1.6841892e-14
* device instance OUTN_t0 r0 *1 0,0
ROUTN_t0 OUTN__t0 OUTN 1.0700957882
* device instance OUTN_t1 r0 *1 0,0
ROUTN_t1 OUTN__t1 OUTN 1.80122656404
* device instance OUTN_t2 r0 *1 0,0
ROUTN_t2 OUTN__t2 OUTN 1.85277409724
* device instance OUTN_t3 r0 *1 0,0
ROUTN_t3 OUTN__t3 OUTN 1.90469153304
* device instance OUTN_t4 r0 *1 0,0
ROUTN_t4 OUTN__t4 OUTN 1.95694943134
* device instance OUTN_t5 r0 *1 0,0
ROUTN_t5 OUTN__t5 OUTN 1.10719806408
* device instance OUTN_t6 r0 *1 0,0
ROUTN_t6 OUTN__t6 OUTN 1.14603375626
* device instance OUTN_t7 r0 *1 0,0
ROUTN_t7 OUTN__t7 OUTN 1.18643265636
* device instance OUTN_t8 r0 *1 0,0
ROUTN_t8 OUTN__t8 OUTN 1.22824052443
* device instance OUTN_t9 r0 *1 0,0
ROUTN_t9 OUTN__t9 OUTN 1.27131836447
* device instance OUTN_t10 r0 *1 0,0
ROUTN_t10 OUTN__t10 OUTN 1.31554142544
* device instance OUTN_t11 r0 *1 0,0
ROUTN_t11 OUTN__t11 OUTN 1.36079806012
* device instance OUTN_t12 r0 *1 0,0
ROUTN_t12 OUTN__t12 OUTN 1.4069885355
* device instance OUTN_t13 r0 *1 0,0
ROUTN_t13 OUTN__t13 OUTN 1.45402385738
* device instance OUTN_t14 r0 *1 0,0
ROUTN_t14 OUTN__t14 OUTN 1.50182464916
* device instance OUTN_t15 r0 *1 0,0
ROUTN_t15 OUTN__t15 OUTN 1.55032010759
* device instance OUTN_t16 r0 *1 0,0
ROUTN_t16 OUTN__t16 OUTN 1.59944704677
* device instance OUTN_t17 r0 *1 0,0
ROUTN_t17 OUTN__t17 OUTN 1.6491490336
* device instance OUTN_t18 r0 *1 0,0
ROUTN_t18 OUTN__t18 OUTN 1.75008161947
* device instance OUTN_t19 r0 *1 0,0
ROUTN_t19 OUTN__t19 OUTN 1.69937561322
* device instance OUTN_t20 r0 *1 0,0
ROUTN_t20 OUTN__t20 OUTN 0.283906481151
* device instance OUTN_t21 r0 *1 0,0
ROUTN_t21 OUTN__t21 OUTN 0.360335014458
* device instance OUTN_t22 r0 *1 0,0
ROUTN_t22 OUTN__t22 OUTN 0.339596296711
* device instance OUTN_t23 r0 *1 0,0
ROUTN_t23 OUTN__t23 OUTN 0.320560937214
* device instance OUTN_t24 r0 *1 0,0
ROUTN_t24 OUTN__t24 OUTN 0.382500128341
* device instance OUTN_t25 r0 *1 0,0
ROUTN_t25 OUTN__t25 OUTN 0.405858006389
* device instance OUTN_t26 r0 *1 0,0
ROUTN_t26 OUTN__t26 OUTN 0.43021441416
* device instance OUTN_t27 r0 *1 0,0
ROUTN_t27 OUTN__t27 OUTN 0.455409168315
* device instance OUTN_t28 r0 *1 0,0
ROUTN_t28 OUTN__t28 OUTN 0.481310634259
* device instance OUTN_t29 r0 *1 0,0
ROUTN_t29 OUTN__t29 OUTN 0.303549554154
* device instance OUTN_t30 r0 *1 0,0
ROUTN_t30 OUTN__t30 OUTN 0.278177974449
* device instance OUTN_t31 r0 *1 0,0
ROUTN_t31 OUTN__t31 OUTN 0.26908211953
* device instance OUTN_t32 r0 *1 0,0
ROUTN_t32 OUTN__t32 OUTN 0.261338158544
* device instance OUTN_t33 r0 *1 0,0
ROUTN_t33 OUTN__t33 OUTN 0.262997866132
* device instance OUTN_t34 r0 *1 0,0
ROUTN_t34 OUTN__t34 OUTN 0.26830480745
* device instance OUTN_t35 r0 *1 0,0
ROUTN_t35 OUTN__t35 OUTN 0.277049471113
* device instance OUTN_t36 r0 *1 0,0
ROUTN_t36 OUTN__t36 OUTN 0.288919879585
* device instance OUTN_t37 r0 *1 0,0
ROUTN_t37 OUTN__t37 OUTN 0.26339463978
* device instance OUTN_t38 r0 *1 0,0
ROUTN_t38 OUTN__t38 OUTN 0.675335896289
* device instance OUTN_t39 r0 *1 0,0
ROUTN_t39 OUTN__t39 OUTN 0.704227072712
* device instance OUTN_t40 r0 *1 0,0
ROUTN_t40 OUTN__t40 OUTN 0.733309153561
* device instance OUTN_t41 r0 *1 0,0
ROUTN_t41 OUTN__t41 OUTN 0.590087338652
* device instance OUTN_t42 r0 *1 0,0
ROUTN_t42 OUTN__t42 OUTN 0.534820345237
* device instance OUTN_t43 r0 *1 0,0
ROUTN_t43 OUTN__t43 OUTN 0.562266183086
* device instance OUTN_t44 r0 *1 0,0
ROUTN_t44 OUTN__t44 OUTN 0.762560297344
* device instance OUTN_t45 r0 *1 0,0
ROUTN_t45 OUTN__t45 OUTN 0.79196177124
* device instance OUTN_t46 r0 *1 0,0
ROUTN_t46 OUTN__t46 OUTN 0.82149743442
* device instance OUTN_t47 r0 *1 0,0
ROUTN_t47 OUTN__t47 OUTN 0.646661212169
* device instance OUTN_t48 r0 *1 0,0
ROUTN_t48 OUTN__t48 OUTN 0.618233144909
* device instance OUTN_t49 r0 *1 0,0
ROUTN_t49 OUTN__t49 OUTN 0.880917279296
* device instance OUTN_t50 r0 *1 0,0
ROUTN_t50 OUTN__t50 OUTN 0.85115331759
* device instance OUTN_t51 r0 *1 0,0
ROUTN_t51 OUTN__t51 OUTN 0.507810683571
* device instance OUTN_t52 r0 *1 0,0
ROUTN_t52 OUTN__t52 OUTN 0.910778723682
* device instance OUTN_t53 r0 *1 0,0
ROUTN_t53 OUTN__t53 OUTN 0.371254854458
* device instance OUTN_t54 r0 *1 0,0
ROUTN_t54 OUTN__t54 OUTN 0.349771089768
* device instance OUTN_t55 r0 *1 0,0
ROUTN_t55 OUTN__t55 OUTN 0.394042975209
* device instance OUTN_t56 r0 *1 0,0
ROUTN_t56 OUTN__t56 OUTN 0.329846647928
* device instance OUTN_t57 r0 *1 0,0
ROUTN_t57 OUTN__t57 OUTN 0.311780619496
* device instance OUTN_t58 r0 *1 0,0
ROUTN_t58 OUTN__t58 OUTN 0.295913578379
* device instance OUTN_t59 r0 *1 0,0
ROUTN_t59 OUTN__t59 OUTN 0.41792213784
* device instance OUTN_t60 r0 *1 0,0
ROUTN_t60 OUTN__t60 OUTN 0.442715832012
* device instance OUTN_t61 r0 *1 0,0
ROUTN_t61 OUTN__t61 OUTN 0.468278816694
* device instance OUTN_t62 r0 *1 0,0
ROUTN_t62 OUTN__t62 OUTN 0.494491799776
* device instance OUTN_t63 r0 *1 0,0
ROUTN_t63 OUTN__t63 OUTN 0.806713748785
* device instance OUTN_t64 r0 *1 0,0
ROUTN_t64 OUTN__t64 OUTN 0.273222286436
* device instance OUTN_t65 r0 *1 0,0
ROUTN_t65 OUTN__t65 OUTN 0.265795585373
* device instance OUTN_t66 r0 *1 0,0
ROUTN_t66 OUTN__t66 OUTN 0.261903639215
* device instance OUTN_t67 r0 *1 0,0
ROUTN_t67 OUTN__t67 OUTN 0.261704197323
* device instance OUTN_t68 r0 *1 0,0
ROUTN_t68 OUTN__t68 OUTN 0.265205590422
* device instance OUTN_t69 r0 *1 0,0
ROUTN_t69 OUTN__t69 OUTN 0.272265075098
* device instance OUTN_t70 r0 *1 0,0
ROUTN_t70 OUTN__t70 OUTN 0.282616143696
* device instance OUTN_t71 r0 *1 0,0
ROUTN_t71 OUTN__t71 OUTN 0.660969726702
* device instance OUTN_t72 r0 *1 0,0
ROUTN_t72 OUTN__t72 OUTN 0.689756118439
* device instance OUTN_t73 r0 *1 0,0
ROUTN_t73 OUTN__t73 OUTN 0.718745694849
* device instance OUTN_t74 r0 *1 0,0
ROUTN_t74 OUTN__t74 OUTN 0.548492810078
* device instance OUTN_t75 r0 *1 0,0
ROUTN_t75 OUTN__t75 OUTN 0.576133227202
* device instance OUTN_t76 r0 *1 0,0
ROUTN_t76 OUTN__t76 OUTN 0.777243307235
* device instance OUTN_t77 r0 *1 0,0
ROUTN_t77 OUTN__t77 OUTN 0.604122484184
* device instance OUTN_t78 r0 *1 0,0
ROUTN_t78 OUTN__t78 OUTN 0.632414266079
* device instance OUTN_t79 r0 *1 0,0
ROUTN_t79 OUTN__t79 OUTN 0.521256729031
* device instance OUTN_t80 r0 *1 0,0
ROUTN_t80 OUTN__t80 OUTN 0.747914829667
* device instance OUTN_t81 r0 *1 0,0
ROUTN_t81 OUTN__t81 OUTN 0.89583642468
* device instance OUTN_t82 r0 *1 0,0
ROUTN_t82 OUTN__t82 OUTN 0.866022484147
* device instance OUTN_t83 r0 *1 0,0
ROUTN_t83 OUTN__t83 OUTN 0.836311146612
* device instance OUTN r0 *1 0,0
COUTN OUTN vsubs 3.0452888e-14
* device instance OUTP_t0 r0 *1 0,0
ROUTP_t0 OUTP__t0 OUTP 3.46048372199
* device instance OUTP_t1 r0 *1 0,0
ROUTP_t1 OUTP__t1 OUTP 3.42223165381
* device instance OUTP_t2 r0 *1 0,0
ROUTP_t2 OUTP__t2 OUTP 3.38399665465
* device instance OUTP_t3 r0 *1 0,0
ROUTP_t3 OUTP__t3 OUTP 3.3457793097
* device instance OUTP_t4 r0 *1 0,0
ROUTP_t4 OUTP__t4 OUTP 3.30758023091
* device instance OUTP_t5 r0 *1 0,0
ROUTP_t5 OUTP__t5 OUTP 2.88880292849
* device instance OUTP_t6 r0 *1 0,0
ROUTP_t6 OUTP__t6 OUTP 3.23123946276
* device instance OUTP_t7 r0 *1 0,0
ROUTP_t7 OUTP__t7 OUTP 3.19309914548
* device instance OUTP_t8 r0 *1 0,0
ROUTP_t8 OUTP__t8 OUTP 3.15497984211
* device instance OUTP_t9 r0 *1 0,0
ROUTP_t9 OUTP__t9 OUTP 3.11688232367
* device instance OUTP_t10 r0 *1 0,0
ROUTP_t10 OUTP__t10 OUTP 3.07880739885
* device instance OUTP_t11 r0 *1 0,0
ROUTP_t11 OUTP__t11 OUTP 3.04075591638
* device instance OUTP_t12 r0 *1 0,0
ROUTP_t12 OUTP__t12 OUTP 3.00272876746
* device instance OUTP_t13 r0 *1 0,0
ROUTP_t13 OUTP__t13 OUTP 2.96472688843
* device instance OUTP_t14 r0 *1 0,0
ROUTP_t14 OUTP__t14 OUTP 2.92675126364
* device instance OUTP_t15 r0 *1 0,0
ROUTP_t15 OUTP__t15 OUTP 3.26940005853
* device instance OUTP_t16 r0 *1 0,0
ROUTP_t16 OUTP__t16 OUTP 3.6136518403
* device instance OUTP_t17 r0 *1 0,0
ROUTP_t17 OUTP__t17 OUTP 3.57533686084
* device instance OUTP_t18 r0 *1 0,0
ROUTP_t18 OUTP__t18 OUTP 3.53703684999
* device instance OUTP_t19 r0 *1 0,0
ROUTP_t19 OUTP__t19 OUTP 3.49875229933
* device instance OUTP_t20 r0 *1 0,0
ROUTP_t20 OUTP__t20 OUTP 1.04142326645
* device instance OUTP_t21 r0 *1 0,0
ROUTP_t21 OUTP__t21 OUTP 1.08259682682
* device instance OUTP_t22 r0 *1 0,0
ROUTP_t22 OUTP__t22 OUTP 1.06200195851
* device instance OUTP_t23 r0 *1 0,0
ROUTP_t23 OUTP__t23 OUTP 0.938809652806
* device instance OUTP_t24 r0 *1 0,0
ROUTP_t24 OUTP__t24 OUTP 0.918351654804
* device instance OUTP_t25 r0 *1 0,0
ROUTP_t25 OUTP__t25 OUTP 0.959291069555
* device instance OUTP_t26 r0 *1 0,0
ROUTP_t26 OUTP__t26 OUTP 0.816474490966
* device instance OUTP_t27 r0 *1 0,0
ROUTP_t27 OUTP__t27 OUTP 0.796196414036
* device instance OUTP_t28 r0 *1 0,0
ROUTP_t28 OUTP__t28 OUTP 0.775956735042
* device instance OUTP_t29 r0 *1 0,0
ROUTP_t29 OUTP__t29 OUTP 0.755758538951
* device instance OUTP_t30 r0 *1 0,0
ROUTP_t30 OUTP__t30 OUTP 0.735605242875
* device instance OUTP_t31 r0 *1 0,0
ROUTP_t31 OUTP__t31 OUTP 1.02086172891
* device instance OUTP_t32 r0 *1 0,0
ROUTP_t32 OUTP__t32 OUTP 1.00031840371
* device instance OUTP_t33 r0 *1 0,0
ROUTP_t33 OUTP__t33 OUTP 1.33072304921
* device instance OUTP_t34 r0 *1 0,0
ROUTP_t34 OUTP__t34 OUTP 1.34109298046
* device instance OUTP_t35 r0 *1 0,0
ROUTP_t35 OUTP__t35 OUTP 1.30998940028
* device instance OUTP_t36 r0 *1 0,0
ROUTP_t36 OUTP__t36 OUTP 1.28926436916
* device instance OUTP_t37 r0 *1 0,0
ROUTP_t37 OUTP__t37 OUTP 1.26854837824
* device instance OUTP_t38 r0 *1 0,0
ROUTP_t38 OUTP__t38 OUTP 1.24784187776
* device instance OUTP_t39 r0 *1 0,0
ROUTP_t39 OUTP__t39 OUTP 1.22714534814
* device instance OUTP_t40 r0 *1 0,0
ROUTP_t40 OUTP__t40 OUTP 1.20645930252
* device instance OUTP_t41 r0 *1 0,0
ROUTP_t41 OUTP__t41 OUTP 1.18578428958
* device instance OUTP_t42 r0 *1 0,0
ROUTP_t42 OUTP__t42 OUTP 1.16512089665
* device instance OUTP_t43 r0 *1 0,0
ROUTP_t43 OUTP__t43 OUTP 1.14446975312
* device instance OUTP_t44 r0 *1 0,0
ROUTP_t44 OUTP__t44 OUTP 1.12383153427
* device instance OUTP_t45 r0 *1 0,0
ROUTP_t45 OUTP__t45 OUTP 1.10320696545
* device instance OUTP_t46 r0 *1 0,0
ROUTP_t46 OUTP__t46 OUTP 0.715500640881
* device instance OUTP_t47 r0 *1 0,0
ROUTP_t47 OUTP__t47 OUTP 0.836788174319
* device instance OUTP_t48 r0 *1 0,0
ROUTP_t48 OUTP__t48 OUTP 0.897918676256
* device instance OUTP_t49 r0 *1 0,0
ROUTP_t49 OUTP__t49 OUTP 0.877512464906
* device instance OUTP_t50 r0 *1 0,0
ROUTP_t50 OUTP__t50 OUTP 0.979794436432
* device instance OUTP_t51 r0 *1 0,0
ROUTP_t51 OUTP__t51 OUTP 0.857134932533
* device instance OUTP_t52 r0 *1 0,0
ROUTP_t52 OUTP__t52 OUTP 0.705467901525
* device instance OUTP_t53 r0 *1 0,0
ROUTP_t53 OUTP__t53 OUTP 0.695448956045
* device instance OUTP_t54 r0 *1 0,0
ROUTP_t54 OUTP__t54 OUTP 1.05171053108
* device instance OUTP_t55 r0 *1 0,0
ROUTP_t55 OUTP__t55 OUTP 1.07229742887
* device instance OUTP_t56 r0 *1 0,0
ROUTP_t56 OUTP__t56 OUTP 1.09290004133
* device instance OUTP_t57 r0 *1 0,0
ROUTP_t57 OUTP__t57 OUTP 0.928577629679
* device instance OUTP_t58 r0 *1 0,0
ROUTP_t58 OUTP__t58 OUTP 1.29962578172
* device instance OUTP_t59 r0 *1 0,0
ROUTP_t59 OUTP__t59 OUTP 0.949047528559
* device instance OUTP_t60 r0 *1 0,0
ROUTP_t60 OUTP__t60 OUTP 0.826627045794
* device instance OUTP_t61 r0 *1 0,0
ROUTP_t61 OUTP__t61 OUTP 0.80633083369
* device instance OUTP_t62 r0 *1 0,0
ROUTP_t62 OUTP__t62 OUTP 0.78607158929
* device instance OUTP_t63 r0 *1 0,0
ROUTP_t63 OUTP__t63 OUTP 0.765852246341
* device instance OUTP_t64 r0 *1 0,0
ROUTP_t64 OUTP__t64 OUTP 0.745676050689
* device instance OUTP_t65 r0 *1 0,0
ROUTP_t65 OUTP__t65 OUTP 1.03114028921
* device instance OUTP_t66 r0 *1 0,0
ROUTP_t66 OUTP__t66 OUTP 1.01058772033
* device instance OUTP_t67 r0 *1 0,0
ROUTP_t67 OUTP__t67 OUTP 0.990053925063
* device instance OUTP_t68 r0 *1 0,0
ROUTP_t68 OUTP__t68 OUTP 1.32035517289
* device instance OUTP_t69 r0 *1 0,0
ROUTP_t69 OUTP__t69 OUTP 1.27890521621
* device instance OUTP_t70 r0 *1 0,0
ROUTP_t70 OUTP__t70 OUTP 1.25819391241
* device instance OUTP_t71 r0 *1 0,0
ROUTP_t71 OUTP__t71 OUTP 1.21680098141
* device instance OUTP_t72 r0 *1 0,0
ROUTP_t72 OUTP__t72 OUTP 1.1961203812
* device instance OUTP_t73 r0 *1 0,0
ROUTP_t73 OUTP__t73 OUTP 1.17545110231
* device instance OUTP_t74 r0 *1 0,0
ROUTP_t74 OUTP__t74 OUTP 1.15479375263
* device instance OUTP_t75 r0 *1 0,0
ROUTP_t75 OUTP__t75 OUTP 1.134148984
* device instance OUTP_t76 r0 *1 0,0
ROUTP_t76 OUTP__t76 OUTP 1.11351749619
* device instance OUTP_t77 r0 *1 0,0
ROUTP_t77 OUTP__t77 OUTP 1.23749233532
* device instance OUTP_t78 r0 *1 0,0
ROUTP_t78 OUTP__t78 OUTP 0.846957567959
* device instance OUTP_t79 r0 *1 0,0
ROUTP_t79 OUTP__t79 OUTP 0.908131932499
* device instance OUTP_t80 r0 *1 0,0
ROUTP_t80 OUTP__t80 OUTP 0.887712109254
* device instance OUTP_t81 r0 *1 0,0
ROUTP_t81 OUTP__t81 OUTP 0.867319987442
* device instance OUTP_t82 r0 *1 0,0
ROUTP_t82 OUTP__t82 OUTP 0.725546601896
* device instance OUTP_t83 r0 *1 0,0
ROUTP_t83 OUTP__t83 OUTP 0.969540096228
* device instance OUTP r0 *1 0,0
COUTP OUTP vsubs 4.8733229e-14
* device instance TAIL_t0 r0 *1 0,0
RTAIL_t0 TAIL__t0 TAIL 0.362648639416
* device instance TAIL_t1 r0 *1 0,0
RTAIL_t1 TAIL__t1 TAIL 0.675850575829
* device instance TAIL_t2 r0 *1 0,0
RTAIL_t2 TAIL__t2 TAIL 0.677885185394
* device instance TAIL_t3 r0 *1 0,0
RTAIL_t3 TAIL__t3 TAIL 0.366426472022
* device instance TAIL_t4 r0 *1 0,0
RTAIL_t4 TAIL__t4 TAIL 0.558990071548
* device instance TAIL_t5 r0 *1 0,0
RTAIL_t5 TAIL__t5 TAIL 0.568890610941
* device instance TAIL_t6 r0 *1 0,0
RTAIL_t6 TAIL__t6 TAIL 0.549091190119
* device instance TAIL_t7 r0 *1 0,0
RTAIL_t7 TAIL__t7 TAIL 0.578792723218
* device instance TAIL_t8 r0 *1 0,0
RTAIL_t8 TAIL__t8 TAIL 0.588696329009
* device instance TAIL_t9 r0 *1 0,0
RTAIL_t9 TAIL__t9 TAIL 0.598601354185
* device instance TAIL_t10 r0 *1 0,0
RTAIL_t10 TAIL__t10 TAIL 0.539194057969
* device instance TAIL_t11 r0 *1 0,0
RTAIL_t11 TAIL__t11 TAIL 0.529298773224
* device instance TAIL_t12 r0 *1 0,0
RTAIL_t12 TAIL__t12 TAIL 0.519405441472
* device instance TAIL_t13 r0 *1 0,0
RTAIL_t13 TAIL__t13 TAIL 0.509514176475
* device instance TAIL_t14 r0 *1 0,0
RTAIL_t14 TAIL__t14 TAIL 0.536633868126
* device instance TAIL_t15 r0 *1 0,0
RTAIL_t15 TAIL__t15 TAIL 0.400890399446
* device instance TAIL_t16 r0 *1 0,0
RTAIL_t16 TAIL__t16 TAIL 0.546577360799
* device instance TAIL_t17 r0 *1 0,0
RTAIL_t17 TAIL__t17 TAIL 0.667970968149
* device instance TAIL_t18 r0 *1 0,0
RTAIL_t18 TAIL__t18 TAIL 0.658057722475
* device instance TAIL_t19 r0 *1 0,0
RTAIL_t19 TAIL__t19 TAIL 0.556520957701
* device instance TAIL_t20 r0 *1 0,0
RTAIL_t20 TAIL__t20 TAIL 0.648145492951
* device instance TAIL_t21 r0 *1 0,0
RTAIL_t21 TAIL__t21 TAIL 0.638234326922
* device instance TAIL_t22 r0 *1 0,0
RTAIL_t22 TAIL__t22 TAIL 0.628324274715
* device instance TAIL_t23 r0 *1 0,0
RTAIL_t23 TAIL__t23 TAIL 0.618415389877
* device instance TAIL_t24 r0 *1 0,0
RTAIL_t24 TAIL__t24 TAIL 0.608507729435
* device instance TAIL_t25 r0 *1 0,0
RTAIL_t25 TAIL__t25 TAIL 0.450217614753
* device instance TAIL_t26 r0 *1 0,0
RTAIL_t26 TAIL__t26 TAIL 0.440344886163
* device instance TAIL_t27 r0 *1 0,0
RTAIL_t27 TAIL__t27 TAIL 0.430475549842
* device instance TAIL_t28 r0 *1 0,0
RTAIL_t28 TAIL__t28 TAIL 0.489738347633
* device instance TAIL_t29 r0 *1 0,0
RTAIL_t29 TAIL__t29 TAIL 0.479854059957
* device instance TAIL_t30 r0 *1 0,0
RTAIL_t30 TAIL__t30 TAIL 0.476975465961
* device instance TAIL_t31 r0 *1 0,0
RTAIL_t31 TAIL__t31 TAIL 0.655961616545
* device instance TAIL_t32 r0 *1 0,0
RTAIL_t32 TAIL__t32 TAIL 0.486918191706
* device instance TAIL_t33 r0 *1 0,0
RTAIL_t33 TAIL__t33 TAIL 0.427264409099
* device instance TAIL_t34 r0 *1 0,0
RTAIL_t34 TAIL__t34 TAIL 0.410748032023
* device instance TAIL_t35 r0 *1 0,0
RTAIL_t35 TAIL__t35 TAIL 0.417322797879
* device instance TAIL_t36 r0 *1 0,0
RTAIL_t36 TAIL__t36 TAIL 0.407381420885
* device instance TAIL_t37 r0 *1 0,0
RTAIL_t37 TAIL__t37 TAIL 0.397440295692
* device instance TAIL_t38 r0 *1 0,0
RTAIL_t38 TAIL__t38 TAIL 0.38749944168
* device instance TAIL_t39 r0 *1 0,0
RTAIL_t39 TAIL__t39 TAIL 0.469972393527
* device instance TAIL_t40 r0 *1 0,0
RTAIL_t40 TAIL__t40 TAIL 0.526690485587
* device instance TAIL_t41 r0 *1 0,0
RTAIL_t41 TAIL__t41 TAIL 0.51674721954
* device instance TAIL_t42 r0 *1 0,0
RTAIL_t42 TAIL__t42 TAIL 0.506804076839
* device instance TAIL_t43 r0 *1 0,0
RTAIL_t43 TAIL__t43 TAIL 0.665906067371
* device instance TAIL_t44 r0 *1 0,0
RTAIL_t44 TAIL__t44 TAIL 0.646017226012
* device instance TAIL_t45 r0 *1 0,0
RTAIL_t45 TAIL__t45 TAIL 0.6360728986
* device instance TAIL_t46 r0 *1 0,0
RTAIL_t46 TAIL__t46 TAIL 0.616184445363
* device instance TAIL_t47 r0 *1 0,0
RTAIL_t47 TAIL__t47 TAIL 0.606240326152
* device instance TAIL_t48 r0 *1 0,0
RTAIL_t48 TAIL__t48 TAIL 0.596296283322
* device instance TAIL_t49 r0 *1 0,0
RTAIL_t49 TAIL__t49 TAIL 0.586352320759
* device instance TAIL_t50 r0 *1 0,0
RTAIL_t50 TAIL__t50 TAIL 0.576408442618
* device instance TAIL_t51 r0 *1 0,0
RTAIL_t51 TAIL__t51 TAIL 0.566464653344
* device instance TAIL_t52 r0 *1 0,0
RTAIL_t52 TAIL__t52 TAIL 0.460093517237
* device instance TAIL_t53 r0 *1 0,0
RTAIL_t53 TAIL__t53 TAIL 0.626128637317
* device instance TAIL_t54 r0 *1 0,0
RTAIL_t54 TAIL__t54 TAIL 0.437206238566
* device instance TAIL_t55 r0 *1 0,0
RTAIL_t55 TAIL__t55 TAIL 0.467032897074
* device instance TAIL_t56 r0 *1 0,0
RTAIL_t56 TAIL__t56 TAIL 0.457090495279
* device instance TAIL_t57 r0 *1 0,0
RTAIL_t57 TAIL__t57 TAIL 0.447148271723
* device instance TAIL_t58 r0 *1 0,0
RTAIL_t58 TAIL__t58 TAIL 0.37755888027
* device instance TAIL_t59 r0 *1 0,0
RTAIL_t59 TAIL__t59 TAIL 0.499625100984
* device instance TAIL_t60 r0 *1 0,0
RTAIL_t60 TAIL__t60 TAIL 0.496861064891
* device instance TAIL_t61 r0 *1 0,0
RTAIL_t61 TAIL__t61 TAIL 0.420609844581
* device instance TAIL_t62 r0 *1 0,0
RTAIL_t62 TAIL__t62 TAIL 0.371345909729
* device instance TAIL_t63 r0 *1 0,0
RTAIL_t63 TAIL__t63 TAIL 0.381188971245
* device instance TAIL_t64 r0 *1 0,0
RTAIL_t64 TAIL__t64 TAIL 0.39103726297
* device instance TAIL_t65 r0 *1 0,0
RTAIL_t65 TAIL__t65 TAIL 0.563940139456
* device instance TAIL_t66 r0 *1 0,0
RTAIL_t66 TAIL__t66 TAIL 0.573841475558
* device instance TAIL_t67 r0 *1 0,0
RTAIL_t67 TAIL__t67 TAIL 0.583744344175
* device instance TAIL_t68 r0 *1 0,0
RTAIL_t68 TAIL__t68 TAIL 0.554040418033
* device instance TAIL_t69 r0 *1 0,0
RTAIL_t69 TAIL__t69 TAIL 0.544142399418
* device instance TAIL_t70 r0 *1 0,0
RTAIL_t70 TAIL__t70 TAIL 0.534246178255
* device instance TAIL_t71 r0 *1 0,0
RTAIL_t71 TAIL__t71 TAIL 0.524351856315
* device instance TAIL_t72 r0 *1 0,0
RTAIL_t72 TAIL__t72 TAIL 0.514459543178
* device instance TAIL_t73 r0 *1 0,0
RTAIL_t73 TAIL__t73 TAIL 0.593648668614
* device instance TAIL_t74 r0 *1 0,0
RTAIL_t74 TAIL__t74 TAIL 0.531662162704
* device instance TAIL_t75 r0 *1 0,0
RTAIL_t75 TAIL__t75 TAIL 0.551549146573
* device instance TAIL_t76 r0 *1 0,0
RTAIL_t76 TAIL__t76 TAIL 0.541605601075
* device instance TAIL_t77 r0 *1 0,0
RTAIL_t77 TAIL__t77 TAIL 0.672927958009
* device instance TAIL_t78 r0 *1 0,0
RTAIL_t78 TAIL__t78 TAIL 0.663014221142
* device instance TAIL_t79 r0 *1 0,0
RTAIL_t79 TAIL__t79 TAIL 0.643189773927
* device instance TAIL_t80 r0 *1 0,0
RTAIL_t80 TAIL__t80 TAIL 0.633279158323
* device instance TAIL_t81 r0 *1 0,0
RTAIL_t81 TAIL__t81 TAIL 0.623369682896
* device instance TAIL_t82 r0 *1 0,0
RTAIL_t82 TAIL__t82 TAIL 0.613461402898
* device instance TAIL_t83 r0 *1 0,0
RTAIL_t83 TAIL__t83 TAIL 0.603554377206
* device instance TAIL_t84 r0 *1 0,0
RTAIL_t84 TAIL__t84 TAIL 0.653101477802
* device instance TAIL_t85 r0 *1 0,0
RTAIL_t85 TAIL__t85 TAIL 0.445280840525
* device instance TAIL_t86 r0 *1 0,0
RTAIL_t86 TAIL__t86 TAIL 0.43540977955
* device instance TAIL_t87 r0 *1 0,0
RTAIL_t87 TAIL__t87 TAIL 0.425542227542
* device instance TAIL_t88 r0 *1 0,0
RTAIL_t88 TAIL__t88 TAIL 0.481946809833
* device instance TAIL_t89 r0 *1 0,0
RTAIL_t89 TAIL__t89 TAIL 0.474912888859
* device instance TAIL_t90 r0 *1 0,0
RTAIL_t90 TAIL__t90 TAIL 0.494681425338
* device instance TAIL_t91 r0 *1 0,0
RTAIL_t91 TAIL__t91 TAIL 0.484795886159
* device instance TAIL_t92 r0 *1 0,0
RTAIL_t92 TAIL__t92 TAIL 0.472004161291
* device instance TAIL_t93 r0 *1 0,0
RTAIL_t93 TAIL__t93 TAIL 0.491889610427
* device instance TAIL_t94 r0 *1 0,0
RTAIL_t94 TAIL__t94 TAIL 0.422293575245
* device instance TAIL_t95 r0 *1 0,0
RTAIL_t95 TAIL__t95 TAIL 0.412352079045
* device instance TAIL_t96 r0 *1 0,0
RTAIL_t96 TAIL__t96 TAIL 0.402410825646
* device instance TAIL_t97 r0 *1 0,0
RTAIL_t97 TAIL__t97 TAIL 0.3924698335
* device instance TAIL_t98 r0 *1 0,0
RTAIL_t98 TAIL__t98 TAIL 0.382529122974
* device instance TAIL_t99 r0 *1 0,0
RTAIL_t99 TAIL__t99 TAIL 0.415678434395
* device instance TAIL_t100 r0 *1 0,0
RTAIL_t100 TAIL__t100 TAIL 0.405818674196
* device instance TAIL_t101 r0 *1 0,0
RTAIL_t101 TAIL__t101 TAIL 0.521718837586
* device instance TAIL_t102 r0 *1 0,0
RTAIL_t102 TAIL__t102 TAIL 0.511775632321
* device instance TAIL_t103 r0 *1 0,0
RTAIL_t103 TAIL__t103 TAIL 0.670878314556
* device instance TAIL_t104 r0 *1 0,0
RTAIL_t104 TAIL__t104 TAIL 0.660933834591
* device instance TAIL_t105 r0 *1 0,0
RTAIL_t105 TAIL__t105 TAIL 0.395963248214
* device instance TAIL_t106 r0 *1 0,0
RTAIL_t106 TAIL__t106 TAIL 0.650989413569
* device instance TAIL_t107 r0 *1 0,0
RTAIL_t107 TAIL__t107 TAIL 0.641045054232
* device instance TAIL_t108 r0 *1 0,0
RTAIL_t108 TAIL__t108 TAIL 0.631100759497
* device instance TAIL_t109 r0 *1 0,0
RTAIL_t109 TAIL__t109 TAIL 0.455155182169
* device instance TAIL_t110 r0 *1 0,0
RTAIL_t110 TAIL__t110 TAIL 0.621156532466
* device instance TAIL_t111 r0 *1 0,0
RTAIL_t111 TAIL__t111 TAIL 0.611212376443
* device instance TAIL_t112 r0 *1 0,0
RTAIL_t112 TAIL__t112 TAIL 0.601268294953
* device instance TAIL_t113 r0 *1 0,0
RTAIL_t113 TAIL__t113 TAIL 0.591324291754
* device instance TAIL_t114 r0 *1 0,0
RTAIL_t114 TAIL__t114 TAIL 0.581380370865
* device instance TAIL_t115 r0 *1 0,0
RTAIL_t115 TAIL__t115 TAIL 0.571436536583
* device instance TAIL_t116 r0 *1 0,0
RTAIL_t116 TAIL__t116 TAIL 0.561492793508
* device instance TAIL_t117 r0 *1 0,0
RTAIL_t117 TAIL__t117 TAIL 0.4650325955
* device instance TAIL_t118 r0 *1 0,0
RTAIL_t118 TAIL__t118 TAIL 0.372588716609
* device instance TAIL_t119 r0 *1 0,0
RTAIL_t119 TAIL__t119 TAIL 0.367618635197
* device instance TAIL_t120 r0 *1 0,0
RTAIL_t120 TAIL__t120 TAIL 0.432235297493
* device instance TAIL_t121 r0 *1 0,0
RTAIL_t121 TAIL__t121 TAIL 0.462061674616
* device instance TAIL_t122 r0 *1 0,0
RTAIL_t122 TAIL__t122 TAIL 0.452119360487
* device instance TAIL_t123 r0 *1 0,0
RTAIL_t123 TAIL__t123 TAIL 0.501832554035
* device instance TAIL_t124 r0 *1 0,0
RTAIL_t124 TAIL__t124 TAIL 0.376266761052
* device instance TAIL_t125 r0 *1 0,0
RTAIL_t125 TAIL__t125 TAIL 0.38611248834
* device instance TAIL_t126 r0 *1 0,0
RTAIL_t126 TAIL__t126 TAIL 0.442177230542
* device instance TAIL_t127 r0 *1 0,0
RTAIL_t127 TAIL__t127 TAIL 0.504569356995
* device instance TAIL_t128 r0 *1 0,0
RTAIL_t128 TAIL__t128 TAIL 0.133494373509
* device instance TAIL_t129 r0 *1 0,0
RTAIL_t129 TAIL__t129 TAIL 0.146509195074
* device instance TAIL_t130 r0 *1 0,0
RTAIL_t130 TAIL__t130 TAIL 0.0559720948713
* device instance TAIL_t131 r0 *1 0,0
RTAIL_t131 TAIL__t131 TAIL 0.0903394285708
* device instance TAIL_t132 r0 *1 0,0
RTAIL_t132 TAIL__t132 TAIL 0.129266714658
* device instance TAIL_t133 r0 *1 0,0
RTAIL_t133 TAIL__t133 TAIL 0.116269299309
* device instance TAIL_t134 r0 *1 0,0
RTAIL_t134 TAIL__t134 TAIL 0.103290817148
* device instance TAIL_t135 r0 *1 0,0
RTAIL_t135 TAIL__t135 TAIL 0.0774287304802
* device instance TAIL_t136 r0 *1 0,0
RTAIL_t136 TAIL__t136 TAIL 0.142277874517
* device instance TAIL_t137 r0 *1 0,0
RTAIL_t137 TAIL__t137 TAIL 0.0433718161415
* device instance TAIL_t138 r0 *1 0,0
RTAIL_t138 TAIL__t138 TAIL 0.0311629582759
* device instance TAIL_t139 r0 *1 0,0
RTAIL_t139 TAIL__t139 TAIL 0.0200729171662
* device instance TAIL_t140 r0 *1 0,0
RTAIL_t140 TAIL__t140 TAIL 0.0132849742405
* device instance TAIL_t141 r0 *1 0,0
RTAIL_t141 TAIL__t141 TAIL 0.120492023711
* device instance TAIL_t142 r0 *1 0,0
RTAIL_t142 TAIL__t142 TAIL 0.0170831958234
* device instance TAIL_t143 r0 *1 0,0
RTAIL_t143 TAIL__t143 TAIL 0.0273670809636
* device instance TAIL_t144 r0 *1 0,0
RTAIL_t144 TAIL__t144 TAIL 0.0393427904877
* device instance TAIL_t145 r0 *1 0,0
RTAIL_t145 TAIL__t145 TAIL 0.05185103382
* device instance TAIL_t146 r0 *1 0,0
RTAIL_t146 TAIL__t146 TAIL 0.0645831305761
* device instance TAIL_t147 r0 *1 0,0
RTAIL_t147 TAIL__t147 TAIL 0.298829184372
* device instance TAIL_t148 r0 *1 0,0
RTAIL_t148 TAIL__t148 TAIL 0.311889541371
* device instance TAIL_t149 r0 *1 0,0
RTAIL_t149 TAIL__t149 TAIL 0.318420091226
* device instance TAIL_t150 r0 *1 0,0
RTAIL_t150 TAIL__t150 TAIL 0.15529932433
* device instance TAIL_t151 r0 *1 0,0
RTAIL_t151 TAIL__t151 TAIL 0.168328676107
* device instance TAIL_t152 r0 *1 0,0
RTAIL_t152 TAIL__t152 TAIL 0.181364226804
* device instance TAIL_t153 r0 *1 0,0
RTAIL_t153 TAIL__t153 TAIL 0.194404729445
* device instance TAIL_t154 r0 *1 0,0
RTAIL_t154 TAIL__t154 TAIL 0.207449250177
* device instance TAIL_t155 r0 *1 0,0
RTAIL_t155 TAIL__t155 TAIL 0.220497075875
* device instance TAIL_t156 r0 *1 0,0
RTAIL_t156 TAIL__t156 TAIL 0.233547652614
* device instance TAIL_t157 r0 *1 0,0
RTAIL_t157 TAIL__t157 TAIL 0.246600543625
* device instance TAIL_t158 r0 *1 0,0
RTAIL_t158 TAIL__t158 TAIL 0.107506670953
* device instance TAIL_t159 r0 *1 0,0
RTAIL_t159 TAIL__t159 TAIL 0.0945453188827
* device instance TAIL_t160 r0 *1 0,0
RTAIL_t160 TAIL__t160 TAIL 0.0816194023985
* device instance TAIL_t161 r0 *1 0,0
RTAIL_t161 TAIL__t161 TAIL 0.0687489118103
* device instance TAIL_t162 r0 *1 0,0
RTAIL_t162 TAIL__t162 TAIL 0.172564963745
* device instance TAIL_t163 r0 *1 0,0
RTAIL_t163 TAIL__t163 TAIL 0.159533436074
* device instance TAIL_t164 r0 *1 0,0
RTAIL_t164 TAIL__t164 TAIL 0.198644142101
* device instance TAIL_t165 r0 *1 0,0
RTAIL_t165 TAIL__t165 TAIL 0.272711939178
* device instance TAIL_t166 r0 *1 0,0
RTAIL_t166 TAIL__t166 TAIL 0.285769930802
* device instance TAIL_t167 r0 *1 0,0
RTAIL_t167 TAIL__t167 TAIL 0.185602243253
* device instance TAIL_t168 r0 *1 0,0
RTAIL_t168 TAIL__t168 TAIL 0.368385788603
* device instance TAIL_t169 r0 *1 0,0
RTAIL_t169 TAIL__t169 TAIL 0.38145021007
* device instance TAIL_t170 r0 *1 0,0
RTAIL_t170 TAIL__t170 TAIL 0.394515161663
* device instance TAIL_t171 r0 *1 0,0
RTAIL_t171 TAIL__t171 TAIL 0.407580592404
* device instance TAIL_t172 r0 *1 0,0
RTAIL_t172 TAIL__t172 TAIL 0.420646457643
* device instance TAIL_t173 r0 *1 0,0
RTAIL_t173 TAIL__t173 TAIL 0.433712718113
* device instance TAIL_t174 r0 *1 0,0
RTAIL_t174 TAIL__t174 TAIL 0.446779339138
* device instance TAIL_t175 r0 *1 0,0
RTAIL_t175 TAIL__t175 TAIL 0.211689806518
* device instance TAIL_t176 r0 *1 0,0
RTAIL_t176 TAIL__t176 TAIL 0.459846289982
* device instance TAIL_t177 r0 *1 0,0
RTAIL_t177 TAIL__t177 TAIL 0.472913543306
* device instance TAIL_t178 r0 *1 0,0
RTAIL_t178 TAIL__t178 TAIL 0.485981074709
* device instance TAIL_t179 r0 *1 0,0
RTAIL_t179 TAIL__t179 TAIL 0.499048862348
* device instance TAIL_t180 r0 *1 0,0
RTAIL_t180 TAIL__t180 TAIL 0.747367634472
* device instance TAIL_t181 r0 *1 0,0
RTAIL_t181 TAIL__t181 TAIL 0.760438079748
* device instance TAIL_t182 r0 *1 0,0
RTAIL_t182 TAIL__t182 TAIL 0.773508591877
* device instance TAIL_t183 r0 *1 0,0
RTAIL_t183 TAIL__t183 TAIL 0.786579167527
* device instance TAIL_t184 r0 *1 0,0
RTAIL_t184 TAIL__t184 TAIL 0.551322210846
* device instance TAIL_t185 r0 *1 0,0
RTAIL_t185 TAIL__t185 TAIL 0.564391021117
* device instance TAIL_t186 r0 *1 0,0
RTAIL_t186 TAIL__t186 TAIL 0.329196336102
* device instance TAIL_t187 r0 *1 0,0
RTAIL_t187 TAIL__t187 TAIL 0.224738580751
* device instance TAIL_t188 r0 *1 0,0
RTAIL_t188 TAIL__t188 TAIL 0.237789952845
* device instance TAIL_t189 r0 *1 0,0
RTAIL_t189 TAIL__t189 TAIL 0.250843517302
* device instance TAIL_t190 r0 *1 0,0
RTAIL_t190 TAIL__t190 TAIL 0.26389894879
* device instance TAIL_t191 r0 *1 0,0
RTAIL_t191 TAIL__t191 TAIL 0.27695598328
* device instance TAIL_t192 r0 *1 0,0
RTAIL_t192 TAIL__t192 TAIL 0.290014404261
* device instance TAIL_t193 r0 *1 0,0
RTAIL_t193 TAIL__t193 TAIL 0.303074032515
* device instance TAIL_t194 r0 *1 0,0
RTAIL_t194 TAIL__t194 TAIL 0.512116886607
* device instance TAIL_t195 r0 *1 0,0
RTAIL_t195 TAIL__t195 TAIL 0.525185129824
* device instance TAIL_t196 r0 *1 0,0
RTAIL_t196 TAIL__t196 TAIL 0.538253576049
* device instance TAIL_t197 r0 *1 0,0
RTAIL_t197 TAIL__t197 TAIL 0.316134718424
* device instance TAIL_t198 r0 *1 0,0
RTAIL_t198 TAIL__t198 TAIL 0.342258778872
* device instance TAIL_t199 r0 *1 0,0
RTAIL_t199 TAIL__t199 TAIL 0.355321955737
* device instance TAIL_t200 r0 *1 0,0
RTAIL_t200 TAIL__t200 TAIL 0.668946586171
* device instance TAIL_t201 r0 *1 0,0
RTAIL_t201 TAIL__t201 TAIL 0.68201654541
* device instance TAIL_t202 r0 *1 0,0
RTAIL_t202 TAIL__t202 TAIL 0.695086597323
* device instance TAIL_t203 r0 *1 0,0
RTAIL_t203 TAIL__t203 TAIL 0.708156736779
* device instance TAIL_t204 r0 *1 0,0
RTAIL_t204 TAIL__t204 TAIL 0.721226959017
* device instance TAIL_t205 r0 *1 0,0
RTAIL_t205 TAIL__t205 TAIL 0.734297259619
* device instance TAIL_t206 r0 *1 0,0
RTAIL_t206 TAIL__t206 TAIL 0.799649803581
* device instance TAIL_t207 r0 *1 0,0
RTAIL_t207 TAIL__t207 TAIL 0.943430068888
* device instance TAIL_t208 r0 *1 0,0
RTAIL_t208 TAIL__t208 TAIL 0.956501246463
* device instance TAIL_t209 r0 *1 0,0
RTAIL_t209 TAIL__t209 TAIL 0.969572457629
* device instance TAIL_t210 r0 *1 0,0
RTAIL_t210 TAIL__t210 TAIL 0.930358926318
* device instance TAIL_t211 r0 *1 0,0
RTAIL_t211 TAIL__t211 TAIL 0.25965539989
* device instance TAIL_t212 r0 *1 0,0
RTAIL_t212 TAIL__t212 TAIL 0.812720497127
* device instance TAIL_t213 r0 *1 0,0
RTAIL_t213 TAIL__t213 TAIL 0.825791245433
* device instance TAIL_t214 r0 *1 0,0
RTAIL_t214 TAIL__t214 TAIL 0.838862045941
* device instance TAIL_t215 r0 *1 0,0
RTAIL_t215 TAIL__t215 TAIL 0.851932896248
* device instance TAIL_t216 r0 *1 0,0
RTAIL_t216 TAIL__t216 TAIL 0.865003794095
* device instance TAIL_t217 r0 *1 0,0
RTAIL_t217 TAIL__t217 TAIL 0.878074737361
* device instance TAIL_t218 r0 *1 0,0
RTAIL_t218 TAIL__t218 TAIL 0.891145724046
* device instance TAIL_t219 r0 *1 0,0
RTAIL_t219 TAIL__t219 TAIL 0.917287820251
* device instance TAIL_t220 r0 *1 0,0
RTAIL_t220 TAIL__t220 TAIL 0.577459994948
* device instance TAIL_t221 r0 *1 0,0
RTAIL_t221 TAIL__t221 TAIL 0.590529121478
* device instance TAIL_t222 r0 *1 0,0
RTAIL_t222 TAIL__t222 TAIL 0.603598390791
* device instance TAIL_t223 r0 *1 0,0
RTAIL_t223 TAIL__t223 TAIL 0.616667793807
* device instance TAIL_t224 r0 *1 0,0
RTAIL_t224 TAIL__t224 TAIL 0.629737322201
* device instance TAIL_t225 r0 *1 0,0
RTAIL_t225 TAIL__t225 TAIL 0.642806968328
* device instance TAIL_t226 r0 *1 0,0
RTAIL_t226 TAIL__t226 TAIL 0.655876725147
* device instance TAIL_t227 r0 *1 0,0
RTAIL_t227 TAIL__t227 TAIL 0.904216752268
* device instance TAIL_t228 r0 *1 0,0
RTAIL_t228 TAIL__t228 TAIL 0.976108075386
* device instance TAIL_t229 r0 *1 0,0
RTAIL_t229 TAIL__t229 TAIL 0.982643701043
* device instance TAIL_t230 r0 *1 0,0
RTAIL_t230 TAIL__t230 TAIL 0.1139968595
* device instance TAIL_t231 r0 *1 0,0
RTAIL_t231 TAIL__t231 TAIL 0.126991400124
* device instance TAIL_t232 r0 *1 0,0
RTAIL_t232 TAIL__t232 TAIL 0.140000442632
* device instance TAIL_t233 r0 *1 0,0
RTAIL_t233 TAIL__t233 TAIL 0.135770823393
* device instance TAIL_t234 r0 *1 0,0
RTAIL_t234 TAIL__t234 TAIL 0.0709955806135
* device instance TAIL_t235 r0 *1 0,0
RTAIL_t235 TAIL__t235 TAIL 0.083877817487
* device instance TAIL_t236 r0 *1 0,0
RTAIL_t236 TAIL__t236 TAIL 0.0968110560219
* device instance TAIL_t237 r0 *1 0,0
RTAIL_t237 TAIL__t237 TAIL 0.122766015971
* device instance TAIL_t238 r0 *1 0,0
RTAIL_t238 TAIL__t238 TAIL 0.109777271654
* device instance TAIL_t239 r0 *1 0,0
RTAIL_t239 TAIL__t239 TAIL 0.0496414429394
* device instance TAIL_t240 r0 *1 0,0
RTAIL_t240 TAIL__t240 TAIL 0.0371940874228
* device instance TAIL_t241 r0 *1 0,0
RTAIL_t241 TAIL__t241 TAIL 0.0253831425022
* device instance TAIL_t242 r0 *1 0,0
RTAIL_t242 TAIL__t242 TAIL 0.015715731269
* device instance TAIL_t243 r0 *1 0,0
RTAIL_t243 TAIL__t243 TAIL 0.0218557609627
* device instance TAIL_t244 r0 *1 0,0
RTAIL_t244 TAIL__t244 TAIL 0.0332518282079
* device instance TAIL_t245 r0 *1 0,0
RTAIL_t245 TAIL__t245 TAIL 0.045557330618
* device instance TAIL_t246 r0 *1 0,0
RTAIL_t246 TAIL__t246 TAIL 0.058198223073
* device instance TAIL_t247 r0 *1 0,0
RTAIL_t247 TAIL__t247 TAIL 0.0138362204851
* device instance TAIL_t248 r0 *1 0,0
RTAIL_t248 TAIL__t248 TAIL 0.305359233791
* device instance TAIL_t249 r0 *1 0,0
RTAIL_t249 TAIL__t249 TAIL 0.148787481982
* device instance TAIL_t250 r0 *1 0,0
RTAIL_t250 TAIL__t250 TAIL 0.161813131748
* device instance TAIL_t251 r0 *1 0,0
RTAIL_t251 TAIL__t251 TAIL 0.17484576323
* device instance TAIL_t252 r0 *1 0,0
RTAIL_t252 TAIL__t252 TAIL 0.218213839772
* device instance TAIL_t253 r0 *1 0,0
RTAIL_t253 TAIL__t253 TAIL 0.200926536456
* device instance TAIL_t254 r0 *1 0,0
RTAIL_t254 TAIL__t254 TAIL 0.213972787689
* device instance TAIL_t255 r0 *1 0,0
RTAIL_t255 TAIL__t255 TAIL 0.227022050015
* device instance TAIL_t256 r0 *1 0,0
RTAIL_t256 TAIL__t256 TAIL 0.240073832427
* device instance TAIL_t257 r0 *1 0,0
RTAIL_t257 TAIL__t257 TAIL 0.253127745104
* device instance TAIL_t258 r0 *1 0,0
RTAIL_t258 TAIL__t258 TAIL 0.187883923567
* device instance TAIL_t259 r0 *1 0,0
RTAIL_t259 TAIL__t259 TAIL 0.101022417058
* device instance TAIL_t260 r0 *1 0,0
RTAIL_t260 TAIL__t260 TAIL 0.088076955116
* device instance TAIL_t261 r0 *1 0,0
RTAIL_t261 TAIL__t261 TAIL 0.0751754467812
* device instance TAIL_t262 r0 *1 0,0
RTAIL_t262 TAIL__t262 TAIL 0.0623451848738
* device instance TAIL_t263 r0 *1 0,0
RTAIL_t263 TAIL__t263 TAIL 0.192122674047
* device instance TAIL_t264 r0 *1 0,0
RTAIL_t264 TAIL__t264 TAIL 0.292299410414
* device instance TAIL_t265 r0 *1 0,0
RTAIL_t265 TAIL__t265 TAIL 0.179082963019
* device instance TAIL_t266 r0 *1 0,0
RTAIL_t266 TAIL__t266 TAIL 0.166048396277
* device instance TAIL_t267 r0 *1 0,0
RTAIL_t267 TAIL__t267 TAIL 0.153020288428
* device instance TAIL_t268 r0 *1 0,0
RTAIL_t268 TAIL__t268 TAIL 0.205166548503
* device instance TAIL_t269 r0 *1 0,0
RTAIL_t269 TAIL__t269 TAIL 0.279240766181
* device instance TAIL_t270 r0 *1 0,0
RTAIL_t270 TAIL__t270 TAIL 0.374917929607
* device instance TAIL_t271 r0 *1 0,0
RTAIL_t271 TAIL__t271 TAIL 0.387982622948
* device instance TAIL_t272 r0 *1 0,0
RTAIL_t272 TAIL__t272 TAIL 0.401047820067
* device instance TAIL_t273 r0 *1 0,0
RTAIL_t273 TAIL__t273 TAIL 0.414113473281
* device instance TAIL_t274 r0 *1 0,0
RTAIL_t274 TAIL__t274 TAIL 0.492514937774
* device instance TAIL_t275 r0 *1 0,0
RTAIL_t275 TAIL__t275 TAIL 0.427179540741
* device instance TAIL_t276 r0 *1 0,0
RTAIL_t276 TAIL__t276 TAIL 0.440245985563
* device instance TAIL_t277 r0 *1 0,0
RTAIL_t277 TAIL__t277 TAIL 0.466379880423
* device instance TAIL_t278 r0 *1 0,0
RTAIL_t278 TAIL__t278 TAIL 0.479447275669
* device instance TAIL_t279 r0 *1 0,0
RTAIL_t279 TAIL__t279 TAIL 0.74083243801
* device instance TAIL_t280 r0 *1 0,0
RTAIL_t280 TAIL__t280 TAIL 0.753902848537
* device instance TAIL_t281 r0 *1 0,0
RTAIL_t281 TAIL__t281 TAIL 0.76697332767
* device instance TAIL_t282 r0 *1 0,0
RTAIL_t282 TAIL__t282 TAIL 0.780043871961
* device instance TAIL_t283 r0 *1 0,0
RTAIL_t283 TAIL__t283 TAIL 0.79311447819
* device instance TAIL_t284 r0 *1 0,0
RTAIL_t284 TAIL__t284 TAIL 0.453312775116
* device instance TAIL_t285 r0 *1 0,0
RTAIL_t285 TAIL__t285 TAIL 0.557856594818
* device instance TAIL_t286 r0 *1 0,0
RTAIL_t286 TAIL__t286 TAIL 0.322665417864
* device instance TAIL_t287 r0 *1 0,0
RTAIL_t287 TAIL__t287 TAIL 0.505582846047
* device instance TAIL_t288 r0 *1 0,0
RTAIL_t288 TAIL__t288 TAIL 0.231263969552
* device instance TAIL_t289 r0 *1 0,0
RTAIL_t289 TAIL__t289 TAIL 0.24431648299
* device instance TAIL_t290 r0 *1 0,0
RTAIL_t290 TAIL__t290 TAIL 0.257371017424
* device instance TAIL_t291 r0 *1 0,0
RTAIL_t291 TAIL__t291 TAIL 0.270427280171
* device instance TAIL_t292 r0 *1 0,0
RTAIL_t292 TAIL__t292 TAIL 0.36185379461
* device instance TAIL_t293 r0 *1 0,0
RTAIL_t293 TAIL__t293 TAIL 0.296544077447
* device instance TAIL_t294 r0 *1 0,0
RTAIL_t294 TAIL__t294 TAIL 0.309604251628
* device instance TAIL_t295 r0 *1 0,0
RTAIL_t295 TAIL__t295 TAIL 0.51865098188
* device instance TAIL_t296 r0 *1 0,0
RTAIL_t296 TAIL__t296 TAIL 0.531719328496
* device instance TAIL_t297 r0 *1 0,0
RTAIL_t297 TAIL__t297 TAIL 0.544787870724
* device instance TAIL_t298 r0 *1 0,0
RTAIL_t298 TAIL__t298 TAIL 0.335727460369
* device instance TAIL_t299 r0 *1 0,0
RTAIL_t299 TAIL__t299 TAIL 0.348790280698
* device instance TAIL_t300 r0 *1 0,0
RTAIL_t300 TAIL__t300 TAIL 0.283485032434
* device instance TAIL_t301 r0 *1 0,0
RTAIL_t301 TAIL__t301 TAIL 0.67548155387
* device instance TAIL_t302 r0 *1 0,0
RTAIL_t302 TAIL__t302 TAIL 0.688551560112
* device instance TAIL_t303 r0 *1 0,0
RTAIL_t303 TAIL__t303 TAIL 0.701621656414
* device instance TAIL_t304 r0 *1 0,0
RTAIL_t304 TAIL__t304 TAIL 0.714691837834
* device instance TAIL_t305 r0 *1 0,0
RTAIL_t305 TAIL__t305 TAIL 0.727762099787
* device instance TAIL_t306 r0 *1 0,0
RTAIL_t306 TAIL__t306 TAIL 0.57092548829
* device instance TAIL_t307 r0 *1 0,0
RTAIL_t307 TAIL__t307 TAIL 0.936894493136
* device instance TAIL_t308 r0 *1 0,0
RTAIL_t308 TAIL__t308 TAIL 0.94996565339
* device instance TAIL_t309 r0 *1 0,0
RTAIL_t309 TAIL__t309 TAIL 0.963036847933
* device instance TAIL_t310 r0 *1 0,0
RTAIL_t310 TAIL__t310 TAIL 0.923823368625
* device instance TAIL_t311 r0 *1 0,0
RTAIL_t311 TAIL__t311 TAIL 0.266183474634
* device instance TAIL_t312 r0 *1 0,0
RTAIL_t312 TAIL__t312 TAIL 0.806185143342
* device instance TAIL_t313 r0 *1 0,0
RTAIL_t313 TAIL__t313 TAIL 0.819255864599
* device instance TAIL_t314 r0 *1 0,0
RTAIL_t314 TAIL__t314 TAIL 0.832326639316
* device instance TAIL_t315 r0 *1 0,0
RTAIL_t315 TAIL__t315 TAIL 0.845397465014
* device instance TAIL_t316 r0 *1 0,0
RTAIL_t316 TAIL__t316 TAIL 0.858468339364
* device instance TAIL_t317 r0 *1 0,0
RTAIL_t317 TAIL__t317 TAIL 0.871539260179
* device instance TAIL_t318 r0 *1 0,0
RTAIL_t318 TAIL__t318 TAIL 0.884610225396
* device instance TAIL_t319 r0 *1 0,0
RTAIL_t319 TAIL__t319 TAIL 0.897681233078
* device instance TAIL_t320 r0 *1 0,0
RTAIL_t320 TAIL__t320 TAIL 0.662411643019
* device instance TAIL_t321 r0 *1 0,0
RTAIL_t321 TAIL__t321 TAIL 0.910752281396
* device instance TAIL_t322 r0 *1 0,0
RTAIL_t322 TAIL__t322 TAIL 0.583994539766
* device instance TAIL_t323 r0 *1 0,0
RTAIL_t323 TAIL__t323 TAIL 0.597063738873
* device instance TAIL_t324 r0 *1 0,0
RTAIL_t324 TAIL__t324 TAIL 0.610133076123
* device instance TAIL_t325 r0 *1 0,0
RTAIL_t325 TAIL__t325 TAIL 0.623202542825
* device instance TAIL_t326 r0 *1 0,0
RTAIL_t326 TAIL__t326 TAIL 0.636272131001
* device instance TAIL_t327 r0 *1 0,0
RTAIL_t327 TAIL__t327 TAIL 0.649341833318
* device instance TAIL r0 *1 0,0
CTAIL TAIL vsubs 6.2772511e-14
* device instance VSS_t0 r0 *1 0,0
RVSS_t0 VSS__t0 VSS 0.293568281459
* device instance VSS_t1 r0 *1 0,0
RVSS_t1 VSS__t1 VSS 0.503938387728
* device instance VSS_t2 r0 *1 0,0
RVSS_t2 VSS__t2 VSS 0.503720689523
* device instance VSS_t3 r0 *1 0,0
RVSS_t3 VSS__t3 VSS 0.467742914098
* device instance VSS_t4 r0 *1 0,0
RVSS_t4 VSS__t4 VSS 0.0368714418895
* device instance VSS_t5 r0 *1 0,0
RVSS_t5 VSS__t5 VSS 0.0310706937309
* device instance VSS_t6 r0 *1 0,0
RVSS_t6 VSS__t6 VSS 0.0264440709403
* device instance VSS_t7 r0 *1 0,0
RVSS_t7 VSS__t7 VSS 0.182128391015
* device instance VSS_t8 r0 *1 0,0
RVSS_t8 VSS__t8 VSS 0.142544050989
* device instance VSS_t9 r0 *1 0,0
RVSS_t9 VSS__t9 VSS 0.150443222335
* device instance VSS_t10 r0 *1 0,0
RVSS_t10 VSS__t10 VSS 0.158352568396
* device instance VSS_t11 r0 *1 0,0
RVSS_t11 VSS__t11 VSS 0.174196239199
* device instance VSS_t12 r0 *1 0,0
RVSS_t12 VSS__t12 VSS 0.166270637173
* device instance VSS_t13 r0 *1 0,0
RVSS_t13 VSS__t13 VSS 0.0724590972445
* device instance VSS_t14 r0 *1 0,0
RVSS_t14 VSS__t14 VSS 0.0800782902788
* device instance VSS_t15 r0 *1 0,0
RVSS_t15 VSS__t15 VSS 0.0877653717109
* device instance VSS_t16 r0 *1 0,0
RVSS_t16 VSS__t16 VSS 0.095503950003
* device instance VSS_t17 r0 *1 0,0
RVSS_t17 VSS__t17 VSS 0.111092487355
* device instance VSS_t18 r0 *1 0,0
RVSS_t18 VSS__t18 VSS 0.118927848011
* device instance VSS_t19 r0 *1 0,0
RVSS_t19 VSS__t19 VSS 0.126783837359
* device instance VSS_t20 r0 *1 0,0
RVSS_t20 VSS__t20 VSS 0.134656844963
* device instance VSS_t21 r0 *1 0,0
RVSS_t21 VSS__t21 VSS 0.103282450387
* device instance VSS_t22 r0 *1 0,0
RVSS_t22 VSS__t22 VSS 0.285593573908
* device instance VSS_t23 r0 *1 0,0
RVSS_t23 VSS__t23 VSS 0.190066272582
* device instance VSS_t24 r0 *1 0,0
RVSS_t24 VSS__t24 VSS 0.198009194811
* device instance VSS_t25 r0 *1 0,0
RVSS_t25 VSS__t25 VSS 0.205956574508
* device instance VSS_t26 r0 *1 0,0
RVSS_t26 VSS__t26 VSS 0.0423205883723
* device instance VSS_t27 r0 *1 0,0
RVSS_t27 VSS__t27 VSS 0.221862789989
* device instance VSS_t28 r0 *1 0,0
RVSS_t28 VSS__t28 VSS 0.229820832881
* device instance VSS_t29 r0 *1 0,0
RVSS_t29 VSS__t29 VSS 0.237781725471
* device instance VSS_t30 r0 *1 0,0
RVSS_t30 VSS__t30 VSS 0.245745190812
* device instance VSS_t31 r0 *1 0,0
RVSS_t31 VSS__t31 VSS 0.253710986642
* device instance VSS_t32 r0 *1 0,0
RVSS_t32 VSS__t32 VSS 0.213907914846
* device instance VSS_t33 r0 *1 0,0
RVSS_t33 VSS__t33 VSS 0.0433778116341
* device instance VSS_t34 r0 *1 0,0
RVSS_t34 VSS__t34 VSS 0.0503168158213
* device instance VSS_t35 r0 *1 0,0
RVSS_t35 VSS__t35 VSS 0.0575321254925
* device instance VSS_t36 r0 *1 0,0
RVSS_t36 VSS__t36 VSS 0.0649316954195
* device instance VSS_t37 r0 *1 0,0
RVSS_t37 VSS__t37 VSS 0.0302498491645
* device instance VSS_t38 r0 *1 0,0
RVSS_t38 VSS__t38 VSS 0.277620350719
* device instance VSS_t39 r0 *1 0,0
RVSS_t39 VSS__t39 VSS 0.0258667374678
* device instance VSS_t40 r0 *1 0,0
RVSS_t40 VSS__t40 VSS 0.0234763484607
* device instance VSS_t41 r0 *1 0,0
RVSS_t41 VSS__t41 VSS 0.0236897839572
* device instance VSS_t42 r0 *1 0,0
RVSS_t42 VSS__t42 VSS 0.0359031299303
* device instance VSS_t43 r0 *1 0,0
RVSS_t43 VSS__t43 VSS 0.269648743565
* device instance VSS_t44 r0 *1 0,0
RVSS_t44 VSS__t44 VSS 0.133417604941
* device instance VSS_t45 r0 *1 0,0
RVSS_t45 VSS__t45 VSS 0.141302738938
* device instance VSS_t46 r0 *1 0,0
RVSS_t46 VSS__t46 VSS 0.14920015701
* device instance VSS_t47 r0 *1 0,0
RVSS_t47 VSS__t47 VSS 0.157108006699
* device instance VSS_t48 r0 *1 0,0
RVSS_t48 VSS__t48 VSS 0.204706368518
* device instance VSS_t49 r0 *1 0,0
RVSS_t49 VSS__t49 VSS 0.165024788391
* device instance VSS_t50 r0 *1 0,0
RVSS_t50 VSS__t50 VSS 0.172949275497
* device instance VSS_t51 r0 *1 0,0
RVSS_t51 VSS__t51 VSS 0.188817484385
* device instance VSS_t52 r0 *1 0,0
RVSS_t52 VSS__t52 VSS 0.19675965494
* device instance VSS_t53 r0 *1 0,0
RVSS_t53 VSS__t53 VSS 0.356151835951
* device instance VSS_t54 r0 *1 0,0
RVSS_t54 VSS__t54 VSS 0.364135672095
* device instance VSS_t55 r0 *1 0,0
RVSS_t55 VSS__t55 VSS 0.372120224162
* device instance VSS_t56 r0 *1 0,0
RVSS_t56 VSS__t56 VSS 0.380105447035
* device instance VSS_t57 r0 *1 0,0
RVSS_t57 VSS__t57 VSS 0.388091299307
* device instance VSS_t58 r0 *1 0,0
RVSS_t58 VSS__t58 VSS 0.180880455284
* device instance VSS_t59 r0 *1 0,0
RVSS_t59 VSS__t59 VSS 0.24449256894
* device instance VSS_t60 r0 *1 0,0
RVSS_t60 VSS__t60 VSS 0.102056804701
* device instance VSS_t61 r0 *1 0,0
RVSS_t61 VSS__t61 VSS 0.21265711582
* device instance VSS_t62 r0 *1 0,0
RVSS_t62 VSS__t62 VSS 0.0492041233905
* device instance VSS_t63 r0 *1 0,0
RVSS_t63 VSS__t63 VSS 0.0563832902033
* device instance VSS_t64 r0 *1 0,0
RVSS_t64 VSS__t64 VSS 0.0637583027278
* device instance VSS_t65 r0 *1 0,0
RVSS_t65 VSS__t65 VSS 0.0712683872161
* device instance VSS_t66 r0 *1 0,0
RVSS_t66 VSS__t66 VSS 0.125547069587
* device instance VSS_t67 r0 *1 0,0
RVSS_t67 VSS__t67 VSS 0.0865526140963
* device instance VSS_t68 r0 *1 0,0
RVSS_t68 VSS__t68 VSS 0.0942839601828
* device instance VSS_t69 r0 *1 0,0
RVSS_t69 VSS__t69 VSS 0.220611460724
* device instance VSS_t70 r0 *1 0,0
RVSS_t70 VSS__t70 VSS 0.228569027634
* device instance VSS_t71 r0 *1 0,0
RVSS_t71 VSS__t71 VSS 0.236529491357
* device instance VSS_t72 r0 *1 0,0
RVSS_t72 VSS__t72 VSS 0.109862339865
* device instance VSS_t73 r0 *1 0,0
RVSS_t73 VSS__t73 VSS 0.117694061672
* device instance VSS_t74 r0 *1 0,0
RVSS_t74 VSS__t74 VSS 0.0788749704476
* device instance VSS_t75 r0 *1 0,0
RVSS_t75 VSS__t75 VSS 0.316245291667
* device instance VSS_t76 r0 *1 0,0
RVSS_t76 VSS__t76 VSS 0.324224708277
* device instance VSS_t77 r0 *1 0,0
RVSS_t77 VSS__t77 VSS 0.332205139199
* device instance VSS_t78 r0 *1 0,0
RVSS_t78 VSS__t78 VSS 0.340186513048
* device instance VSS_t79 r0 *1 0,0
RVSS_t79 VSS__t79 VSS 0.348168764979
* device instance VSS_t80 r0 *1 0,0
RVSS_t80 VSS__t80 VSS 0.252458013042
* device instance VSS_t81 r0 *1 0,0
RVSS_t81 VSS__t81 VSS 0.499722984734
* device instance VSS_t82 r0 *1 0,0
RVSS_t82 VSS__t82 VSS 0.475737655109
* device instance VSS_t83 r0 *1 0,0
RVSS_t83 VSS__t83 VSS 0.491727699423
* device instance VSS_t84 r0 *1 0,0
RVSS_t84 VSS__t84 VSS 0.47596815236
* device instance VSS_t85 r0 *1 0,0
RVSS_t85 VSS__t85 VSS 0.483959276136
* device instance VSS_t86 r0 *1 0,0
RVSS_t86 VSS__t86 VSS 0.491950704799
* device instance VSS_t87 r0 *1 0,0
RVSS_t87 VSS__t87 VSS 0.467977349089
* device instance VSS_t88 r0 *1 0,0
RVSS_t88 VSS__t88 VSS 0.261678900136
* device instance VSS_t89 r0 *1 0,0
RVSS_t89 VSS__t89 VSS 0.483732586649
* device instance VSS_t90 r0 *1 0,0
RVSS_t90 VSS__t90 VSS 0.396077742909
* device instance VSS_t91 r0 *1 0,0
RVSS_t91 VSS__t91 VSS 0.404064742775
* device instance VSS_t92 r0 *1 0,0
RVSS_t92 VSS__t92 VSS 0.412052266561
* device instance VSS_t93 r0 *1 0,0
RVSS_t93 VSS__t93 VSS 0.420040284376
* device instance VSS_t94 r0 *1 0,0
RVSS_t94 VSS__t94 VSS 0.428028768561
* device instance VSS_t95 r0 *1 0,0
RVSS_t95 VSS__t95 VSS 0.436017693484
* device instance VSS_t96 r0 *1 0,0
RVSS_t96 VSS__t96 VSS 0.444007035353
* device instance VSS_t97 r0 *1 0,0
RVSS_t97 VSS__t97 VSS 0.451996772059
* device instance VSS_t98 r0 *1 0,0
RVSS_t98 VSS__t98 VSS 0.308266968134
* device instance VSS_t99 r0 *1 0,0
RVSS_t99 VSS__t99 VSS 0.459986883028
* device instance VSS_t100 r0 *1 0,0
RVSS_t100 VSS__t100 VSS 0.260425606514
* device instance VSS_t101 r0 *1 0,0
RVSS_t101 VSS__t101 VSS 0.268395157938
* device instance VSS_t102 r0 *1 0,0
RVSS_t102 VSS__t102 VSS 0.27636649793
* device instance VSS_t103 r0 *1 0,0
RVSS_t103 VSS__t103 VSS 0.284339476065
* device instance VSS_t104 r0 *1 0,0
RVSS_t104 VSS__t104 VSS 0.292313958299
* device instance VSS_t105 r0 *1 0,0
RVSS_t105 VSS__t105 VSS 0.300289824804
* device instance VSS_t106 r0 *1 0,0
RVSS_t106 VSS__t106 VSS 0.02857160192
* device instance VSS_t107 r0 *1 0,0
RVSS_t107 VSS__t107 VSS 0.0247839739304
* device instance VSS_t108 r0 *1 0,0
RVSS_t108 VSS__t108 VSS 0.0686820275591
* device instance VSS_t109 r0 *1 0,0
RVSS_t109 VSS__t109 VSS 0.154396721209
* device instance VSS_t110 r0 *1 0,0
RVSS_t110 VSS__t110 VSS 0.178161551044
* device instance VSS_t111 r0 *1 0,0
RVSS_t111 VSS__t111 VSS 0.170232562268
* device instance VSS_t112 r0 *1 0,0
RVSS_t112 VSS__t112 VSS 0.162310592198
* device instance VSS_t113 r0 *1 0,0
RVSS_t113 VSS__t113 VSS 0.146492261903
* device instance VSS_t114 r0 *1 0,0
RVSS_t114 VSS__t114 VSS 0.186096661392
* device instance VSS_t115 r0 *1 0,0
RVSS_t115 VSS__t115 VSS 0.0762589316841
* device instance VSS_t116 r0 *1 0,0
RVSS_t116 VSS__t116 VSS 0.0839145071524
* device instance VSS_t117 r0 *1 0,0
RVSS_t117 VSS__t117 VSS 0.091629037192
* device instance VSS_t118 r0 *1 0,0
RVSS_t118 VSS__t118 VSS 0.0993887946395
* device instance VSS_t119 r0 *1 0,0
RVSS_t119 VSS__t119 VSS 0.0338591731416
* device instance VSS_t120 r0 *1 0,0
RVSS_t120 VSS__t120 VSS 0.107183957009
* device instance VSS_t121 r0 *1 0,0
RVSS_t121 VSS__t121 VSS 0.115007325321
* device instance VSS_t122 r0 *1 0,0
RVSS_t122 VSS__t122 VSS 0.12285351119
* device instance VSS_t123 r0 *1 0,0
RVSS_t123 VSS__t123 VSS 0.130718405908
* device instance VSS_t124 r0 *1 0,0
RVSS_t124 VSS__t124 VSS 0.138598824568
* device instance VSS_t125 r0 *1 0,0
RVSS_t125 VSS__t125 VSS 0.281606768888
* device instance VSS_t126 r0 *1 0,0
RVSS_t126 VSS__t126 VSS 0.289580749803
* device instance VSS_t127 r0 *1 0,0
RVSS_t127 VSS__t127 VSS 0.194037142293
* device instance VSS_t128 r0 *1 0,0
RVSS_t128 VSS__t128 VSS 0.201982360354
* device instance VSS_t129 r0 *1 0,0
RVSS_t129 VSS__t129 VSS 0.209931777719
* device instance VSS_t130 r0 *1 0,0
RVSS_t130 VSS__t130 VSS 0.21788493476
* device instance VSS_t131 r0 *1 0,0
RVSS_t131 VSS__t131 VSS 0.225841436392
* device instance VSS_t132 r0 *1 0,0
RVSS_t132 VSS__t132 VSS 0.233800941155
* device instance VSS_t133 r0 *1 0,0
RVSS_t133 VSS__t133 VSS 0.241763152435
* device instance VSS_t134 r0 *1 0,0
RVSS_t134 VSS__t134 VSS 0.249727811353
* device instance VSS_t135 r0 *1 0,0
RVSS_t135 VSS__t135 VSS 0.0400570452287
* device instance VSS_t136 r0 *1 0,0
RVSS_t136 VSS__t136 VSS 0.0468049808904
* device instance VSS_t137 r0 *1 0,0
RVSS_t137 VSS__t137 VSS 0.0538967688912
* device instance VSS_t138 r0 *1 0,0
RVSS_t138 VSS__t138 VSS 0.0612130154031
* device instance VSS_t139 r0 *1 0,0
RVSS_t139 VSS__t139 VSS 0.0243744027621
* device instance VSS_t140 r0 *1 0,0
RVSS_t140 VSS__t140 VSS 0.0232415659619
* device instance VSS_t141 r0 *1 0,0
RVSS_t141 VSS__t141 VSS 0.0329551520176
* device instance VSS_t142 r0 *1 0,0
RVSS_t142 VSS__t142 VSS 0.265663591463
* device instance VSS_t143 r0 *1 0,0
RVSS_t143 VSS__t143 VSS 0.27363433631
* device instance VSS_t144 r0 *1 0,0
RVSS_t144 VSS__t144 VSS 0.0278580101357
* device instance VSS_t145 r0 *1 0,0
RVSS_t145 VSS__t145 VSS 0.129480345933
* device instance VSS_t146 r0 *1 0,0
RVSS_t146 VSS__t146 VSS 0.137358504133
* device instance VSS_t147 r0 *1 0,0
RVSS_t147 VSS__t147 VSS 0.145250037623
* device instance VSS_t148 r0 *1 0,0
RVSS_t148 VSS__t148 VSS 0.153152878844
* device instance VSS_t149 r0 *1 0,0
RVSS_t149 VSS__t149 VSS 0.161065363329
* device instance VSS_t150 r0 *1 0,0
RVSS_t150 VSS__t150 VSS 0.168986136494
* device instance VSS_t151 r0 *1 0,0
RVSS_t151 VSS__t151 VSS 0.176914085045
* device instance VSS_t152 r0 *1 0,0
RVSS_t152 VSS__t152 VSS 0.039038845492
* device instance VSS_t153 r0 *1 0,0
RVSS_t153 VSS__t153 VSS 0.184848285749
* device instance VSS_t154 r0 *1 0,0
RVSS_t154 VSS__t154 VSS 0.192787966685
* device instance VSS_t155 r0 *1 0,0
RVSS_t155 VSS__t155 VSS 0.200732477566
* device instance VSS_t156 r0 *1 0,0
RVSS_t156 VSS__t156 VSS 0.208681266764
* device instance VSS_t157 r0 *1 0,0
RVSS_t157 VSS__t157 VSS 0.360143661557
* device instance VSS_t158 r0 *1 0,0
RVSS_t158 VSS__t158 VSS 0.36812786155
* device instance VSS_t159 r0 *1 0,0
RVSS_t159 VSS__t159 VSS 0.376112754418
* device instance VSS_t160 r0 *1 0,0
RVSS_t160 VSS__t160 VSS 0.38409829695
* device instance VSS_t161 r0 *1 0,0
RVSS_t161 VSS__t161 VSS 0.240510719641
* device instance VSS_t162 r0 *1 0,0
RVSS_t162 VSS__t162 VSS 0.248475009399
* device instance VSS_t163 r0 *1 0,0
RVSS_t163 VSS__t163 VSS 0.10595593679
* device instance VSS_t164 r0 *1 0,0
RVSS_t164 VSS__t164 VSS 0.0457169221106
* device instance VSS_t165 r0 *1 0,0
RVSS_t165 VSS__t165 VSS 0.052764178893
* device instance VSS_t166 r0 *1 0,0
RVSS_t166 VSS__t166 VSS 0.0600507808301
* device instance VSS_t167 r0 *1 0,0
RVSS_t167 VSS__t167 VSS 0.0674992598436
* device instance VSS_t168 r0 *1 0,0
RVSS_t168 VSS__t168 VSS 0.0750614413505
* device instance VSS_t169 r0 *1 0,0
RVSS_t169 VSS__t169 VSS 0.0827061422923
* device instance VSS_t170 r0 *1 0,0
RVSS_t170 VSS__t170 VSS 0.0904124331339
* device instance VSS_t171 r0 *1 0,0
RVSS_t171 VSS__t171 VSS 0.216633863335
* device instance VSS_t172 r0 *1 0,0
RVSS_t172 VSS__t172 VSS 0.22458986283
* device instance VSS_t173 r0 *1 0,0
RVSS_t173 VSS__t173 VSS 0.232548915985
* device instance VSS_t174 r0 *1 0,0
RVSS_t174 VSS__t174 VSS 0.0981658100083
* device instance VSS_t175 r0 *1 0,0
RVSS_t175 VSS__t175 VSS 0.113775264995
* device instance VSS_t176 r0 *1 0,0
RVSS_t176 VSS__t176 VSS 0.121618162316
* device instance VSS_t177 r0 *1 0,0
RVSS_t177 VSS__t177 VSS 0.312255988029
* device instance VSS_t178 r0 *1 0,0
RVSS_t178 VSS__t178 VSS 0.320234868444
* device instance VSS_t179 r0 *1 0,0
RVSS_t179 VSS__t179 VSS 0.328214801573
* device instance VSS_t180 r0 *1 0,0
RVSS_t180 VSS__t180 VSS 0.336195712455
* device instance VSS_t181 r0 *1 0,0
RVSS_t181 VSS__t181 VSS 0.344177533072
* device instance VSS_t182 r0 *1 0,0
RVSS_t182 VSS__t182 VSS 0.352160201566
* device instance VSS_t183 r0 *1 0,0
RVSS_t183 VSS__t183 VSS 0.479735097658
* device instance VSS_t184 r0 *1 0,0
RVSS_t184 VSS__t184 VSS 0.39208444945
* device instance VSS_t185 r0 *1 0,0
RVSS_t185 VSS__t185 VSS 0.487730120939
* device instance VSS_t186 r0 *1 0,0
RVSS_t186 VSS__t186 VSS 0.479963675185
* device instance VSS_t187 r0 *1 0,0
RVSS_t187 VSS__t187 VSS 0.487954953293
* device instance VSS_t188 r0 *1 0,0
RVSS_t188 VSS__t188 VSS 0.495946528857
* device instance VSS_t189 r0 *1 0,0
RVSS_t189 VSS__t189 VSS 0.499942423728
* device instance VSS_t190 r0 *1 0,0
RVSS_t190 VSS__t190 VSS 0.495725321033
* device instance VSS_t191 r0 *1 0,0
RVSS_t191 VSS__t191 VSS 0.471972709644
* device instance VSS_t192 r0 *1 0,0
RVSS_t192 VSS__t192 VSS 0.471740260182
* device instance VSS_t193 r0 *1 0,0
RVSS_t193 VSS__t193 VSS 0.257694690957
* device instance VSS_t194 r0 *1 0,0
RVSS_t194 VSS__t194 VSS 0.400071175391
* device instance VSS_t195 r0 *1 0,0
RVSS_t195 VSS__t195 VSS 0.408058441101
* device instance VSS_t196 r0 *1 0,0
RVSS_t196 VSS__t196 VSS 0.416046215493
* device instance VSS_t197 r0 *1 0,0
RVSS_t197 VSS__t197 VSS 0.424034469819
* device instance VSS_t198 r0 *1 0,0
RVSS_t198 VSS__t198 VSS 0.432023177458
* device instance VSS_t199 r0 *1 0,0
RVSS_t199 VSS__t199 VSS 0.440012313719
* device instance VSS_t200 r0 *1 0,0
RVSS_t200 VSS__t200 VSS 0.448001855671
* device instance VSS_t201 r0 *1 0,0
RVSS_t201 VSS__t201 VSS 0.463982072818
* device instance VSS_t202 r0 *1 0,0
RVSS_t202 VSS__t202 VSS 0.256441553627
* device instance VSS_t203 r0 *1 0,0
RVSS_t203 VSS__t203 VSS 0.264410148547
* device instance VSS_t204 r0 *1 0,0
RVSS_t204 VSS__t204 VSS 0.272380614177
* device instance VSS_t205 r0 *1 0,0
RVSS_t205 VSS__t205 VSS 0.280352790964
* device instance VSS_t206 r0 *1 0,0
RVSS_t206 VSS__t206 VSS 0.288326536969
* device instance VSS_t207 r0 *1 0,0
RVSS_t207 VSS__t207 VSS 0.296301725504
* device instance VSS_t208 r0 *1 0,0
RVSS_t208 VSS__t208 VSS 0.304278243142
* device instance VSS_t209 r0 *1 0,0
RVSS_t209 VSS__t209 VSS 0.45599178199
* device instance VSS_t210 r0 *1 0,0
RVSS_t210 VSS__t210 VSS 0.931140137825
* device instance VSS_t211 r0 *1 0,0
RVSS_t211 VSS__t211 VSS 0.920195642846
* device instance VSS_t212 r0 *1 0,0
RVSS_t212 VSS__t212 VSS 0.909259970887
* device instance VSS_t213 r0 *1 0,0
RVSS_t213 VSS__t213 VSS 0.898333444163
* device instance VSS_t214 r0 *1 0,0
RVSS_t214 VSS__t214 VSS 0.887416400483
* device instance VSS_t215 r0 *1 0,0
RVSS_t215 VSS__t215 VSS 0.876509194185
* device instance VSS_t216 r0 *1 0,0
RVSS_t216 VSS__t216 VSS 0.86561219714
* device instance VSS_t217 r0 *1 0,0
RVSS_t217 VSS__t217 VSS 0.854725799823
* device instance VSS_t218 r0 *1 0,0
RVSS_t218 VSS__t218 VSS 0.843850412473
* device instance VSS_t219 r0 *1 0,0
RVSS_t219 VSS__t219 VSS 0.832986466323
* device instance VSS_t220 r0 *1 0,0
RVSS_t220 VSS__t220 VSS 0.822134414938
* device instance VSS_t221 r0 *1 0,0
RVSS_t221 VSS__t221 VSS 0.811294735638
* device instance VSS_t222 r0 *1 0,0
RVSS_t222 VSS__t222 VSS 0.800467931039
* device instance VSS_t223 r0 *1 0,0
RVSS_t223 VSS__t223 VSS 0.78965453071
* device instance VSS_t224 r0 *1 0,0
RVSS_t224 VSS__t224 VSS 0.778855092954
* device instance VSS_t225 r0 *1 0,0
RVSS_t225 VSS__t225 VSS 0.768070206732
* device instance VSS_t226 r0 *1 0,0
RVSS_t226 VSS__t226 VSS 0.757300493741
* device instance VSS_t227 r0 *1 0,0
RVSS_t227 VSS__t227 VSS 0.746546610648
* device instance VSS_t228 r0 *1 0,0
RVSS_t228 VSS__t228 VSS 0.735809251519
* device instance VSS_t229 r0 *1 0,0
RVSS_t229 VSS__t229 VSS 0.725089150431
* device instance VSS_t230 r0 *1 0,0
RVSS_t230 VSS__t230 VSS 0.661989825317
* device instance VSS_t231 r0 *1 0,0
RVSS_t231 VSS__t231 VSS 0.67259011083
* device instance VSS_t232 r0 *1 0,0
RVSS_t232 VSS__t232 VSS 0.683212993327
* device instance VSS_t233 r0 *1 0,0
RVSS_t233 VSS__t233 VSS 0.693857434935
* device instance VSS_t234 r0 *1 0,0
RVSS_t234 VSS__t234 VSS 0.704522458463
* device instance VSS_t235 r0 *1 0,0
RVSS_t235 VSS__t235 VSS 0.715207143172
* device instance VSS_t236 r0 *1 0,0
RVSS_t236 VSS__t236 VSS 0.725910620882
* device instance VSS_t237 r0 *1 0,0
RVSS_t237 VSS__t237 VSS 0.736632072391
* device instance VSS_t238 r0 *1 0,0
RVSS_t238 VSS__t238 VSS 0.747370724167
* device instance VSS_t239 r0 *1 0,0
RVSS_t239 VSS__t239 VSS 0.758125845297
* device instance VSS_t240 r0 *1 0,0
RVSS_t240 VSS__t240 VSS 0.768896744677
* device instance VSS_t241 r0 *1 0,0
RVSS_t241 VSS__t241 VSS 0.779682768402
* device instance VSS_t242 r0 *1 0,0
RVSS_t242 VSS__t242 VSS 0.790483297363
* device instance VSS_t243 r0 *1 0,0
RVSS_t243 VSS__t243 VSS 0.801297745023
* device instance VSS_t244 r0 *1 0,0
RVSS_t244 VSS__t244 VSS 0.812125555347
* device instance VSS_t245 r0 *1 0,0
RVSS_t245 VSS__t245 VSS 0.822966200896
* device instance VSS_t246 r0 *1 0,0
RVSS_t246 VSS__t246 VSS 0.83381918105
* device instance VSS_t247 r0 *1 0,0
RVSS_t247 VSS__t247 VSS 0.844684020363
* device instance VSS_t248 r0 *1 0,0
RVSS_t248 VSS__t248 VSS 0.855560267034
* device instance VSS_t249 r0 *1 0,0
RVSS_t249 VSS__t249 VSS 0.866447491484
* device instance VSS_t250 r0 *1 0,0
RVSS_t250 VSS__t250 VSS 0.499942423728
* device instance VSS_t251 r0 *1 0,0
RVSS_t251 VSS__t251 VSS 0.495946528857
* device instance VSS_t252 r0 *1 0,0
RVSS_t252 VSS__t252 VSS 0.491950704799
* device instance VSS_t253 r0 *1 0,0
RVSS_t253 VSS__t253 VSS 0.487954953293
* device instance VSS_t254 r0 *1 0,0
RVSS_t254 VSS__t254 VSS 0.483959276136
* device instance VSS_t255 r0 *1 0,0
RVSS_t255 VSS__t255 VSS 0.479963675185
* device instance VSS_t256 r0 *1 0,0
RVSS_t256 VSS__t256 VSS 0.47596815236
* device instance VSS_t257 r0 *1 0,0
RVSS_t257 VSS__t257 VSS 0.471972709644
* device instance VSS_t258 r0 *1 0,0
RVSS_t258 VSS__t258 VSS 0.467977349089
* device instance VSS_t259 r0 *1 0,0
RVSS_t259 VSS__t259 VSS 0.463982072818
* device instance VSS_t260 r0 *1 0,0
RVSS_t260 VSS__t260 VSS 0.459986883028
* device instance VSS_t261 r0 *1 0,0
RVSS_t261 VSS__t261 VSS 0.45599178199
* device instance VSS_t262 r0 *1 0,0
RVSS_t262 VSS__t262 VSS 0.451996772059
* device instance VSS_t263 r0 *1 0,0
RVSS_t263 VSS__t263 VSS 0.448001855671
* device instance VSS_t264 r0 *1 0,0
RVSS_t264 VSS__t264 VSS 0.444007035353
* device instance VSS_t265 r0 *1 0,0
RVSS_t265 VSS__t265 VSS 0.440012313719
* device instance VSS_t266 r0 *1 0,0
RVSS_t266 VSS__t266 VSS 0.436017693484
* device instance VSS_t267 r0 *1 0,0
RVSS_t267 VSS__t267 VSS 0.432023177458
* device instance VSS_t268 r0 *1 0,0
RVSS_t268 VSS__t268 VSS 0.428028768561
* device instance VSS_t269 r0 *1 0,0
RVSS_t269 VSS__t269 VSS 0.424034469819
* device instance VSS_t270 r0 *1 0,0
RVSS_t270 VSS__t270 VSS 0.420040284376
* device instance VSS_t271 r0 *1 0,0
RVSS_t271 VSS__t271 VSS 0.416046215493
* device instance VSS_t272 r0 *1 0,0
RVSS_t272 VSS__t272 VSS 0.412052266561
* device instance VSS_t273 r0 *1 0,0
RVSS_t273 VSS__t273 VSS 0.408058441101
* device instance VSS_t274 r0 *1 0,0
RVSS_t274 VSS__t274 VSS 0.404064742775
* device instance VSS_t275 r0 *1 0,0
RVSS_t275 VSS__t275 VSS 0.400071175391
* device instance VSS_t276 r0 *1 0,0
RVSS_t276 VSS__t276 VSS 0.396077742909
* device instance VSS_t277 r0 *1 0,0
RVSS_t277 VSS__t277 VSS 0.39208444945
* device instance VSS_t278 r0 *1 0,0
RVSS_t278 VSS__t278 VSS 0.388091299307
* device instance VSS_t279 r0 *1 0,0
RVSS_t279 VSS__t279 VSS 0.38409829695
* device instance VSS_t280 r0 *1 0,0
RVSS_t280 VSS__t280 VSS 0.380105447035
* device instance VSS_t281 r0 *1 0,0
RVSS_t281 VSS__t281 VSS 0.376112754418
* device instance VSS_t282 r0 *1 0,0
RVSS_t282 VSS__t282 VSS 0.372120224162
* device instance VSS_t283 r0 *1 0,0
RVSS_t283 VSS__t283 VSS 0.36812786155
* device instance VSS_t284 r0 *1 0,0
RVSS_t284 VSS__t284 VSS 0.364135672095
* device instance VSS_t285 r0 *1 0,0
RVSS_t285 VSS__t285 VSS 0.360143661557
* device instance VSS_t286 r0 *1 0,0
RVSS_t286 VSS__t286 VSS 0.356151835951
* device instance VSS_t287 r0 *1 0,0
RVSS_t287 VSS__t287 VSS 0.352160201566
* device instance VSS_t288 r0 *1 0,0
RVSS_t288 VSS__t288 VSS 0.348168764979
* device instance VSS_t289 r0 *1 0,0
RVSS_t289 VSS__t289 VSS 0.344177533072
* device instance VSS_t290 r0 *1 0,0
RVSS_t290 VSS__t290 VSS 0.340186513048
* device instance VSS_t291 r0 *1 0,0
RVSS_t291 VSS__t291 VSS 0.336195712455
* device instance VSS_t292 r0 *1 0,0
RVSS_t292 VSS__t292 VSS 0.332205139199
* device instance VSS_t293 r0 *1 0,0
RVSS_t293 VSS__t293 VSS 0.328214801573
* device instance VSS_t294 r0 *1 0,0
RVSS_t294 VSS__t294 VSS 0.324224708277
* device instance VSS_t295 r0 *1 0,0
RVSS_t295 VSS__t295 VSS 0.320234868444
* device instance VSS_t296 r0 *1 0,0
RVSS_t296 VSS__t296 VSS 0.316245291667
* device instance VSS_t297 r0 *1 0,0
RVSS_t297 VSS__t297 VSS 0.312255988029
* device instance VSS_t298 r0 *1 0,0
RVSS_t298 VSS__t298 VSS 0.308266968134
* device instance VSS_t299 r0 *1 0,0
RVSS_t299 VSS__t299 VSS 0.304278243142
* device instance VSS_t300 r0 *1 0,0
RVSS_t300 VSS__t300 VSS 0.300289824804
* device instance VSS_t301 r0 *1 0,0
RVSS_t301 VSS__t301 VSS 0.296301725504
* device instance VSS_t302 r0 *1 0,0
RVSS_t302 VSS__t302 VSS 0.292313958299
* device instance VSS_t303 r0 *1 0,0
RVSS_t303 VSS__t303 VSS 0.288326536969
* device instance VSS_t304 r0 *1 0,0
RVSS_t304 VSS__t304 VSS 0.284339476065
* device instance VSS_t305 r0 *1 0,0
RVSS_t305 VSS__t305 VSS 0.280352790964
* device instance VSS_t306 r0 *1 0,0
RVSS_t306 VSS__t306 VSS 0.27636649793
* device instance VSS_t307 r0 *1 0,0
RVSS_t307 VSS__t307 VSS 0.272380614177
* device instance VSS_t308 r0 *1 0,0
RVSS_t308 VSS__t308 VSS 0.268395157938
* device instance VSS_t309 r0 *1 0,0
RVSS_t309 VSS__t309 VSS 0.264410148547
* device instance VSS_t310 r0 *1 0,0
RVSS_t310 VSS__t310 VSS 0.260425606514
* device instance VSS_t311 r0 *1 0,0
RVSS_t311 VSS__t311 VSS 0.256441553627
* device instance VSS_t312 r0 *1 0,0
RVSS_t312 VSS__t312 VSS 0.252458013042
* device instance VSS_t313 r0 *1 0,0
RVSS_t313 VSS__t313 VSS 0.248475009399
* device instance VSS_t314 r0 *1 0,0
RVSS_t314 VSS__t314 VSS 0.24449256894
* device instance VSS_t315 r0 *1 0,0
RVSS_t315 VSS__t315 VSS 0.240510719641
* device instance VSS_t316 r0 *1 0,0
RVSS_t316 VSS__t316 VSS 0.236529491357
* device instance VSS_t317 r0 *1 0,0
RVSS_t317 VSS__t317 VSS 0.232548915985
* device instance VSS_t318 r0 *1 0,0
RVSS_t318 VSS__t318 VSS 0.228569027634
* device instance VSS_t319 r0 *1 0,0
RVSS_t319 VSS__t319 VSS 0.22458986283
* device instance VSS_t320 r0 *1 0,0
RVSS_t320 VSS__t320 VSS 0.220611460724
* device instance VSS_t321 r0 *1 0,0
RVSS_t321 VSS__t321 VSS 0.216633863335
* device instance VSS_t322 r0 *1 0,0
RVSS_t322 VSS__t322 VSS 0.21265711582
* device instance VSS_t323 r0 *1 0,0
RVSS_t323 VSS__t323 VSS 0.208681266764
* device instance VSS_t324 r0 *1 0,0
RVSS_t324 VSS__t324 VSS 0.204706368518
* device instance VSS_t325 r0 *1 0,0
RVSS_t325 VSS__t325 VSS 0.200732477566
* device instance VSS_t326 r0 *1 0,0
RVSS_t326 VSS__t326 VSS 0.19675965494
* device instance VSS_t327 r0 *1 0,0
RVSS_t327 VSS__t327 VSS 0.192787966685
* device instance VSS_t328 r0 *1 0,0
RVSS_t328 VSS__t328 VSS 0.188817484385
* device instance VSS_t329 r0 *1 0,0
RVSS_t329 VSS__t329 VSS 0.184848285749
* device instance VSS_t330 r0 *1 0,0
RVSS_t330 VSS__t330 VSS 0.180880455284
* device instance VSS_t331 r0 *1 0,0
RVSS_t331 VSS__t331 VSS 0.176914085045
* device instance VSS_t332 r0 *1 0,0
RVSS_t332 VSS__t332 VSS 0.172949275497
* device instance VSS_t333 r0 *1 0,0
RVSS_t333 VSS__t333 VSS 0.168986136494
* device instance VSS_t334 r0 *1 0,0
RVSS_t334 VSS__t334 VSS 0.165024788391
* device instance VSS_t335 r0 *1 0,0
RVSS_t335 VSS__t335 VSS 0.161065363329
* device instance VSS_t336 r0 *1 0,0
RVSS_t336 VSS__t336 VSS 0.157108006699
* device instance VSS_t337 r0 *1 0,0
RVSS_t337 VSS__t337 VSS 0.153152878844
* device instance VSS_t338 r0 *1 0,0
RVSS_t338 VSS__t338 VSS 0.14920015701
* device instance VSS_t339 r0 *1 0,0
RVSS_t339 VSS__t339 VSS 0.145250037623
* device instance VSS_t340 r0 *1 0,0
RVSS_t340 VSS__t340 VSS 0.141302738938
* device instance VSS_t341 r0 *1 0,0
RVSS_t341 VSS__t341 VSS 0.137358504133
* device instance VSS_t342 r0 *1 0,0
RVSS_t342 VSS__t342 VSS 0.133417604941
* device instance VSS_t343 r0 *1 0,0
RVSS_t343 VSS__t343 VSS 0.129480345933
* device instance VSS_t344 r0 *1 0,0
RVSS_t344 VSS__t344 VSS 0.125547069587
* device instance VSS_t345 r0 *1 0,0
RVSS_t345 VSS__t345 VSS 0.121618162316
* device instance VSS_t346 r0 *1 0,0
RVSS_t346 VSS__t346 VSS 0.117694061672
* device instance VSS_t347 r0 *1 0,0
RVSS_t347 VSS__t347 VSS 0.113775264995
* device instance VSS_t348 r0 *1 0,0
RVSS_t348 VSS__t348 VSS 0.109862339865
* device instance VSS_t349 r0 *1 0,0
RVSS_t349 VSS__t349 VSS 0.10595593679
* device instance VSS_t350 r0 *1 0,0
RVSS_t350 VSS__t350 VSS 0.102056804701
* device instance VSS_t351 r0 *1 0,0
RVSS_t351 VSS__t351 VSS 0.0981658100083
* device instance VSS_t352 r0 *1 0,0
RVSS_t352 VSS__t352 VSS 0.0942839601828
* device instance VSS_t353 r0 *1 0,0
RVSS_t353 VSS__t353 VSS 0.0904124331339
* device instance VSS_t354 r0 *1 0,0
RVSS_t354 VSS__t354 VSS 0.0865526140963
* device instance VSS_t355 r0 *1 0,0
RVSS_t355 VSS__t355 VSS 0.0827061422923
* device instance VSS_t356 r0 *1 0,0
RVSS_t356 VSS__t356 VSS 0.0788749704476
* device instance VSS_t357 r0 *1 0,0
RVSS_t357 VSS__t357 VSS 0.0750614413505
* device instance VSS_t358 r0 *1 0,0
RVSS_t358 VSS__t358 VSS 0.0712683872161
* device instance VSS_t359 r0 *1 0,0
RVSS_t359 VSS__t359 VSS 0.0674992598436
* device instance VSS_t360 r0 *1 0,0
RVSS_t360 VSS__t360 VSS 0.0637583027278
* device instance VSS_t361 r0 *1 0,0
RVSS_t361 VSS__t361 VSS 0.0600507808301
* device instance VSS_t362 r0 *1 0,0
RVSS_t362 VSS__t362 VSS 0.0563832902033
* device instance VSS_t363 r0 *1 0,0
RVSS_t363 VSS__t363 VSS 0.052764178893
* device instance VSS_t364 r0 *1 0,0
RVSS_t364 VSS__t364 VSS 0.0492041233905
* device instance VSS_t365 r0 *1 0,0
RVSS_t365 VSS__t365 VSS 0.0457169221106
* device instance VSS_t366 r0 *1 0,0
RVSS_t366 VSS__t366 VSS 0.0423205883723
* device instance VSS_t367 r0 *1 0,0
RVSS_t367 VSS__t367 VSS 0.039038845492
* device instance VSS_t368 r0 *1 0,0
RVSS_t368 VSS__t368 VSS 0.0359031299303
* device instance VSS_t369 r0 *1 0,0
RVSS_t369 VSS__t369 VSS 0.0329551520176
* device instance VSS_t370 r0 *1 0,0
RVSS_t370 VSS__t370 VSS 0.0302498491645
* device instance VSS_t371 r0 *1 0,0
RVSS_t371 VSS__t371 VSS 0.0278580101357
* device instance VSS_t372 r0 *1 0,0
RVSS_t372 VSS__t372 VSS 0.0258667374678
* device instance VSS_t373 r0 *1 0,0
RVSS_t373 VSS__t373 VSS 0.0243744027621
* device instance VSS_t374 r0 *1 0,0
RVSS_t374 VSS__t374 VSS 0.0234763484607
* device instance VSS_t375 r0 *1 0,0
RVSS_t375 VSS__t375 VSS 0.0232415659619
* device instance VSS_t376 r0 *1 0,0
RVSS_t376 VSS__t376 VSS 0.0236897839572
* device instance VSS_t377 r0 *1 0,0
RVSS_t377 VSS__t377 VSS 0.0247839739304
* device instance VSS_t378 r0 *1 0,0
RVSS_t378 VSS__t378 VSS 0.0264440709403
* device instance VSS_t379 r0 *1 0,0
RVSS_t379 VSS__t379 VSS 0.02857160192
* device instance VSS_t380 r0 *1 0,0
RVSS_t380 VSS__t380 VSS 0.0310706937309
* device instance VSS_t381 r0 *1 0,0
RVSS_t381 VSS__t381 VSS 0.0338591731416
* device instance VSS_t382 r0 *1 0,0
RVSS_t382 VSS__t382 VSS 0.0368714418895
* device instance VSS_t383 r0 *1 0,0
RVSS_t383 VSS__t383 VSS 0.0400570452287
* device instance VSS_t384 r0 *1 0,0
RVSS_t384 VSS__t384 VSS 0.0433778116341
* device instance VSS_t385 r0 *1 0,0
RVSS_t385 VSS__t385 VSS 0.0468049808904
* device instance VSS_t386 r0 *1 0,0
RVSS_t386 VSS__t386 VSS 0.0503168158213
* device instance VSS_t387 r0 *1 0,0
RVSS_t387 VSS__t387 VSS 0.0538967688912
* device instance VSS_t388 r0 *1 0,0
RVSS_t388 VSS__t388 VSS 0.0575321254925
* device instance VSS_t389 r0 *1 0,0
RVSS_t389 VSS__t389 VSS 0.0612130154031
* device instance VSS_t390 r0 *1 0,0
RVSS_t390 VSS__t390 VSS 0.0649316954195
* device instance VSS_t391 r0 *1 0,0
RVSS_t391 VSS__t391 VSS 0.0686820275591
* device instance VSS_t392 r0 *1 0,0
RVSS_t392 VSS__t392 VSS 0.0724590972445
* device instance VSS_t393 r0 *1 0,0
RVSS_t393 VSS__t393 VSS 0.0762589316841
* device instance VSS_t394 r0 *1 0,0
RVSS_t394 VSS__t394 VSS 0.0800782902788
* device instance VSS_t395 r0 *1 0,0
RVSS_t395 VSS__t395 VSS 0.0839145071524
* device instance VSS_t396 r0 *1 0,0
RVSS_t396 VSS__t396 VSS 0.0877653717109
* device instance VSS_t397 r0 *1 0,0
RVSS_t397 VSS__t397 VSS 0.091629037192
* device instance VSS_t398 r0 *1 0,0
RVSS_t398 VSS__t398 VSS 0.095503950003
* device instance VSS_t399 r0 *1 0,0
RVSS_t399 VSS__t399 VSS 0.0993887946395
* device instance VSS_t400 r0 *1 0,0
RVSS_t400 VSS__t400 VSS 0.103282450387
* device instance VSS_t401 r0 *1 0,0
RVSS_t401 VSS__t401 VSS 0.107183957009
* device instance VSS_t402 r0 *1 0,0
RVSS_t402 VSS__t402 VSS 0.111092487355
* device instance VSS_t403 r0 *1 0,0
RVSS_t403 VSS__t403 VSS 0.115007325321
* device instance VSS_t404 r0 *1 0,0
RVSS_t404 VSS__t404 VSS 0.118927848011
* device instance VSS_t405 r0 *1 0,0
RVSS_t405 VSS__t405 VSS 0.12285351119
* device instance VSS_t406 r0 *1 0,0
RVSS_t406 VSS__t406 VSS 0.126783837359
* device instance VSS_t407 r0 *1 0,0
RVSS_t407 VSS__t407 VSS 0.130718405908
* device instance VSS_t408 r0 *1 0,0
RVSS_t408 VSS__t408 VSS 0.134656844963
* device instance VSS_t409 r0 *1 0,0
RVSS_t409 VSS__t409 VSS 0.138598824568
* device instance VSS_t410 r0 *1 0,0
RVSS_t410 VSS__t410 VSS 0.142544050989
* device instance VSS_t411 r0 *1 0,0
RVSS_t411 VSS__t411 VSS 0.146492261903
* device instance VSS_t412 r0 *1 0,0
RVSS_t412 VSS__t412 VSS 0.150443222335
* device instance VSS_t413 r0 *1 0,0
RVSS_t413 VSS__t413 VSS 0.154396721209
* device instance VSS_t414 r0 *1 0,0
RVSS_t414 VSS__t414 VSS 0.158352568396
* device instance VSS_t415 r0 *1 0,0
RVSS_t415 VSS__t415 VSS 0.162310592198
* device instance VSS_t416 r0 *1 0,0
RVSS_t416 VSS__t416 VSS 0.166270637173
* device instance VSS_t417 r0 *1 0,0
RVSS_t417 VSS__t417 VSS 0.170232562268
* device instance VSS_t418 r0 *1 0,0
RVSS_t418 VSS__t418 VSS 0.174196239199
* device instance VSS_t419 r0 *1 0,0
RVSS_t419 VSS__t419 VSS 0.178161551044
* device instance VSS_t420 r0 *1 0,0
RVSS_t420 VSS__t420 VSS 0.182128391015
* device instance VSS_t421 r0 *1 0,0
RVSS_t421 VSS__t421 VSS 0.186096661392
* device instance VSS_t422 r0 *1 0,0
RVSS_t422 VSS__t422 VSS 0.190066272582
* device instance VSS_t423 r0 *1 0,0
RVSS_t423 VSS__t423 VSS 0.194037142293
* device instance VSS_t424 r0 *1 0,0
RVSS_t424 VSS__t424 VSS 0.198009194811
* device instance VSS_t425 r0 *1 0,0
RVSS_t425 VSS__t425 VSS 0.201982360354
* device instance VSS_t426 r0 *1 0,0
RVSS_t426 VSS__t426 VSS 0.205956574508
* device instance VSS_t427 r0 *1 0,0
RVSS_t427 VSS__t427 VSS 0.209931777719
* device instance VSS_t428 r0 *1 0,0
RVSS_t428 VSS__t428 VSS 0.213907914846
* device instance VSS_t429 r0 *1 0,0
RVSS_t429 VSS__t429 VSS 0.21788493476
* device instance VSS_t430 r0 *1 0,0
RVSS_t430 VSS__t430 VSS 0.221862789989
* device instance VSS_t431 r0 *1 0,0
RVSS_t431 VSS__t431 VSS 0.225841436392
* device instance VSS_t432 r0 *1 0,0
RVSS_t432 VSS__t432 VSS 0.229820832881
* device instance VSS_t433 r0 *1 0,0
RVSS_t433 VSS__t433 VSS 0.233800941155
* device instance VSS_t434 r0 *1 0,0
RVSS_t434 VSS__t434 VSS 0.237781725471
* device instance VSS_t435 r0 *1 0,0
RVSS_t435 VSS__t435 VSS 0.241763152435
* device instance VSS_t436 r0 *1 0,0
RVSS_t436 VSS__t436 VSS 0.245745190812
* device instance VSS_t437 r0 *1 0,0
RVSS_t437 VSS__t437 VSS 0.249727811353
* device instance VSS_t438 r0 *1 0,0
RVSS_t438 VSS__t438 VSS 0.253710986642
* device instance VSS_t439 r0 *1 0,0
RVSS_t439 VSS__t439 VSS 0.257694690957
* device instance VSS_t440 r0 *1 0,0
RVSS_t440 VSS__t440 VSS 0.261678900136
* device instance VSS_t441 r0 *1 0,0
RVSS_t441 VSS__t441 VSS 0.265663591463
* device instance VSS_t442 r0 *1 0,0
RVSS_t442 VSS__t442 VSS 0.269648743565
* device instance VSS_t443 r0 *1 0,0
RVSS_t443 VSS__t443 VSS 0.27363433631
* device instance VSS_t444 r0 *1 0,0
RVSS_t444 VSS__t444 VSS 0.277620350719
* device instance VSS_t445 r0 *1 0,0
RVSS_t445 VSS__t445 VSS 0.281606768888
* device instance VSS_t446 r0 *1 0,0
RVSS_t446 VSS__t446 VSS 0.285593573908
* device instance VSS_t447 r0 *1 0,0
RVSS_t447 VSS__t447 VSS 0.289580749803
* device instance VSS_t448 r0 *1 0,0
RVSS_t448 VSS__t448 VSS 0.499722984734
* device instance VSS_t449 r0 *1 0,0
RVSS_t449 VSS__t449 VSS 0.495725321033
* device instance VSS_t450 r0 *1 0,0
RVSS_t450 VSS__t450 VSS 0.491727699423
* device instance VSS_t451 r0 *1 0,0
RVSS_t451 VSS__t451 VSS 0.487730120939
* device instance VSS_t452 r0 *1 0,0
RVSS_t452 VSS__t452 VSS 0.483732586649
* device instance VSS_t453 r0 *1 0,0
RVSS_t453 VSS__t453 VSS 0.479735097658
* device instance VSS_t454 r0 *1 0,0
RVSS_t454 VSS__t454 VSS 0.475737655109
* device instance VSS_t455 r0 *1 0,0
RVSS_t455 VSS__t455 VSS 0.471740260182
* device instance VSS_t456 r0 *1 0,0
RVSS_t456 VSS__t456 VSS 0.293568281459
* device instance VSS_t457 r0 *1 0,0
RVSS_t457 VSS__t457 VSS 0.467742914098
* device instance VSS_t458 r0 *1 0,0
RVSS_t458 VSS__t458 VSS 0.503938387728
* device instance VSS_t459 r0 *1 0,0
RVSS_t459 VSS__t459 VSS 0.503720689523
* device instance VSS_t460 r0 *1 0,0
RVSS_t460 VSS__t460 VSS 0.320579145635
* device instance VSS_t461 r0 *1 0,0
RVSS_t461 VSS__t461 VSS 0.320236823373
* device instance VSS_t462 r0 *1 0,0
RVSS_t462 VSS__t462 VSS 0.323614886922
* device instance VSS_t463 r0 *1 0,0
RVSS_t463 VSS__t463 VSS 0.326650775766
* device instance VSS_t464 r0 *1 0,0
RVSS_t464 VSS__t464 VSS 0.32968680809
* device instance VSS_t465 r0 *1 0,0
RVSS_t465 VSS__t465 VSS 0.332722979968
* device instance VSS_t466 r0 *1 0,0
RVSS_t466 VSS__t466 VSS 0.335759287614
* device instance VSS_t467 r0 *1 0,0
RVSS_t467 VSS__t467 VSS 0.338795727376
* device instance VSS_t468 r0 *1 0,0
RVSS_t468 VSS__t468 VSS 0.341832295734
* device instance VSS_t469 r0 *1 0,0
RVSS_t469 VSS__t469 VSS 0.344868989292
* device instance VSS_t470 r0 *1 0,0
RVSS_t470 VSS__t470 VSS 0.347905804771
* device instance VSS_t471 r0 *1 0,0
RVSS_t471 VSS__t471 VSS 0.350942739006
* device instance VSS_t472 r0 *1 0,0
RVSS_t472 VSS__t472 VSS 0.353979788941
* device instance VSS_t473 r0 *1 0,0
RVSS_t473 VSS__t473 VSS 0.357016951622
* device instance VSS_t474 r0 *1 0,0
RVSS_t474 VSS__t474 VSS 0.360054224197
* device instance VSS_t475 r0 *1 0,0
RVSS_t475 VSS__t475 VSS 0.363091603907
* device instance VSS_t476 r0 *1 0,0
RVSS_t476 VSS__t476 VSS 0.366129088087
* device instance VSS_t477 r0 *1 0,0
RVSS_t477 VSS__t477 VSS 0.369166674158
* device instance VSS_t478 r0 *1 0,0
RVSS_t478 VSS__t478 VSS 0.372204359625
* device instance VSS_t479 r0 *1 0,0
RVSS_t479 VSS__t479 VSS 0.375242142074
* device instance VSS_t480 r0 *1 0,0
RVSS_t480 VSS__t480 VSS 0.378280019168
* device instance VSS_t481 r0 *1 0,0
RVSS_t481 VSS__t481 VSS 0.381317988647
* device instance VSS_t482 r0 *1 0,0
RVSS_t482 VSS__t482 VSS 0.384356048318
* device instance VSS_t483 r0 *1 0,0
RVSS_t483 VSS__t483 VSS 0.38739419606
* device instance VSS_t484 r0 *1 0,0
RVSS_t484 VSS__t484 VSS 0.390432429818
* device instance VSS_t485 r0 *1 0,0
RVSS_t485 VSS__t485 VSS 0.393470747598
* device instance VSS_t486 r0 *1 0,0
RVSS_t486 VSS__t486 VSS 0.39650914747
* device instance VSS_t487 r0 *1 0,0
RVSS_t487 VSS__t487 VSS 0.399547627559
* device instance VSS_t488 r0 *1 0,0
RVSS_t488 VSS__t488 VSS 0.402586186051
* device instance VSS_t489 r0 *1 0,0
RVSS_t489 VSS__t489 VSS 0.405624821182
* device instance VSS_t490 r0 *1 0,0
RVSS_t490 VSS__t490 VSS 0.408663531244
* device instance VSS_t491 r0 *1 0,0
RVSS_t491 VSS__t491 VSS 0.411702314577
* device instance VSS_t492 r0 *1 0,0
RVSS_t492 VSS__t492 VSS 0.414741169571
* device instance VSS_t493 r0 *1 0,0
RVSS_t493 VSS__t493 VSS 0.417780094662
* device instance VSS_t494 r0 *1 0,0
RVSS_t494 VSS__t494 VSS 0.420819088331
* device instance VSS_t495 r0 *1 0,0
RVSS_t495 VSS__t495 VSS 0.423858149104
* device instance VSS_t496 r0 *1 0,0
RVSS_t496 VSS__t496 VSS 0.426897275547
* device instance VSS_t497 r0 *1 0,0
RVSS_t497 VSS__t497 VSS 0.429936466267
* device instance VSS_t498 r0 *1 0,0
RVSS_t498 VSS__t498 VSS 0.432975719911
* device instance VSS_t499 r0 *1 0,0
RVSS_t499 VSS__t499 VSS 0.436015035164
* device instance VSS_t500 r0 *1 0,0
RVSS_t500 VSS__t500 VSS 0.439054410745
* device instance VSS_t501 r0 *1 0,0
RVSS_t501 VSS__t501 VSS 0.442093845411
* device instance VSS_t502 r0 *1 0,0
RVSS_t502 VSS__t502 VSS 0.44513333795
* device instance VSS_t503 r0 *1 0,0
RVSS_t503 VSS__t503 VSS 0.448172887187
* device instance VSS_t504 r0 *1 0,0
RVSS_t504 VSS__t504 VSS 0.451212491974
* device instance VSS_t505 r0 *1 0,0
RVSS_t505 VSS__t505 VSS 0.454252151197
* device instance VSS_t506 r0 *1 0,0
RVSS_t506 VSS__t506 VSS 0.45729186377
* device instance VSS_t507 r0 *1 0,0
RVSS_t507 VSS__t507 VSS 0.460331628636
* device instance VSS_t508 r0 *1 0,0
RVSS_t508 VSS__t508 VSS 0.463371444767
* device instance VSS_t509 r0 *1 0,0
RVSS_t509 VSS__t509 VSS 0.46641131116
* device instance VSS_t510 r0 *1 0,0
RVSS_t510 VSS__t510 VSS 0.469451226837
* device instance VSS_t511 r0 *1 0,0
RVSS_t511 VSS__t511 VSS 0.472491190849
* device instance VSS_t512 r0 *1 0,0
RVSS_t512 VSS__t512 VSS 0.475531202269
* device instance VSS_t513 r0 *1 0,0
RVSS_t513 VSS__t513 VSS 0.478571260192
* device instance VSS_t514 r0 *1 0,0
RVSS_t514 VSS__t514 VSS 0.481611363738
* device instance VSS_t515 r0 *1 0,0
RVSS_t515 VSS__t515 VSS 0.484651512049
* device instance VSS_t516 r0 *1 0,0
RVSS_t516 VSS__t516 VSS 0.487691704287
* device instance VSS_t517 r0 *1 0,0
RVSS_t517 VSS__t517 VSS 0.490731939636
* device instance VSS_t518 r0 *1 0,0
RVSS_t518 VSS__t518 VSS 0.4937722173
* device instance VSS_t519 r0 *1 0,0
RVSS_t519 VSS__t519 VSS 0.496812536501
* device instance VSS_t520 r0 *1 0,0
RVSS_t520 VSS__t520 VSS 0.499852896483
* device instance VSS_t521 r0 *1 0,0
RVSS_t521 VSS__t521 VSS 0.502893296505
* device instance VSS_t522 r0 *1 0,0
RVSS_t522 VSS__t522 VSS 0.505933735845
* device instance VSS_t523 r0 *1 0,0
RVSS_t523 VSS__t523 VSS 0.508974213799
* device instance VSS_t524 r0 *1 0,0
RVSS_t524 VSS__t524 VSS 0.323275779274
* device instance VSS_t525 r0 *1 0,0
RVSS_t525 VSS__t525 VSS 0.326314823041
* device instance VSS_t526 r0 *1 0,0
RVSS_t526 VSS__t526 VSS 0.329353952241
* device instance VSS_t527 r0 *1 0,0
RVSS_t527 VSS__t527 VSS 0.332393164531
* device instance VSS_t528 r0 *1 0,0
RVSS_t528 VSS__t528 VSS 0.335432457652
* device instance VSS_t529 r0 *1 0,0
RVSS_t529 VSS__t529 VSS 0.338471829428
* device instance VSS_t530 r0 *1 0,0
RVSS_t530 VSS__t530 VSS 0.341511277757
* device instance VSS_t531 r0 *1 0,0
RVSS_t531 VSS__t531 VSS 0.344550800614
* device instance VSS_t532 r0 *1 0,0
RVSS_t532 VSS__t532 VSS 0.347590396043
* device instance VSS_t533 r0 *1 0,0
RVSS_t533 VSS__t533 VSS 0.350630062158
* device instance VSS_t534 r0 *1 0,0
RVSS_t534 VSS__t534 VSS 0.353669797136
* device instance VSS_t535 r0 *1 0,0
RVSS_t535 VSS__t535 VSS 0.356709599217
* device instance VSS_t536 r0 *1 0,0
RVSS_t536 VSS__t536 VSS 0.359749466698
* device instance VSS_t537 r0 *1 0,0
RVSS_t537 VSS__t537 VSS 0.362789397937
* device instance VSS_t538 r0 *1 0,0
RVSS_t538 VSS__t538 VSS 0.365829391344
* device instance VSS_t539 r0 *1 0,0
RVSS_t539 VSS__t539 VSS 0.368869445382
* device instance VSS_t540 r0 *1 0,0
RVSS_t540 VSS__t540 VSS 0.371909558564
* device instance VSS_t541 r0 *1 0,0
RVSS_t541 VSS__t541 VSS 0.374949729452
* device instance VSS_t542 r0 *1 0,0
RVSS_t542 VSS__t542 VSS 0.377989956652
* device instance VSS_t543 r0 *1 0,0
RVSS_t543 VSS__t543 VSS 0.381030238818
* device instance VSS_t544 r0 *1 0,0
RVSS_t544 VSS__t544 VSS 0.384070574643
* device instance VSS_t545 r0 *1 0,0
RVSS_t545 VSS__t545 VSS 0.387110962864
* device instance VSS_t546 r0 *1 0,0
RVSS_t546 VSS__t546 VSS 0.390151402255
* device instance VSS_t547 r0 *1 0,0
RVSS_t547 VSS__t547 VSS 0.39319189163
* device instance VSS_t548 r0 *1 0,0
RVSS_t548 VSS__t548 VSS 0.396232429838
* device instance VSS_t549 r0 *1 0,0
RVSS_t549 VSS__t549 VSS 0.399273015762
* device instance VSS_t550 r0 *1 0,0
RVSS_t550 VSS__t550 VSS 0.402313648323
* device instance VSS_t551 r0 *1 0,0
RVSS_t551 VSS__t551 VSS 0.405354326469
* device instance VSS_t552 r0 *1 0,0
RVSS_t552 VSS__t552 VSS 0.408395049183
* device instance VSS_t553 r0 *1 0,0
RVSS_t553 VSS__t553 VSS 0.411435815476
* device instance VSS_t554 r0 *1 0,0
RVSS_t554 VSS__t554 VSS 0.414476624389
* device instance VSS_t555 r0 *1 0,0
RVSS_t555 VSS__t555 VSS 0.417517474992
* device instance VSS_t556 r0 *1 0,0
RVSS_t556 VSS__t556 VSS 0.42055836638
* device instance VSS_t557 r0 *1 0,0
RVSS_t557 VSS__t557 VSS 0.423599297674
* device instance VSS_t558 r0 *1 0,0
RVSS_t558 VSS__t558 VSS 0.426640268021
* device instance VSS_t559 r0 *1 0,0
RVSS_t559 VSS__t559 VSS 0.429681276593
* device instance VSS_t560 r0 *1 0,0
RVSS_t560 VSS__t560 VSS 0.432722322582
* device instance VSS_t561 r0 *1 0,0
RVSS_t561 VSS__t561 VSS 0.435763405206
* device instance VSS_t562 r0 *1 0,0
RVSS_t562 VSS__t562 VSS 0.438804523703
* device instance VSS_t563 r0 *1 0,0
RVSS_t563 VSS__t563 VSS 0.441845677333
* device instance VSS_t564 r0 *1 0,0
RVSS_t564 VSS__t564 VSS 0.444886865375
* device instance VSS_t565 r0 *1 0,0
RVSS_t565 VSS__t565 VSS 0.447928087127
* device instance VSS_t566 r0 *1 0,0
RVSS_t566 VSS__t566 VSS 0.450969341908
* device instance VSS_t567 r0 *1 0,0
RVSS_t567 VSS__t567 VSS 0.454010629055
* device instance VSS_t568 r0 *1 0,0
RVSS_t568 VSS__t568 VSS 0.457051947921
* device instance VSS_t569 r0 *1 0,0
RVSS_t569 VSS__t569 VSS 0.460093297877
* device instance VSS_t570 r0 *1 0,0
RVSS_t570 VSS__t570 VSS 0.46313467831
* device instance VSS_t571 r0 *1 0,0
RVSS_t571 VSS__t571 VSS 0.466176088625
* device instance VSS_t572 r0 *1 0,0
RVSS_t572 VSS__t572 VSS 0.469217528239
* device instance VSS_t573 r0 *1 0,0
RVSS_t573 VSS__t573 VSS 0.472258996588
* device instance VSS_t574 r0 *1 0,0
RVSS_t574 VSS__t574 VSS 0.475300493119
* device instance VSS_t575 r0 *1 0,0
RVSS_t575 VSS__t575 VSS 0.478342017294
* device instance VSS_t576 r0 *1 0,0
RVSS_t576 VSS__t576 VSS 0.481383568591
* device instance VSS_t577 r0 *1 0,0
RVSS_t577 VSS__t577 VSS 0.484425146497
* device instance VSS_t578 r0 *1 0,0
RVSS_t578 VSS__t578 VSS 0.487466750515
* device instance VSS_t579 r0 *1 0,0
RVSS_t579 VSS__t579 VSS 0.490508380159
* device instance VSS_t580 r0 *1 0,0
RVSS_t580 VSS__t580 VSS 0.493550034956
* device instance VSS_t581 r0 *1 0,0
RVSS_t581 VSS__t581 VSS 0.496591714442
* device instance VSS_t582 r0 *1 0,0
RVSS_t582 VSS__t582 VSS 0.499633418168
* device instance VSS_t583 r0 *1 0,0
RVSS_t583 VSS__t583 VSS 0.502675145693
* device instance VSS_t584 r0 *1 0,0
RVSS_t584 VSS__t584 VSS 0.505716896587
* device instance VSS_t585 r0 *1 0,0
RVSS_t585 VSS__t585 VSS 0.508758670432
* device instance VSS_t586 r0 *1 0,0
RVSS_t586 VSS__t586 VSS 0.512014729679
* device instance VSS_t587 r0 *1 0,0
RVSS_t587 VSS__t587 VSS 0.511800466819
* device instance VSS r0 *1 0,0
CVSS VSS vsubs 2.42829522e-13
* device instance cc_OUTN_VSS r0 *1 0,0
Ccc_OUTN_VSS OUTN VSS 8.2638e-17
* device instance cc_OUTP_TAIL r0 *1 0,0
Ccc_OUTP_TAIL OUTP TAIL 6.5757e-16
* device instance cc_OUTP_VSS r0 *1 0,0
Ccc_OUTP_VSS OUTP VSS 2.365876e-15
* device instance vsubs_dctie r0 *1 0,0
Rvsubs_dctie vsubs 0 1e+12
.ENDS gf180_tmds_pad_ring_assembly
