* extracted by klt extract --deck gf180mcu

* cell tmds_encoder
* pin A1,A2,A3,ZN
* pin A1,A2,A3,ZN
* pin A1,A2,A3,data[2]
* pin A1,A2,A4,I,Q
* pin A1,A2,B,B2,C,Z
* pin A1,A2,B,ZN
* pin A1,A2,B,ZN
* pin A1,A2,B1,Z
* pin A1,A2,B2,Z
* pin A1,A2,B2,ZN
* pin A1,A2,C,I,de
* pin A1,A2,C,S,ZN
* pin A1,A2,I,Q
* pin A1,A2,I,ZN
* pin A1,A2,I,data[0]
* pin A1,A2,I0,ZN
* pin A1,A2,Q
* pin A1,A2,Z
* pin A1,A2,Z
* pin A1,A2,Z
* pin A1,A2,ZN
* pin A1,A2,ZN
* pin A1,A2,ZN
* pin A1,A2,ZN
* pin A1,A2,ZN
* pin A1,A2,ZN
* pin A1,A2,ZN
* pin A1,A2,ZN
* pin A1,A2,ZN
* pin A1,A2,ZN
* pin A1,A2,ZN
* pin A1,A2,data[3]
* pin A1,A3,B,Q
* pin A1,A3,B1,ZN
* pin A1,A3,I,Q
* pin A1,B,C,I,ZN
* pin A1,B,Z
* pin A1,B,Z
* pin A1,B,Z
* pin A1,B,Z
* pin A1,B,ZN
* pin A1,B,ZN
* pin A1,B,ZN
* pin A1,B1,Z
* pin A1,B1,ZN
* pin A1,B1,ZN
* pin A1,B2,ZN
* pin A1,B2,ZN
* pin A1,B3,ZN
* pin A1,C,Z
* pin A1,C,ZN
* pin A1,I,Q
* pin A1,I0,ZN
* pin A1,Q
* pin A1,Z
* pin A1,Z
* pin A1,Z
* pin A1,Z
* pin A1,Z
* pin A1,Z
* pin A1,Z
* pin A1,Z
* pin A1,Z
* pin A1,Z
* pin A1,ZN
* pin A1,ZN
* pin A1,ZN
* pin A1,ZN
* pin A1,ZN
* pin A1,ZN
* pin A1,ZN
* pin A1,ZN
* pin A1,ZN
* pin A1,ZN
* pin A1,ZN
* pin A1,ZN
* pin A1,ZN
* pin A1,ZN
* pin A1,ZN
* pin A1,ZN
* pin A1,ZN
* pin A1,ZN
* pin A1,ZN
* pin A1,ZN
* pin A1,ZN
* pin A1,ZN
* pin A1,ZN
* pin A1,ZN
* pin A1,ZN
* pin A1,ZN
* pin A1,ZN
* pin A1,ctrl[0]
* pin A1,data[1]
* pin A1,data[5]
* pin A1,data[6]
* pin A1,data[7]
* pin A2,A3,B,ZN
* pin A2,A3,I1,ZN
* pin A2,A3,Z
* pin A2,A3,Z
* pin A2,A3,Z
* pin A2,A3,Z
* pin A2,A3,ZN
* pin A2,A3,ZN
* pin A2,A3,ZN
* pin A2,A3,ZN
* pin A2,A3,ZN
* pin A2,A3,ZN
* pin A2,A3,ZN
* pin A2,A3,ZN
* pin A2,A3,ZN
* pin A2,A4,B1,ZN
* pin A2,B,ZN
* pin A2,B,ZN
* pin A2,B,ZN
* pin A2,B1,I,ZN
* pin A2,B2,Z
* pin A2,B2,ZN
* pin A2,B2,ZN
* pin A2,C,ZN
* pin A2,Z
* pin A2,Z
* pin A2,Z
* pin A2,Z
* pin A2,Z
* pin A2,Z
* pin A2,Z
* pin A2,Z
* pin A2,Z
* pin A2,Z
* pin A2,ZN
* pin A2,ZN
* pin A2,ZN
* pin A2,ZN
* pin A2,ZN
* pin A2,ZN
* pin A2,ZN
* pin A2,ZN
* pin A2,ZN
* pin A2,ZN
* pin A2,ZN
* pin A2,ZN
* pin A2,ZN
* pin A2,ZN
* pin A2,ZN
* pin A2,ZN
* pin A2,ZN
* pin A2,ZN
* pin A2,ZN
* pin A2,ZN
* pin A2,ZN
* pin A2,ZN
* pin A2,ZN
* pin A2,ZN
* pin A2,ZN
* pin A2,ZN
* pin A2,ZN
* pin A2,ZN
* pin A2,ZN
* pin A2,ZN
* pin A2,ZN
* pin A2,ZN
* pin A2,ZN
* pin A2,ZN
* pin A2,ZN
* pin A2,ZN
* pin A2,ZN
* pin A2,ZN
* pin A2,ZN
* pin A2,ZN
* pin A2,ZN
* pin A2,ZN
* pin A2,ZN
* pin A2,ZN
* pin A2,ZN
* pin A2,ZN
* pin A2,ZN
* pin A2,ZN
* pin A2,ZN
* pin A2,ZN
* pin A2,ZN
* pin A2,ZN
* pin A2,ZN
* pin A2,ZN
* pin A2,ZN
* pin A2,ZN
* pin A2,ZN
* pin A2,ZN
* pin A2,ZN
* pin A2,ZN
* pin A2,ZN
* pin A2,ZN
* pin A2,ZN
* pin A2,ZN
* pin A2,ZN
* pin A2,ZN
* pin A2,ctrl[1]
* pin A3,B,Z
* pin A3,B,ZN
* pin A3,B,ZN
* pin A3,B2,Z
* pin A3,B2,ZN
* pin A3,Z
* pin A3,Z
* pin A3,Z
* pin A3,ZN
* pin A3,ZN
* pin A3,ZN
* pin A3,ZN
* pin A3,ZN
* pin A4,Z
* pin B,C,Z
* pin B,C,ZN
* pin B,C,ZN
* pin B,Z
* pin B,Z
* pin B,Z
* pin B,ZN
* pin B,ZN
* pin B,ZN
* pin B,ZN
* pin B,ZN
* pin B,ZN
* pin B,ZN
* pin B,ZN
* pin B,ZN
* pin B,ZN
* pin B,ZN
* pin B,ZN
* pin B,ZN
* pin B,ZN
* pin B,ZN
* pin B,ZN
* pin B,ZN
* pin B,ZN
* pin B,ZN
* pin B,ZN
* pin B,ZN
* pin B,ZN
* pin B1,ZN
* pin B1,ZN
* pin B1,ZN
* pin B1,ZN
* pin B1,ZN
* pin B2,ZN
* pin C,ZN
* pin CLK,clk
* pin D,ZN
* pin D,ZN
* pin D,ZN
* pin D,ZN
* pin D,ZN
* pin D,ZN
* pin D,ZN
* pin D,ZN
* pin D,ZN
* pin D,ZN
* pin D,ZN
* pin D,ZN
* pin D,ZN
* pin D,ZN
* pin D,ZN
* pin D,ZN
* pin D,ZN
* pin I,ZN
* pin I,data[4]
* pin I,rst
* pin I1,Z
* pin Q,tmds[0]
* pin Q,tmds[1]
* pin Q,tmds[2]
* pin Q,tmds[3]
* pin Q,tmds[4]
* pin Q,tmds[5]
* pin Q,tmds[6]
* pin Q,tmds[7]
* pin Q,tmds[8]
* pin Q,tmds[9]
* pin S,ZN
* pin VDD
* pin VSS
* pin vsubs
.SUBCKT tmds_encoder A1|A2|A3|ZN A1|A2|A3|ZN$1 A1|A2|A3|data[2] A1|A2|A4|I|Q
+ A1|A2|B|B2|C|Z A1|A2|B|ZN A1|A2|B|ZN$1 A1|A2|B1|Z A1|A2|B2|Z A1|A2|B2|ZN
+ A1|A2|C|I|de A1|A2|C|S|ZN A1|A2|I|Q A1|A2|I|ZN A1|A2|I|data[0] A1|A2|I0|ZN
+ A1|A2|Q A1|A2|Z A1|A2|Z$1 A1|A2|Z$2 A1|A2|ZN A1|A2|ZN$1 A1|A2|ZN$2 A1|A2|ZN$3
+ A1|A2|ZN$4 A1|A2|ZN$5 A1|A2|ZN$6 A1|A2|ZN$7 A1|A2|ZN$8 A1|A2|ZN$9 A1|A2|ZN$10
+ A1|A2|data[3] A1|A3|B|Q A1|A3|B1|ZN A1|A3|I|Q A1|B|C|I|ZN A1|B|Z A1|B|Z$1
+ A1|B|Z$2 A1|B|Z$3 A1|B|ZN A1|B|ZN$1 A1|B|ZN$2 A1|B1|Z A1|B1|ZN A1|B1|ZN$1
+ A1|B2|ZN A1|B2|ZN$1 A1|B3|ZN A1|C|Z A1|C|ZN A1|I|Q A1|I0|ZN A1|Q A1|Z A1|Z$1
+ A1|Z$2 A1|Z$3 A1|Z$4 A1|Z$5 A1|Z$6 A1|Z$7 A1|Z$8 A1|Z$9 A1|ZN A1|ZN$1 A1|ZN$2
+ A1|ZN$3 A1|ZN$4 A1|ZN$5 A1|ZN$6 A1|ZN$7 A1|ZN$8 A1|ZN$9 A1|ZN$10 A1|ZN$11
+ A1|ZN$12 A1|ZN$13 A1|ZN$14 A1|ZN$15 A1|ZN$16 A1|ZN$17 A1|ZN$18 A1|ZN$19
+ A1|ZN$20 A1|ZN$21 A1|ZN$22 A1|ZN$23 A1|ZN$24 A1|ZN$25 A1|ZN$26 A1|ctrl[0]
+ A1|data[1] A1|data[5] A1|data[6] A1|data[7] A2|A3|B|ZN A2|A3|I1|ZN A2|A3|Z
+ A2|A3|Z$1 A2|A3|Z$2 A2|A3|Z$3 A2|A3|ZN A2|A3|ZN$1 A2|A3|ZN$2 A2|A3|ZN$3
+ A2|A3|ZN$4 A2|A3|ZN$5 A2|A3|ZN$6 A2|A3|ZN$7 A2|A3|ZN$8 A2|A4|B1|ZN A2|B|ZN
+ A2|B|ZN$1 A2|B|ZN$2 A2|B1|I|ZN A2|B2|Z A2|B2|ZN A2|B2|ZN$1 A2|C|ZN A2|Z
+ A2|Z$1 A2|Z$2 A2|Z$3 A2|Z$4 A2|Z$5 A2|Z$6 A2|Z$7 A2|Z$8 A2|Z$9 A2|ZN A2|ZN$1
+ A2|ZN$2 A2|ZN$3 A2|ZN$4 A2|ZN$5 A2|ZN$6 A2|ZN$7 A2|ZN$8 A2|ZN$9 A2|ZN$10
+ A2|ZN$11 A2|ZN$12 A2|ZN$13 A2|ZN$14 A2|ZN$15 A2|ZN$16 A2|ZN$17 A2|ZN$18
+ A2|ZN$19 A2|ZN$20 A2|ZN$21 A2|ZN$22 A2|ZN$23 A2|ZN$24 A2|ZN$25 A2|ZN$26
+ A2|ZN$27 A2|ZN$28 A2|ZN$29 A2|ZN$30 A2|ZN$31 A2|ZN$32 A2|ZN$33 A2|ZN$34
+ A2|ZN$35 A2|ZN$36 A2|ZN$37 A2|ZN$38 A2|ZN$39 A2|ZN$40 A2|ZN$41 A2|ZN$42
+ A2|ZN$43 A2|ZN$44 A2|ZN$45 A2|ZN$46 A2|ZN$47 A2|ZN$48 A2|ZN$49 A2|ZN$50
+ A2|ZN$51 A2|ZN$52 A2|ZN$53 A2|ZN$54 A2|ZN$55 A2|ZN$56 A2|ZN$57 A2|ZN$58
+ A2|ZN$59 A2|ZN$60 A2|ZN$61 A2|ZN$62 A2|ZN$63 A2|ZN$64 A2|ZN$65 A2|ctrl[1]
+ A3|B|Z A3|B|ZN A3|B|ZN$1 A3|B2|Z A3|B2|ZN A3|Z A3|Z$1 A3|Z$2 A3|ZN A3|ZN$1
+ A3|ZN$2 A3|ZN$3 A3|ZN$4 A4|Z B|C|Z B|C|ZN B|C|ZN$1 B|Z B|Z$1 B|Z$2 B|ZN
+ B|ZN$1 B|ZN$2 B|ZN$3 B|ZN$4 B|ZN$5 B|ZN$6 B|ZN$7 B|ZN$8 B|ZN$9 B|ZN$10
+ B|ZN$11 B|ZN$12 B|ZN$13 B|ZN$14 B|ZN$15 B|ZN$16 B|ZN$17 B|ZN$18 B|ZN$19
+ B|ZN$20 B|ZN$21 B1|ZN B1|ZN$1 B1|ZN$2 B1|ZN$3 B1|ZN$4 B2|ZN C|ZN CLK|clk D|ZN
+ D|ZN$1 D|ZN$2 D|ZN$3 D|ZN$4 D|ZN$5 D|ZN$6 D|ZN$7 D|ZN$8 D|ZN$9 D|ZN$10
+ D|ZN$11 D|ZN$12 D|ZN$13 D|ZN$14 D|ZN$15 D|ZN$16 I|ZN I|data[4] I|rst I1|Z
+ Q|tmds[0] Q|tmds[1] Q|tmds[2] Q|tmds[3] Q|tmds[4] Q|tmds[5] Q|tmds[6]
+ Q|tmds[7] Q|tmds[8] Q|tmds[9] S|ZN VDD VSS vsubs
* device instance $1 r0 *1 67.64,6.045 nfet
M$1 Q|tmds[8] \$16 VSS vsubs nfet L=0.6U W=1.32U AS=0.5808P AD=0.5808P PS=3.52U
+ PD=3.52U
* device instance $2 r0 *1 87.72,6.045 nfet
M$2 \$28 A2|ctrl[1] VSS vsubs nfet L=0.6U W=1.32U AS=0.5808P AD=0.2112P
+ PS=3.52U PD=1.64U
* device instance $3 r0 *1 88.64,6.045 nfet
M$3 B1|ZN A1|ctrl[0] \$28 vsubs nfet L=0.6U W=1.32U AS=0.2112P AD=0.402P
+ PS=1.64U PD=2.02U
* device instance $4 r0 *1 89.94,6.245 nfet
M$4 VSS B|ZN B1|ZN vsubs nfet L=0.6U W=0.92U AS=0.402P AD=0.4048P PS=2.02U
+ PD=2.72U
* device instance $5 r0 *1 54.12,6.31 nfet
M$5 VSS CLK|clk \$20 vsubs nfet L=0.6U W=0.79U AS=0.3476P AD=0.2054P PS=2.46U
+ PD=1.31U
* device instance $6 r0 *1 55.24,6.31 nfet
M$6 \$14 \$20 VSS vsubs nfet L=0.6U W=0.79U AS=0.2054P AD=0.3476P PS=1.31U
+ PD=2.46U
* device instance $7 r0 *1 57.08,6.415 nfet
M$7 \$25 \$20 VSS vsubs nfet L=0.6U W=0.58U AS=0.2552P AD=0.0696P PS=2.04U
+ PD=0.82U
* device instance $8 r0 *1 57.92,6.415 nfet
M$8 \$22 D|ZN \$25 vsubs nfet L=0.6U W=0.58U AS=0.0696P AD=0.1508P PS=0.82U
+ PD=1.1U
* device instance $9 r0 *1 59.04,6.415 nfet
M$9 \$26 \$14 \$22 vsubs nfet L=0.6U W=0.58U AS=0.1508P AD=0.0696P PS=1.1U
+ PD=0.82U
* device instance $10 r0 *1 59.88,6.415 nfet
M$10 \$26 \$15 VSS vsubs nfet L=0.6U W=0.58U AS=0.39315P AD=0.0696P PS=2.35U
+ PD=0.82U
* device instance $11 r0 *1 61.38,6.415 nfet
M$11 \$15 \$22 VSS vsubs nfet L=0.6U W=0.58U AS=0.39315P AD=0.1508P PS=2.35U
+ PD=1.1U
* device instance $12 r0 *1 62.5,6.415 nfet
M$12 \$23 \$14 \$15 vsubs nfet L=0.6U W=0.58U AS=0.1508P AD=0.1508P PS=1.1U
+ PD=1.1U
* device instance $13 r0 *1 63.62,6.415 nfet
M$13 \$27 \$20 \$23 vsubs nfet L=0.6U W=0.58U AS=0.1508P AD=0.0696P PS=1.1U
+ PD=0.82U
* device instance $14 r0 *1 64.46,6.415 nfet
M$14 \$27 \$16 VSS vsubs nfet L=0.6U W=0.58U AS=0.252P AD=0.0696P PS=1.49U
+ PD=0.82U
* device instance $15 r0 *1 65.8,6.33 nfet
M$15 \$16 \$23 VSS vsubs nfet L=0.6U W=0.75U AS=0.252P AD=0.33P PS=1.49U
+ PD=2.38U
* device instance $16 r0 *1 121.88,6.34 nfet
M$16 A1|ZN I|data[4] VSS vsubs nfet L=0.6U W=0.73U AS=0.3212P AD=0.3212P
+ PS=2.34U PD=2.34U
* device instance $17 r0 *1 32.84,13.85 nfet
M$17 VSS CLK|clk \$39 vsubs nfet L=0.6U W=0.79U AS=0.3476P AD=0.2054P PS=2.46U
+ PD=1.31U
* device instance $18 r0 *1 33.96,13.85 nfet
M$18 \$47 \$39 VSS vsubs nfet L=0.6U W=0.79U AS=0.2054P AD=0.3476P PS=1.31U
+ PD=2.46U
* device instance $19 r0 *1 35.8,13.745 nfet
M$19 \$89 \$39 VSS vsubs nfet L=0.6U W=0.58U AS=0.2552P AD=0.0696P PS=2.04U
+ PD=0.82U
* device instance $20 r0 *1 36.64,13.745 nfet
M$20 \$49 D|ZN$1 \$89 vsubs nfet L=0.6U W=0.58U AS=0.0696P AD=0.1508P PS=0.82U
+ PD=1.1U
* device instance $21 r0 *1 37.76,13.745 nfet
M$21 \$90 \$47 \$49 vsubs nfet L=0.6U W=0.58U AS=0.1508P AD=0.0696P PS=1.1U
+ PD=0.82U
* device instance $22 r0 *1 38.6,13.745 nfet
M$22 VSS \$50 \$90 vsubs nfet L=0.6U W=0.58U AS=0.0696P AD=0.39315P PS=0.82U
+ PD=2.35U
* device instance $23 r0 *1 40.1,13.745 nfet
M$23 \$50 \$49 VSS vsubs nfet L=0.6U W=0.58U AS=0.39315P AD=0.1508P PS=2.35U
+ PD=1.1U
* device instance $24 r0 *1 41.22,13.745 nfet
M$24 \$51 \$47 \$50 vsubs nfet L=0.6U W=0.58U AS=0.1508P AD=0.1508P PS=1.1U
+ PD=1.1U
* device instance $25 r0 *1 42.34,13.745 nfet
M$25 \$91 \$39 \$51 vsubs nfet L=0.6U W=0.58U AS=0.1508P AD=0.0696P PS=1.1U
+ PD=0.82U
* device instance $26 r0 *1 43.18,13.745 nfet
M$26 VSS \$52 \$91 vsubs nfet L=0.6U W=0.58U AS=0.0696P AD=0.252P PS=0.82U
+ PD=1.49U
* device instance $27 r0 *1 44.52,13.83 nfet
M$27 \$52 \$51 VSS vsubs nfet L=0.6U W=0.75U AS=0.252P AD=0.33P PS=1.49U
+ PD=2.38U
* device instance $28 r0 *1 46.36,14.115 nfet
M$28 Q|tmds[0] \$52 VSS vsubs nfet L=0.6U W=1.32U AS=0.5808P AD=0.5808P
+ PS=3.52U PD=3.52U
* device instance $29 r0 *1 67.56,13.85 nfet
M$29 VSS CLK|clk \$40 vsubs nfet L=0.6U W=0.79U AS=0.3476P AD=0.2054P PS=2.46U
+ PD=1.31U
* device instance $30 r0 *1 68.68,13.85 nfet
M$30 \$53 \$40 VSS vsubs nfet L=0.6U W=0.79U AS=0.2054P AD=0.3476P PS=1.31U
+ PD=2.46U
* device instance $31 r0 *1 70.52,13.745 nfet
M$31 \$93 \$40 VSS vsubs nfet L=0.6U W=0.58U AS=0.2552P AD=0.0696P PS=2.04U
+ PD=0.82U
* device instance $32 r0 *1 71.36,13.745 nfet
M$32 \$54 D|ZN$3 \$93 vsubs nfet L=0.6U W=0.58U AS=0.0696P AD=0.1508P PS=0.82U
+ PD=1.1U
* device instance $33 r0 *1 72.48,13.745 nfet
M$33 \$94 \$53 \$54 vsubs nfet L=0.6U W=0.58U AS=0.1508P AD=0.0696P PS=1.1U
+ PD=0.82U
* device instance $34 r0 *1 73.32,13.745 nfet
M$34 VSS \$55 \$94 vsubs nfet L=0.6U W=0.58U AS=0.0696P AD=0.39315P PS=0.82U
+ PD=2.35U
* device instance $35 r0 *1 74.82,13.745 nfet
M$35 \$55 \$54 VSS vsubs nfet L=0.6U W=0.58U AS=0.39315P AD=0.1508P PS=2.35U
+ PD=1.1U
* device instance $36 r0 *1 75.94,13.745 nfet
M$36 \$56 \$53 \$55 vsubs nfet L=0.6U W=0.58U AS=0.1508P AD=0.1508P PS=1.1U
+ PD=1.1U
* device instance $37 r0 *1 77.06,13.745 nfet
M$37 \$95 \$40 \$56 vsubs nfet L=0.6U W=0.58U AS=0.1508P AD=0.0696P PS=1.1U
+ PD=0.82U
* device instance $38 r0 *1 77.9,13.745 nfet
M$38 VSS \$57 \$95 vsubs nfet L=0.6U W=0.58U AS=0.0696P AD=0.252P PS=0.82U
+ PD=1.49U
* device instance $39 r0 *1 79.24,13.83 nfet
M$39 \$57 \$56 VSS vsubs nfet L=0.6U W=0.75U AS=0.252P AD=0.33P PS=1.49U
+ PD=2.38U
* device instance $40 r0 *1 81.08,14.115 nfet
M$40 Q|tmds[2] \$57 VSS vsubs nfet L=0.6U W=1.32U AS=0.5808P AD=0.5808P
+ PS=3.52U PD=3.52U
* device instance $41 r0 *1 87.72,13.82 nfet
M$41 A2|B|ZN I|rst VSS vsubs nfet L=0.6U W=0.73U AS=0.3212P AD=0.3212P PS=2.34U
+ PD=2.34U
* device instance $42 r0 *1 89.96,14.115 nfet
M$42 B|ZN A2|ctrl[1] \$85 vsubs nfet L=0.6U W=1.32U AS=0.5808P AD=0.3432P
+ PS=3.52U PD=1.84U
* device instance $43 r0 *1 91.08,14.115 nfet
M$43 \$85 A1|ctrl[0] B|ZN vsubs nfet L=0.6U W=1.32U AS=0.3432P AD=0.3432P
+ PS=1.84U PD=1.84U
* device instance $44 r0 *1 92.2,14.115 nfet
M$44 VSS A2|B|ZN \$85 vsubs nfet L=0.6U W=1.32U AS=0.3432P AD=0.5808P PS=1.84U
+ PD=3.52U
* device instance $45 r0 *1 101.48,14.115 nfet
M$45 VSS \$58 Q|tmds[4] vsubs nfet L=0.6U W=1.32U AS=0.5808P AD=0.5808P
+ PS=3.52U PD=3.52U
* device instance $46 r0 *1 104.66,13.745 nfet
M$46 \$92 \$58 VSS vsubs nfet L=0.6U W=0.58U AS=0.252P AD=0.0696P PS=1.49U
+ PD=0.82U
* device instance $47 r0 *1 105.5,13.745 nfet
M$47 \$59 \$42 \$92 vsubs nfet L=0.6U W=0.58U AS=0.0696P AD=0.1508P PS=0.82U
+ PD=1.1U
* device instance $48 r0 *1 106.62,13.745 nfet
M$48 \$61 \$60 \$59 vsubs nfet L=0.6U W=0.58U AS=0.1508P AD=0.1508P PS=1.1U
+ PD=1.1U
* device instance $49 r0 *1 107.74,13.745 nfet
M$49 VSS \$62 \$61 vsubs nfet L=0.6U W=0.58U AS=0.1508P AD=0.39315P PS=1.1U
+ PD=2.35U
* device instance $50 r0 *1 109.24,13.745 nfet
M$50 \$88 \$61 VSS vsubs nfet L=0.6U W=0.58U AS=0.39315P AD=0.0696P PS=2.35U
+ PD=0.82U
* device instance $51 r0 *1 110.08,13.745 nfet
M$51 \$62 \$60 \$88 vsubs nfet L=0.6U W=0.58U AS=0.0696P AD=0.1508P PS=0.82U
+ PD=1.1U
* device instance $52 r0 *1 111.2,13.745 nfet
M$52 \$87 D|ZN$2 \$62 vsubs nfet L=0.6U W=0.58U AS=0.1508P AD=0.0696P PS=1.1U
+ PD=0.82U
* device instance $53 r0 *1 112.04,13.745 nfet
M$53 VSS \$42 \$87 vsubs nfet L=0.6U W=0.58U AS=0.0696P AD=0.2552P PS=0.82U
+ PD=2.04U
* device instance $54 r0 *1 103.32,13.83 nfet
M$54 VSS \$59 \$58 vsubs nfet L=0.6U W=0.75U AS=0.33P AD=0.252P PS=2.38U
+ PD=1.49U
* device instance $55 r0 *1 113.88,13.85 nfet
M$55 VSS \$42 \$60 vsubs nfet L=0.6U W=0.79U AS=0.3476P AD=0.2054P PS=2.46U
+ PD=1.31U
* device instance $56 r0 *1 115,13.85 nfet
M$56 \$42 CLK|clk VSS vsubs nfet L=0.6U W=0.79U AS=0.2054P AD=0.3476P PS=1.31U
+ PD=2.46U
* device instance $57 r0 *1 127.06,13.96 nfet
M$57 \$66 \$65 VSS vsubs nfet L=0.6U W=0.66U AS=0.2904P AD=0.1716P PS=2.2U
+ PD=1.18U
* device instance $58 r0 *1 128.18,13.96 nfet
M$58 \$66 A1|A2|A3|data[2] VSS vsubs nfet L=0.6U W=0.66U AS=0.363P AD=0.1716P
+ PS=2.02U PD=1.18U
* device instance $59 r0 *1 129.48,14.115 nfet
M$59 A2|A3|Z \$66 VSS vsubs nfet L=0.6U W=1.32U AS=0.363P AD=0.3432P PS=2.02U
+ PD=1.84U
* device instance $60 r0 *1 130.6,14.115 nfet
M$60 \$96 A1|A2|A3|data[2] A2|A3|Z vsubs nfet L=0.6U W=1.32U AS=0.3432P
+ AD=0.2112P PS=1.84U PD=1.64U
* device instance $61 r0 *1 131.52,14.115 nfet
M$61 VSS \$65 \$96 vsubs nfet L=0.6U W=1.32U AS=0.2112P AD=0.5808P PS=1.64U
+ PD=3.52U
* device instance $62 r0 *1 14.76,14.08 nfet
M$62 A2|ZN A1|A2|A3|data[2] VSS vsubs nfet L=0.6U W=0.92U AS=0.4048P AD=0.2392P
+ PS=2.72U PD=1.44U
* device instance $63 r0 *1 15.88,14.08 nfet
M$63 VSS A1|A2|Z A2|ZN vsubs nfet L=0.6U W=0.92U AS=0.2392P AD=0.4048P PS=1.44U
+ PD=2.72U
* device instance $64 r0 *1 16.655,15.795 nfet
M$64 \$99 A1|Z VSS vsubs nfet L=0.6U W=0.66U AS=0.2904P AD=0.1716P PS=2.2U
+ PD=1.18U
* device instance $65 r0 *1 17.775,15.795 nfet
M$65 VSS A2|ZN \$99 vsubs nfet L=0.6U W=0.66U AS=0.1716P AD=0.3828P PS=1.18U
+ PD=2.08U
* device instance $66 r0 *1 19.135,16.125 nfet
M$66 A1|Z$1 \$99 VSS vsubs nfet L=0.6U W=1.32U AS=0.3828P AD=0.5808P PS=2.08U
+ PD=3.52U
* device instance $67 r0 *1 22.76,13.99 nfet
M$67 \$44 A1|A2|I|data[0] VSS vsubs nfet L=0.6U W=0.66U AS=0.2904P AD=0.1716P
+ PS=2.2U PD=1.18U
* device instance $68 r0 *1 23.88,13.99 nfet
M$68 \$44 A1|data[1] VSS vsubs nfet L=0.6U W=0.66U AS=0.363P AD=0.1716P
+ PS=2.02U PD=1.18U
* device instance $69 r0 *1 25.18,14.12 nfet
M$69 A1|A2|Z \$44 VSS vsubs nfet L=0.6U W=1.32U AS=0.363P AD=0.3432P PS=2.02U
+ PD=1.84U
* device instance $70 r0 *1 26.3,14.12 nfet
M$70 \$97 A1|data[1] A1|A2|Z vsubs nfet L=0.6U W=1.32U AS=0.3432P AD=0.2112P
+ PS=1.84U PD=1.64U
* device instance $71 r0 *1 27.22,14.12 nfet
M$71 VSS A1|A2|I|data[0] \$97 vsubs nfet L=0.6U W=1.32U AS=0.2112P AD=0.5808P
+ PS=1.64U PD=3.52U
* device instance $72 r0 *1 25.04,16.455 nfet
M$72 \$129 A2|ZN$1 \$101 vsubs nfet L=0.6U W=0.66U AS=0.2904P AD=0.1056P
+ PS=2.2U PD=0.98U
* device instance $73 r0 *1 25.96,16.455 nfet
M$73 \$129 A1|Z$1 VSS vsubs nfet L=0.6U W=0.66U AS=0.363P AD=0.1056P PS=2.02U
+ PD=0.98U
* device instance $74 r0 *1 27.26,16.125 nfet
M$74 \$103 \$101 VSS vsubs nfet L=0.6U W=1.32U AS=0.363P AD=0.3432P PS=2.02U
+ PD=1.84U
* device instance $75 r0 *1 28.38,16.125 nfet
M$75 A2|ZN$4 A1|Z$1 \$103 vsubs nfet L=0.6U W=1.32U AS=0.3432P AD=0.3432P
+ PS=1.84U PD=1.84U
* device instance $76 r0 *1 29.5,16.125 nfet
M$76 \$103 A2|ZN$1 A2|ZN$4 vsubs nfet L=0.6U W=1.32U AS=0.3432P AD=0.5808P
+ PS=1.84U PD=3.52U
* device instance $77 r0 *1 35.08,16.125 nfet
M$77 \$131 A2|ZN$5 VSS vsubs nfet L=0.6U W=1.32U AS=0.5808P AD=0.2112P PS=3.52U
+ PD=1.64U
* device instance $78 r0 *1 36,16.125 nfet
M$78 D|ZN$1 A1|A2|C|I|de \$131 vsubs nfet L=0.6U W=1.32U AS=0.2112P AD=0.402P
+ PS=1.64U PD=2.02U
* device instance $79 r0 *1 37.3,16.325 nfet
M$79 VSS B|ZN$1 D|ZN$1 vsubs nfet L=0.6U W=0.92U AS=0.402P AD=0.4048P PS=2.02U
+ PD=2.72U
* device instance $80 r0 *1 56.44,16.125 nfet
M$80 Q|tmds[1] \$106 VSS vsubs nfet L=0.6U W=1.32U AS=0.5808P AD=0.5808P
+ PS=3.52U PD=3.52U
* device instance $81 r0 *1 62.52,16.125 nfet
M$81 D|ZN$3 A2|ZN$4 \$107 vsubs nfet L=0.6U W=1.32U AS=0.5808P AD=0.3432P
+ PS=3.52U PD=1.84U
* device instance $82 r0 *1 63.64,16.125 nfet
M$82 \$107 A1|B|ZN D|ZN$3 vsubs nfet L=0.6U W=1.32U AS=0.3432P AD=0.3432P
+ PS=1.84U PD=1.84U
* device instance $83 r0 *1 64.76,16.125 nfet
M$83 VSS A1|B|ZN$1 \$107 vsubs nfet L=0.6U W=1.32U AS=0.3432P AD=0.5808P
+ PS=1.84U PD=3.52U
* device instance $84 r0 *1 88.28,16.125 nfet
M$84 B|ZN$1 A1|A2|C|I|de \$108 vsubs nfet L=0.6U W=1.32U AS=0.5808P AD=0.3432P
+ PS=3.52U PD=1.84U
* device instance $85 r0 *1 89.4,16.125 nfet
M$85 \$108 A1|ctrl[0] B|ZN$1 vsubs nfet L=0.6U W=1.32U AS=0.3432P AD=0.3432P
+ PS=1.84U PD=1.84U
* device instance $86 r0 *1 90.52,16.125 nfet
M$86 VSS A2|B|ZN \$108 vsubs nfet L=0.6U W=1.32U AS=0.3432P AD=0.5808P PS=1.84U
+ PD=3.52U
* device instance $87 r0 *1 93.325,16.125 nfet
M$87 \$138 A2|B|ZN VSS vsubs nfet L=0.6U W=1.32U AS=0.5808P AD=0.2112P PS=3.52U
+ PD=1.64U
* device instance $88 r0 *1 94.245,16.125 nfet
M$88 A2|ZN$2 A1|ctrl[0] \$138 vsubs nfet L=0.6U W=1.32U AS=0.2112P AD=0.5808P
+ PS=1.64U PD=3.52U
* device instance $89 r0 *1 107.08,16.125 nfet
M$89 VSS \$110 Q|tmds[6] vsubs nfet L=0.6U W=1.32U AS=0.5808P AD=0.5808P
+ PS=3.52U PD=3.52U
* device instance $90 r0 *1 120.76,14.11 nfet
M$90 \$83 A1|A2|I|data[0] VSS vsubs nfet L=0.6U W=0.36U AS=0.1584P AD=0.0936P
+ PS=1.6U PD=0.88U
* device instance $91 r0 *1 121.88,14.11 nfet
M$91 \$83 A1|data[1] VSS vsubs nfet L=0.6U W=0.36U AS=0.186P AD=0.0936P
+ PS=1.36U PD=0.88U
* device instance $92 r0 *1 123.18,13.96 nfet
M$92 \$65 \$83 VSS vsubs nfet L=0.6U W=0.66U AS=0.186P AD=0.1716P PS=1.36U
+ PD=1.18U
* device instance $93 r0 *1 124.3,13.96 nfet
M$93 \$86 A1|data[1] \$65 vsubs nfet L=0.6U W=0.66U AS=0.1716P AD=0.1056P
+ PS=1.18U PD=0.98U
* device instance $94 r0 *1 125.22,13.96 nfet
M$94 VSS A1|A2|I|data[0] \$86 vsubs nfet L=0.6U W=0.66U AS=0.1056P AD=0.2904P
+ PS=0.98U PD=2.2U
* device instance $95 r0 *1 125.24,16.125 nfet
M$95 \$130 A1|A2|Z VSS vsubs nfet L=0.6U W=1.32U AS=0.5808P AD=0.2112P PS=3.52U
+ PD=1.64U
* device instance $96 r0 *1 126.16,16.125 nfet
M$96 A2|ZN$3 A1|A2|A3|data[2] \$130 vsubs nfet L=0.6U W=1.32U AS=0.2112P
+ AD=0.402P PS=1.64U PD=2.02U
* device instance $97 r0 *1 127.46,16.325 nfet
M$97 VSS A3|B|Z A2|ZN$3 vsubs nfet L=0.6U W=0.92U AS=0.402P AD=0.4048P PS=2.02U
+ PD=2.72U
* device instance $98 r0 *1 140.365,16.125 nfet
M$98 \$127 A2|ZN$3 VSS vsubs nfet L=0.6U W=1.32U AS=0.5808P AD=0.2112P PS=3.52U
+ PD=1.64U
* device instance $99 r0 *1 141.285,16.125 nfet
M$99 A1|ZN$1 A1|ZN$2 \$127 vsubs nfet L=0.6U W=1.32U AS=0.2112P AD=0.5808P
+ PS=1.64U PD=3.52U
* device instance $100 r0 *1 12.12,16.455 nfet
M$100 \$128 A1|A2|A3|data[2] \$118 vsubs nfet L=0.6U W=0.66U AS=0.2904P
+ AD=0.1056P PS=2.2U PD=0.98U
* device instance $101 r0 *1 13.04,16.455 nfet
M$101 \$128 A1|A2|Z VSS vsubs nfet L=0.6U W=0.66U AS=0.3894P AD=0.1056P
+ PS=2.06U PD=0.98U
* device instance $102 r0 *1 14.38,16.125 nfet
M$102 A1|Z \$118 VSS vsubs nfet L=0.6U W=1.32U AS=0.3894P AD=0.5808P PS=2.06U
+ PD=3.52U
* device instance $103 r0 *1 26.72,23.865 nfet
M$103 \$187 A2|ZN$1 \$159 vsubs nfet L=0.6U W=0.66U AS=0.2904P AD=0.1056P
+ PS=2.2U PD=0.98U
* device instance $104 r0 *1 27.64,23.865 nfet
M$104 VSS A1|B2|ZN \$187 vsubs nfet L=0.6U W=0.66U AS=0.1056P AD=0.363P
+ PS=0.98U PD=2.02U
* device instance $105 r0 *1 28.94,24.195 nfet
M$105 \$182 \$159 VSS vsubs nfet L=0.6U W=1.32U AS=0.363P AD=0.3432P PS=2.02U
+ PD=1.84U
* device instance $106 r0 *1 30.06,24.195 nfet
M$106 A2|ZN$5 A1|B2|ZN \$182 vsubs nfet L=0.6U W=1.32U AS=0.3432P AD=0.3432P
+ PS=1.84U PD=1.84U
* device instance $107 r0 *1 31.18,24.195 nfet
M$107 \$182 A2|ZN$1 A2|ZN$5 vsubs nfet L=0.6U W=1.32U AS=0.3432P AD=0.5808P
+ PS=1.84U PD=3.52U
* device instance $108 r0 *1 43.46,23.995 nfet
M$108 VSS B|ZN$1 D|ZN$4 vsubs nfet L=0.6U W=0.92U AS=0.402P AD=0.4048P PS=2.02U
+ PD=2.72U
* device instance $109 r0 *1 41.24,24.195 nfet
M$109 \$194 A2|ZN$8 VSS vsubs nfet L=0.6U W=1.32U AS=0.5808P AD=0.2112P
+ PS=3.52U PD=1.64U
* device instance $110 r0 *1 42.16,24.195 nfet
M$110 D|ZN$4 A1|A2|C|I|de \$194 vsubs nfet L=0.6U W=1.32U AS=0.2112P AD=0.402P
+ PS=1.64U PD=2.02U
* device instance $111 r0 *1 42.92,16.39 nfet
M$111 VSS CLK|clk \$120 vsubs nfet L=0.6U W=0.79U AS=0.3476P AD=0.2054P
+ PS=2.46U PD=1.31U
* device instance $112 r0 *1 44.04,16.39 nfet
M$112 \$104 \$120 VSS vsubs nfet L=0.6U W=0.79U AS=0.2054P AD=0.3476P PS=1.31U
+ PD=2.46U
* device instance $113 r0 *1 45.88,16.495 nfet
M$113 \$133 \$120 VSS vsubs nfet L=0.6U W=0.58U AS=0.2552P AD=0.0696P PS=2.04U
+ PD=0.82U
* device instance $114 r0 *1 46.72,16.495 nfet
M$114 \$122 D|ZN$4 \$133 vsubs nfet L=0.6U W=0.58U AS=0.0696P AD=0.1508P
+ PS=0.82U PD=1.1U
* device instance $115 r0 *1 47.84,16.495 nfet
M$115 \$134 \$104 \$122 vsubs nfet L=0.6U W=0.58U AS=0.1508P AD=0.0696P PS=1.1U
+ PD=0.82U
* device instance $116 r0 *1 48.68,16.495 nfet
M$116 \$134 \$105 VSS vsubs nfet L=0.6U W=0.58U AS=0.39315P AD=0.0696P PS=2.35U
+ PD=0.82U
* device instance $117 r0 *1 50.18,16.495 nfet
M$117 \$105 \$122 VSS vsubs nfet L=0.6U W=0.58U AS=0.39315P AD=0.1508P PS=2.35U
+ PD=1.1U
* device instance $118 r0 *1 51.3,16.495 nfet
M$118 \$123 \$104 \$105 vsubs nfet L=0.6U W=0.58U AS=0.1508P AD=0.1508P PS=1.1U
+ PD=1.1U
* device instance $119 r0 *1 52.42,16.495 nfet
M$119 \$135 \$120 \$123 vsubs nfet L=0.6U W=0.58U AS=0.1508P AD=0.0696P PS=1.1U
+ PD=0.82U
* device instance $120 r0 *1 53.26,16.495 nfet
M$120 \$135 \$106 VSS vsubs nfet L=0.6U W=0.58U AS=0.252P AD=0.0696P PS=1.49U
+ PD=0.82U
* device instance $121 r0 *1 54.6,16.41 nfet
M$121 \$106 \$123 VSS vsubs nfet L=0.6U W=0.75U AS=0.252P AD=0.33P PS=1.49U
+ PD=2.38U
* device instance $122 r0 *1 60.28,24.195 nfet
M$122 D|ZN A1|A2|B|ZN \$183 vsubs nfet L=0.6U W=1.32U AS=0.5808P AD=0.3432P
+ PS=3.52U PD=1.84U
* device instance $123 r0 *1 61.4,24.195 nfet
M$123 \$183 A1|B|ZN D|ZN vsubs nfet L=0.6U W=1.32U AS=0.3432P AD=0.3432P
+ PS=1.84U PD=1.84U
* device instance $124 r0 *1 62.52,24.195 nfet
M$124 VSS A1|B|ZN$1 \$183 vsubs nfet L=0.6U W=1.32U AS=0.3432P AD=0.5808P
+ PS=1.84U PD=3.52U
* device instance $125 r0 *1 72.6,23.9 nfet
M$125 B2|ZN A1|B|C|I|ZN VSS vsubs nfet L=0.6U W=0.73U AS=0.3212P AD=0.3212P
+ PS=2.34U PD=2.34U
* device instance $126 r0 *1 74.84,23.93 nfet
M$126 VSS CLK|clk \$163 vsubs nfet L=0.6U W=0.79U AS=0.3476P AD=0.2054P
+ PS=2.46U PD=1.31U
* device instance $127 r0 *1 75.96,23.93 nfet
M$127 \$174 \$163 VSS vsubs nfet L=0.6U W=0.79U AS=0.2054P AD=0.3476P PS=1.31U
+ PD=2.46U
* device instance $128 r0 *1 77.8,23.825 nfet
M$128 \$189 \$163 VSS vsubs nfet L=0.6U W=0.58U AS=0.2552P AD=0.0696P PS=2.04U
+ PD=0.82U
* device instance $129 r0 *1 78.64,23.825 nfet
M$129 \$175 D|ZN$6 \$189 vsubs nfet L=0.6U W=0.58U AS=0.0696P AD=0.1508P
+ PS=0.82U PD=1.1U
* device instance $130 r0 *1 79.76,23.825 nfet
M$130 \$188 \$174 \$175 vsubs nfet L=0.6U W=0.58U AS=0.1508P AD=0.0696P PS=1.1U
+ PD=0.82U
* device instance $131 r0 *1 80.6,23.825 nfet
M$131 VSS \$164 \$188 vsubs nfet L=0.6U W=0.58U AS=0.0696P AD=0.39315P PS=0.82U
+ PD=2.35U
* device instance $132 r0 *1 82.1,23.825 nfet
M$132 \$164 \$175 VSS vsubs nfet L=0.6U W=0.58U AS=0.39315P AD=0.1508P PS=2.35U
+ PD=1.1U
* device instance $133 r0 *1 83.22,23.825 nfet
M$133 \$165 \$174 \$164 vsubs nfet L=0.6U W=0.58U AS=0.1508P AD=0.1508P PS=1.1U
+ PD=1.1U
* device instance $134 r0 *1 84.34,23.825 nfet
M$134 \$186 \$163 \$165 vsubs nfet L=0.6U W=0.58U AS=0.1508P AD=0.0696P PS=1.1U
+ PD=0.82U
* device instance $135 r0 *1 85.18,23.825 nfet
M$135 VSS \$166 \$186 vsubs nfet L=0.6U W=0.58U AS=0.0696P AD=0.252P PS=0.82U
+ PD=1.49U
* device instance $136 r0 *1 86.52,23.91 nfet
M$136 \$166 \$165 VSS vsubs nfet L=0.6U W=0.75U AS=0.252P AD=0.33P PS=1.49U
+ PD=2.38U
* device instance $137 r0 *1 88.36,24.195 nfet
M$137 Q|tmds[9] \$166 VSS vsubs nfet L=0.6U W=1.32U AS=0.5808P AD=0.5808P
+ PS=3.52U PD=3.52U
* device instance $138 r0 *1 96.125,24.195 nfet
M$138 \$197 A2|ZN$2 VSS vsubs nfet L=0.6U W=1.32U AS=0.5808P AD=0.2112P
+ PS=3.52U PD=1.64U
* device instance $139 r0 *1 97.045,24.195 nfet
M$139 A1|B|ZN$1 A1|B|C|I|ZN \$197 vsubs nfet L=0.6U W=1.32U AS=0.2112P
+ AD=0.5808P PS=1.64U PD=3.52U
* device instance $140 r0 *1 105.645,24.195 nfet
M$140 \$196 A2|ZN$6 VSS vsubs nfet L=0.6U W=1.32U AS=0.5808P AD=0.2112P
+ PS=3.52U PD=1.64U
* device instance $141 r0 *1 106.565,24.195 nfet
M$141 D|ZN$2 A1|B|ZN$1 \$196 vsubs nfet L=0.6U W=1.32U AS=0.2112P AD=0.5808P
+ PS=1.64U PD=3.52U
* device instance $142 r0 *1 108.445,24.195 nfet
M$142 \$195 A2|ZN$7 VSS vsubs nfet L=0.6U W=1.32U AS=0.5808P AD=0.2112P
+ PS=3.52U PD=1.64U
* device instance $143 r0 *1 109.365,24.195 nfet
M$143 D|ZN$5 A1|B|ZN$1 \$195 vsubs nfet L=0.6U W=1.32U AS=0.2112P AD=0.5808P
+ PS=1.64U PD=3.52U
* device instance $144 r0 *1 108.92,16.41 nfet
M$144 VSS \$111 \$110 vsubs nfet L=0.6U W=0.75U AS=0.33P AD=0.252P PS=2.38U
+ PD=1.49U
* device instance $145 r0 *1 110.26,16.495 nfet
M$145 \$137 \$110 VSS vsubs nfet L=0.6U W=0.58U AS=0.252P AD=0.0696P PS=1.49U
+ PD=0.82U
* device instance $146 r0 *1 111.1,16.495 nfet
M$146 \$111 \$114 \$137 vsubs nfet L=0.6U W=0.58U AS=0.0696P AD=0.1508P
+ PS=0.82U PD=1.1U
* device instance $147 r0 *1 112.22,16.495 nfet
M$147 \$125 \$112 \$111 vsubs nfet L=0.6U W=0.58U AS=0.1508P AD=0.1508P PS=1.1U
+ PD=1.1U
* device instance $148 r0 *1 113.34,16.495 nfet
M$148 \$125 \$113 VSS vsubs nfet L=0.6U W=0.58U AS=0.39315P AD=0.1508P PS=2.35U
+ PD=1.1U
* device instance $149 r0 *1 114.84,16.495 nfet
M$149 \$136 \$125 VSS vsubs nfet L=0.6U W=0.58U AS=0.39315P AD=0.0696P PS=2.35U
+ PD=0.82U
* device instance $150 r0 *1 115.68,16.495 nfet
M$150 \$113 \$112 \$136 vsubs nfet L=0.6U W=0.58U AS=0.0696P AD=0.1508P
+ PS=0.82U PD=1.1U
* device instance $151 r0 *1 116.8,16.495 nfet
M$151 \$132 D|ZN$5 \$113 vsubs nfet L=0.6U W=0.58U AS=0.1508P AD=0.0696P
+ PS=1.1U PD=0.82U
* device instance $152 r0 *1 117.64,16.495 nfet
M$152 VSS \$114 \$132 vsubs nfet L=0.6U W=0.58U AS=0.0696P AD=0.2552P PS=0.82U
+ PD=2.04U
* device instance $153 r0 *1 119.48,16.39 nfet
M$153 VSS \$114 \$112 vsubs nfet L=0.6U W=0.79U AS=0.3476P AD=0.2054P PS=2.46U
+ PD=1.31U
* device instance $154 r0 *1 120.6,16.39 nfet
M$154 \$114 CLK|clk VSS vsubs nfet L=0.6U W=0.79U AS=0.2054P AD=0.3476P
+ PS=1.31U PD=2.46U
* device instance $155 r0 *1 122.44,23.865 nfet
M$155 \$185 A1|data[1] \$152 vsubs nfet L=0.6U W=0.66U AS=0.2904P AD=0.1056P
+ PS=2.2U PD=0.98U
* device instance $156 r0 *1 123.36,23.865 nfet
M$156 VSS A1|A2|I|data[0] \$185 vsubs nfet L=0.6U W=0.66U AS=0.1056P AD=0.3894P
+ PS=0.98U PD=2.06U
* device instance $157 r0 *1 124.7,24.195 nfet
M$157 A3|B|Z \$152 VSS vsubs nfet L=0.6U W=1.32U AS=0.3894P AD=0.5808P PS=2.06U
+ PD=3.52U
* device instance $158 r0 *1 130.845,24.195 nfet
M$158 \$193 A2|A3|Z VSS vsubs nfet L=0.6U W=1.32U AS=0.5808P AD=0.2112P
+ PS=3.52U PD=1.64U
* device instance $159 r0 *1 131.765,24.195 nfet
M$159 A1|ZN$2 A1|A2|data[3] \$193 vsubs nfet L=0.6U W=1.32U AS=0.2112P
+ AD=0.5808P PS=1.64U PD=3.52U
* device instance $160 r0 *1 142.02,23.995 nfet
M$160 VSS B|Z A2|A3|B|ZN vsubs nfet L=0.6U W=0.92U AS=0.402P AD=0.4048P
+ PS=2.02U PD=2.72U
* device instance $161 r0 *1 139.8,24.195 nfet
M$161 \$191 A2|ZN$3 VSS vsubs nfet L=0.6U W=1.32U AS=0.5808P AD=0.2112P
+ PS=3.52U PD=1.64U
* device instance $162 r0 *1 140.72,24.195 nfet
M$162 A2|A3|B|ZN A1|ZN$2 \$191 vsubs nfet L=0.6U W=1.32U AS=0.2112P AD=0.402P
+ PS=1.64U PD=2.02U
* device instance $163 r0 *1 12.12,26.205 nfet
M$163 \$199 A3|Z VSS vsubs nfet L=0.6U W=1.32U AS=0.5808P AD=0.3432P PS=3.52U
+ PD=1.84U
* device instance $164 r0 *1 13.24,26.205 nfet
M$164 VSS A2|ZN \$199 vsubs nfet L=0.6U W=1.32U AS=0.3432P AD=0.3432P PS=1.84U
+ PD=1.84U
* device instance $165 r0 *1 14.36,26.205 nfet
M$165 \$199 A1|Z VSS vsubs nfet L=0.6U W=1.32U AS=0.3432P AD=0.3432P PS=1.84U
+ PD=1.84U
* device instance $166 r0 *1 15.48,26.205 nfet
M$166 A1|ZN$3 A1|B1|Z \$199 vsubs nfet L=0.6U W=1.32U AS=0.3432P AD=0.3432P
+ PS=1.84U PD=1.84U
* device instance $167 r0 *1 16.6,26.205 nfet
M$167 \$199 A1|B2|ZN A1|ZN$3 vsubs nfet L=0.6U W=1.32U AS=0.3432P AD=0.5808P
+ PS=1.84U PD=3.52U
* device instance $168 r0 *1 13.24,24.07 nfet
M$168 \$157 A1|A2|A3|ZN VSS vsubs nfet L=0.6U W=0.66U AS=0.2904P AD=0.1716P
+ PS=2.2U PD=1.18U
* device instance $169 r0 *1 14.36,24.07 nfet
M$169 \$157 A1|A2|Z VSS vsubs nfet L=0.6U W=0.66U AS=0.363P AD=0.1716P PS=2.02U
+ PD=1.18U
* device instance $170 r0 *1 15.66,24.2 nfet
M$170 A1|B1|Z \$157 VSS vsubs nfet L=0.6U W=1.32U AS=0.363P AD=0.3432P PS=2.02U
+ PD=1.84U
* device instance $171 r0 *1 16.78,24.2 nfet
M$171 \$192 A1|A2|Z A1|B1|Z vsubs nfet L=0.6U W=1.32U AS=0.3432P AD=0.2112P
+ PS=1.84U PD=1.64U
* device instance $172 r0 *1 17.7,24.2 nfet
M$172 VSS A1|A2|A3|ZN \$192 vsubs nfet L=0.6U W=1.32U AS=0.2112P AD=0.5808P
+ PS=1.64U PD=3.52U
* device instance $173 r0 *1 36.04,26.205 nfet
M$173 \$203 B|ZN$2 VSS vsubs nfet L=0.6U W=1.32U AS=0.5808P AD=0.3432P PS=3.52U
+ PD=1.84U
* device instance $174 r0 *1 37.16,26.205 nfet
M$174 A2|ZN$8 A1|A2|Z \$203 vsubs nfet L=0.6U W=1.32U AS=0.3432P AD=0.3432P
+ PS=1.84U PD=1.84U
* device instance $175 r0 *1 38.28,26.205 nfet
M$175 \$203 A1|A2|C|S|ZN A2|ZN$8 vsubs nfet L=0.6U W=1.32U AS=0.3432P
+ AD=0.5808P PS=1.84U PD=3.52U
* device instance $176 r0 *1 57.48,26.47 nfet
M$176 VSS CLK|clk \$204 vsubs nfet L=0.6U W=0.79U AS=0.3476P AD=0.2054P
+ PS=2.46U PD=1.31U
* device instance $177 r0 *1 58.6,26.47 nfet
M$177 \$205 \$204 VSS vsubs nfet L=0.6U W=0.79U AS=0.2054P AD=0.3476P PS=1.31U
+ PD=2.46U
* device instance $178 r0 *1 71,26.205 nfet
M$178 Q|tmds[5] \$209 VSS vsubs nfet L=0.6U W=1.32U AS=0.5808P AD=0.5808P
+ PS=3.52U PD=3.52U
* device instance $179 r0 *1 73.16,26.205 nfet
M$179 VSS B2|ZN \$210 vsubs nfet L=0.6U W=1.32U AS=0.5808P AD=0.3432P PS=3.52U
+ PD=1.84U
* device instance $180 r0 *1 74.28,26.205 nfet
M$180 \$210 B1|ZN VSS vsubs nfet L=0.6U W=1.32U AS=0.3432P AD=0.3432P PS=1.84U
+ PD=1.84U
* device instance $181 r0 *1 75.4,26.205 nfet
M$181 D|ZN$6 A1|B|ZN \$210 vsubs nfet L=0.6U W=1.32U AS=0.3432P AD=0.3432P
+ PS=1.84U PD=1.84U
* device instance $182 r0 *1 76.52,26.205 nfet
M$182 \$210 A2|ZN$1 D|ZN$6 vsubs nfet L=0.6U W=1.32U AS=0.3432P AD=0.5808P
+ PS=1.84U PD=3.52U
* device instance $183 r0 *1 87.54,26.205 nfet
M$183 A3|B2|ZN A2|A3|Z$1 \$212 vsubs nfet L=0.6U W=1.32U AS=0.5808P AD=0.3432P
+ PS=3.52U PD=1.84U
* device instance $184 r0 *1 88.66,26.205 nfet
M$184 \$212 A1|A2|ZN A3|B2|ZN vsubs nfet L=0.6U W=1.32U AS=0.3432P AD=0.3432P
+ PS=1.84U PD=1.84U
* device instance $185 r0 *1 89.78,26.205 nfet
M$185 VSS \$215 \$212 vsubs nfet L=0.6U W=1.32U AS=0.3432P AD=0.363P PS=1.84U
+ PD=2.02U
* device instance $186 r0 *1 91.08,26.535 nfet
M$186 \$228 A1|A2|ZN VSS vsubs nfet L=0.6U W=0.66U AS=0.363P AD=0.1056P
+ PS=2.02U PD=0.98U
* device instance $187 r0 *1 92,26.535 nfet
M$187 \$215 A2|A3|Z$1 \$228 vsubs nfet L=0.6U W=0.66U AS=0.1056P AD=0.2904P
+ PS=0.98U PD=2.2U
* device instance $188 r0 *1 94.445,26.205 nfet
M$188 \$229 A2|B|ZN VSS vsubs nfet L=0.6U W=1.32U AS=0.5808P AD=0.2112P
+ PS=3.52U PD=1.64U
* device instance $189 r0 *1 95.365,26.205 nfet
M$189 A1|B|C|I|ZN A1|A2|C|I|de \$229 vsubs nfet L=0.6U W=1.32U AS=0.2112P
+ AD=0.5808P PS=1.64U PD=3.52U
* device instance $190 r0 *1 106.2,26.205 nfet
M$190 A2|ZN$6 A2|ZN$9 \$216 vsubs nfet L=0.6U W=1.32U AS=0.5808P AD=0.3432P
+ PS=3.52U PD=1.84U
* device instance $191 r0 *1 107.32,26.205 nfet
M$191 \$216 A1|A2|C|S|ZN A2|ZN$6 vsubs nfet L=0.6U W=1.32U AS=0.3432P AD=0.363P
+ PS=1.84U PD=1.87U
* device instance $192 r0 *1 108.47,26.205 nfet
M$192 \$230 B|ZN$3 \$216 vsubs nfet L=0.6U W=1.32U AS=0.363P AD=0.2442P
+ PS=1.87U PD=1.69U
* device instance $193 r0 *1 109.44,26.205 nfet
M$193 VSS A1|A2|C|I|de \$230 vsubs nfet L=0.6U W=1.32U AS=0.2442P AD=0.5808P
+ PS=1.69U PD=3.52U
* device instance $194 r0 *1 128.04,26.535 nfet
M$194 \$227 A1|A2|A3|data[2] \$219 vsubs nfet L=0.6U W=0.66U AS=0.2904P
+ AD=0.1056P PS=2.2U PD=0.98U
* device instance $195 r0 *1 128.96,26.535 nfet
M$195 \$225 A1|A2|data[3] \$227 vsubs nfet L=0.6U W=0.66U AS=0.1056P AD=0.1386P
+ PS=0.98U PD=1.08U
* device instance $196 r0 *1 129.98,26.535 nfet
M$196 \$225 A3|B|Z VSS vsubs nfet L=0.6U W=0.66U AS=0.4158P AD=0.1386P PS=2.18U
+ PD=1.08U
* device instance $197 r0 *1 131.44,26.205 nfet
M$197 B|Z \$219 VSS vsubs nfet L=0.6U W=1.32U AS=0.4158P AD=0.5808P PS=2.18U
+ PD=3.52U
* device instance $198 r0 *1 142.6,26.205 nfet
M$198 \$222 A2|A3|ZN VSS vsubs nfet L=0.6U W=1.32U AS=0.5808P AD=0.2112P
+ PS=3.52U PD=1.64U
* device instance $199 r0 *1 143.52,26.205 nfet
M$199 A2|ZN$10 A1|ZN$1 \$222 vsubs nfet L=0.6U W=1.32U AS=0.2112P AD=0.402P
+ PS=1.64U PD=2.02U
* device instance $200 r0 *1 144.82,26.405 nfet
M$200 VSS B|Z A2|ZN$10 vsubs nfet L=0.6U W=0.92U AS=0.402P AD=0.4048P PS=2.02U
+ PD=2.72U
* device instance $201 r0 *1 25.96,33.98 nfet
M$201 VSS A1|A2|I|data[0] A1|B2|ZN vsubs nfet L=0.6U W=0.73U AS=0.3212P
+ AD=0.3212P PS=2.34U PD=2.34U
* device instance $202 r0 *1 34.525,34.275 nfet
M$202 \$297 A2|Z VSS vsubs nfet L=0.6U W=1.32U AS=0.5808P AD=0.2112P PS=3.52U
+ PD=1.64U
* device instance $203 r0 *1 35.445,34.275 nfet
M$203 B|ZN$2 A1|A2|C|S|ZN \$297 vsubs nfet L=0.6U W=1.32U AS=0.2112P AD=0.5808P
+ PS=1.64U PD=3.52U
* device instance $204 r0 *1 44.6,34.01 nfet
M$204 VSS CLK|clk \$252 vsubs nfet L=0.6U W=0.79U AS=0.3476P AD=0.2054P
+ PS=2.46U PD=1.31U
* device instance $205 r0 *1 45.72,34.01 nfet
M$205 \$264 \$252 VSS vsubs nfet L=0.6U W=0.79U AS=0.2054P AD=0.3476P PS=1.31U
+ PD=2.46U
* device instance $206 r0 *1 47.56,33.905 nfet
M$206 \$289 \$252 VSS vsubs nfet L=0.6U W=0.58U AS=0.2552P AD=0.0696P PS=2.04U
+ PD=0.82U
* device instance $207 r0 *1 48.4,33.905 nfet
M$207 \$265 D|ZN$8 \$289 vsubs nfet L=0.6U W=0.58U AS=0.0696P AD=0.1508P
+ PS=0.82U PD=1.1U
* device instance $208 r0 *1 49.52,33.905 nfet
M$208 \$291 \$264 \$265 vsubs nfet L=0.6U W=0.58U AS=0.1508P AD=0.0696P PS=1.1U
+ PD=0.82U
* device instance $209 r0 *1 50.36,33.905 nfet
M$209 VSS \$266 \$291 vsubs nfet L=0.6U W=0.58U AS=0.0696P AD=0.39315P PS=0.82U
+ PD=2.35U
* device instance $210 r0 *1 51.86,33.905 nfet
M$210 \$266 \$265 VSS vsubs nfet L=0.6U W=0.58U AS=0.39315P AD=0.1508P PS=2.35U
+ PD=1.1U
* device instance $211 r0 *1 52.98,33.905 nfet
M$211 \$267 \$264 \$266 vsubs nfet L=0.6U W=0.58U AS=0.1508P AD=0.1508P PS=1.1U
+ PD=1.1U
* device instance $212 r0 *1 54.1,33.905 nfet
M$212 \$290 \$252 \$267 vsubs nfet L=0.6U W=0.58U AS=0.1508P AD=0.0696P PS=1.1U
+ PD=0.82U
* device instance $213 r0 *1 54.94,33.905 nfet
M$213 VSS \$268 \$290 vsubs nfet L=0.6U W=0.58U AS=0.0696P AD=0.252P PS=0.82U
+ PD=1.49U
* device instance $214 r0 *1 56.28,33.99 nfet
M$214 \$268 \$267 VSS vsubs nfet L=0.6U W=0.75U AS=0.252P AD=0.33P PS=1.49U
+ PD=2.38U
* device instance $215 r0 *1 58.12,34.275 nfet
M$215 Q|tmds[3] \$268 VSS vsubs nfet L=0.6U W=1.32U AS=0.5808P AD=0.5808P
+ PS=3.52U PD=3.52U
* device instance $216 r0 *1 60.44,26.575 nfet
M$216 \$223 \$204 VSS vsubs nfet L=0.6U W=0.58U AS=0.2552P AD=0.0696P PS=2.04U
+ PD=0.82U
* device instance $217 r0 *1 61.28,26.575 nfet
M$217 \$206 D|ZN$7 \$223 vsubs nfet L=0.6U W=0.58U AS=0.0696P AD=0.1508P
+ PS=0.82U PD=1.1U
* device instance $218 r0 *1 62.4,26.575 nfet
M$218 \$224 \$205 \$206 vsubs nfet L=0.6U W=0.58U AS=0.1508P AD=0.0696P PS=1.1U
+ PD=0.82U
* device instance $219 r0 *1 63.24,26.575 nfet
M$219 \$224 \$207 VSS vsubs nfet L=0.6U W=0.58U AS=0.39315P AD=0.0696P PS=2.35U
+ PD=0.82U
* device instance $220 r0 *1 64.74,26.575 nfet
M$220 \$207 \$206 VSS vsubs nfet L=0.6U W=0.58U AS=0.39315P AD=0.1508P PS=2.35U
+ PD=1.1U
* device instance $221 r0 *1 65.86,26.575 nfet
M$221 \$208 \$205 \$207 vsubs nfet L=0.6U W=0.58U AS=0.1508P AD=0.1508P PS=1.1U
+ PD=1.1U
* device instance $222 r0 *1 66.98,26.575 nfet
M$222 \$226 \$204 \$208 vsubs nfet L=0.6U W=0.58U AS=0.1508P AD=0.0696P PS=1.1U
+ PD=0.82U
* device instance $223 r0 *1 67.82,26.575 nfet
M$223 \$226 \$209 VSS vsubs nfet L=0.6U W=0.58U AS=0.252P AD=0.0696P PS=1.49U
+ PD=0.82U
* device instance $224 r0 *1 69.16,26.49 nfet
M$224 \$209 \$208 VSS vsubs nfet L=0.6U W=0.75U AS=0.252P AD=0.33P PS=1.49U
+ PD=2.38U
* device instance $225 r0 *1 67.56,33.98 nfet
M$225 A1|B|ZN A1|A2|C|I|de VSS vsubs nfet L=0.6U W=0.73U AS=0.3212P AD=0.3212P
+ PS=2.34U PD=2.34U
* device instance $226 r0 *1 102.88,33.945 nfet
M$226 \$288 A1|A2|A3|ZN \$255 vsubs nfet L=0.6U W=0.66U AS=0.2904P AD=0.1056P
+ PS=2.2U PD=0.98U
* device instance $227 r0 *1 103.8,33.945 nfet
M$227 VSS A1|A2|ZN \$288 vsubs nfet L=0.6U W=0.66U AS=0.1056P AD=0.363P
+ PS=0.98U PD=2.02U
* device instance $228 r0 *1 105.1,34.275 nfet
M$228 \$284 \$255 VSS vsubs nfet L=0.6U W=1.32U AS=0.363P AD=0.3432P PS=2.02U
+ PD=1.84U
* device instance $229 r0 *1 106.22,34.275 nfet
M$229 A2|ZN$9 A1|A2|ZN \$284 vsubs nfet L=0.6U W=1.32U AS=0.3432P AD=0.3432P
+ PS=1.84U PD=1.84U
* device instance $230 r0 *1 107.34,34.275 nfet
M$230 \$284 A1|A2|A3|ZN A2|ZN$9 vsubs nfet L=0.6U W=1.32U AS=0.3432P AD=0.5808P
+ PS=1.84U PD=3.52U
* device instance $231 r0 *1 111.835,34.275 nfet
M$231 \$294 A1|A2|C|S|ZN B|ZN$3 vsubs nfet L=0.6U W=1.32U AS=0.5808P AD=0.2112P
+ PS=3.52U PD=1.64U
* device instance $232 r0 *1 112.755,34.275 nfet
M$232 VSS A2|ZN$11 \$294 vsubs nfet L=0.6U W=1.32U AS=0.2112P AD=0.5808P
+ PS=1.64U PD=3.52U
* device instance $233 r0 *1 126.5,34.22 nfet
M$233 \$286 \$259 \$271 vsubs nfet L=0.6U W=0.66U AS=0.2904P AD=0.1056P PS=2.2U
+ PD=0.98U
* device instance $234 r0 *1 127.42,34.22 nfet
M$234 \$286 A2|A3|Z VSS vsubs nfet L=0.6U W=0.66U AS=0.363P AD=0.1056P PS=2.02U
+ PD=0.98U
* device instance $235 r0 *1 128.72,34.275 nfet
M$235 \$285 \$271 VSS vsubs nfet L=0.6U W=1.32U AS=0.363P AD=0.3432P PS=2.02U
+ PD=1.84U
* device instance $236 r0 *1 129.84,34.275 nfet
M$236 A1|A2|ZN A2|A3|Z \$285 vsubs nfet L=0.6U W=1.32U AS=0.3432P AD=0.3432P
+ PS=1.84U PD=1.84U
* device instance $237 r0 *1 130.96,34.275 nfet
M$237 \$285 \$259 A1|A2|ZN vsubs nfet L=0.6U W=1.32U AS=0.3432P AD=0.5808P
+ PS=1.84U PD=3.52U
* device instance $238 r0 *1 143.14,34.075 nfet
M$238 VSS A2|A3|B|ZN A2|ZN$12 vsubs nfet L=0.6U W=0.92U AS=0.402P AD=0.4048P
+ PS=2.02U PD=2.72U
* device instance $239 r0 *1 140.92,34.275 nfet
M$239 \$292 A2|ZN$14 VSS vsubs nfet L=0.6U W=1.32U AS=0.5808P AD=0.2112P
+ PS=3.52U PD=1.64U
* device instance $240 r0 *1 141.84,34.275 nfet
M$240 A2|ZN$12 A1|Z$2 \$292 vsubs nfet L=0.6U W=1.32U AS=0.2112P AD=0.402P
+ PS=1.64U PD=2.02U
* device instance $241 r0 *1 14.76,34.15 nfet
M$241 \$248 A1|data[1] VSS vsubs nfet L=0.6U W=0.66U AS=0.363P AD=0.1716P
+ PS=2.02U PD=1.18U
* device instance $242 r0 *1 15.88,34.15 nfet
M$242 VSS A1|A2|A3|ZN \$248 vsubs nfet L=0.6U W=0.66U AS=0.1716P AD=0.2904P
+ PS=1.18U PD=2.2U
* device instance $243 r0 *1 11.42,34.28 nfet
M$243 \$293 A1|A2|A3|ZN VSS vsubs nfet L=0.6U W=1.32U AS=0.5808P AD=0.2112P
+ PS=3.52U PD=1.64U
* device instance $244 r0 *1 12.34,34.28 nfet
M$244 A3|Z A1|data[1] \$293 vsubs nfet L=0.6U W=1.32U AS=0.2112P AD=0.3432P
+ PS=1.64U PD=1.84U
* device instance $245 r0 *1 13.46,34.28 nfet
M$245 VSS \$248 A3|Z vsubs nfet L=0.6U W=1.32U AS=0.3432P AD=0.363P PS=1.84U
+ PD=2.02U
* device instance $246 r0 *1 14.5,36.34 nfet
M$246 \$315 \$299 \$300 vsubs nfet L=0.6U W=0.66U AS=0.2904P AD=0.1056P PS=2.2U
+ PD=0.98U
* device instance $247 r0 *1 15.42,36.34 nfet
M$247 \$315 A1|A2|A3|ZN VSS vsubs nfet L=0.6U W=0.66U AS=0.363P AD=0.1056P
+ PS=2.02U PD=0.98U
* device instance $248 r0 *1 16.72,36.285 nfet
M$248 \$301 \$300 VSS vsubs nfet L=0.6U W=1.32U AS=0.363P AD=0.3432P PS=2.02U
+ PD=1.84U
* device instance $249 r0 *1 17.84,36.285 nfet
M$249 A1|ZN$4 A1|A2|A3|ZN \$301 vsubs nfet L=0.6U W=1.32U AS=0.3432P AD=0.3432P
+ PS=1.84U PD=1.84U
* device instance $250 r0 *1 18.96,36.285 nfet
M$250 \$301 \$299 A1|ZN$4 vsubs nfet L=0.6U W=1.32U AS=0.3432P AD=0.5808P
+ PS=1.84U PD=3.52U
* device instance $251 r0 *1 27.8,34.15 nfet
M$251 \$262 A1|A2|B2|Z VSS vsubs nfet L=0.6U W=0.66U AS=0.2904P AD=0.1716P
+ PS=2.2U PD=1.18U
* device instance $252 r0 *1 28.92,34.15 nfet
M$252 \$262 A1|B1|Z VSS vsubs nfet L=0.6U W=0.66U AS=0.363P AD=0.1716P PS=2.02U
+ PD=1.18U
* device instance $253 r0 *1 30.22,34.28 nfet
M$253 A2|Z \$262 VSS vsubs nfet L=0.6U W=1.32U AS=0.363P AD=0.3432P PS=2.02U
+ PD=1.84U
* device instance $254 r0 *1 31.34,34.28 nfet
M$254 \$296 A1|B1|Z A2|Z vsubs nfet L=0.6U W=1.32U AS=0.3432P AD=0.2112P
+ PS=1.84U PD=1.64U
* device instance $255 r0 *1 32.26,34.28 nfet
M$255 VSS A1|A2|B2|Z \$296 vsubs nfet L=0.6U W=1.32U AS=0.2112P AD=0.5808P
+ PS=1.64U PD=3.52U
* device instance $256 r0 *1 28.92,36.41 nfet
M$256 \$303 A1|A2|B2|Z VSS vsubs nfet L=0.6U W=0.66U AS=0.2904P AD=0.1716P
+ PS=2.2U PD=1.18U
* device instance $257 r0 *1 30.04,36.41 nfet
M$257 \$303 A1|A2|ZN$1 VSS vsubs nfet L=0.6U W=0.66U AS=0.363P AD=0.1716P
+ PS=2.02U PD=1.18U
* device instance $258 r0 *1 31.34,36.28 nfet
M$258 I1|Z \$303 VSS vsubs nfet L=0.6U W=1.32U AS=0.363P AD=0.3432P PS=2.02U
+ PD=1.84U
* device instance $259 r0 *1 32.46,36.28 nfet
M$259 \$317 A1|A2|ZN$1 I1|Z vsubs nfet L=0.6U W=1.32U AS=0.3432P AD=0.2112P
+ PS=1.84U PD=1.64U
* device instance $260 r0 *1 33.38,36.28 nfet
M$260 VSS A1|A2|B2|Z \$317 vsubs nfet L=0.6U W=1.32U AS=0.2112P AD=0.5808P
+ PS=1.64U PD=3.52U
* device instance $261 r0 *1 40.68,36.285 nfet
M$261 \$319 A2|Z$1 VSS vsubs nfet L=0.6U W=1.32U AS=0.5808P AD=0.2112P PS=3.52U
+ PD=1.64U
* device instance $262 r0 *1 41.6,36.285 nfet
M$262 D|ZN$8 A1|A2|C|I|de \$319 vsubs nfet L=0.6U W=1.32U AS=0.2112P AD=0.402P
+ PS=1.64U PD=2.02U
* device instance $263 r0 *1 42.9,36.485 nfet
M$263 VSS B|ZN$1 D|ZN$8 vsubs nfet L=0.6U W=0.92U AS=0.402P AD=0.4048P PS=2.02U
+ PD=2.72U
* device instance $264 r0 *1 67,36.285 nfet
M$264 \$321 A2|ZN$15 VSS vsubs nfet L=0.6U W=1.32U AS=0.5808P AD=0.2112P
+ PS=3.52U PD=1.64U
* device instance $265 r0 *1 67.92,36.285 nfet
M$265 A2|ZN$13 A1|A2|C|S|ZN \$321 vsubs nfet L=0.6U W=1.32U AS=0.2112P
+ AD=0.402P PS=1.64U PD=2.02U
* device instance $266 r0 *1 69.22,36.485 nfet
M$266 VSS A1|B|ZN A2|ZN$13 vsubs nfet L=0.6U W=0.92U AS=0.402P AD=0.4048P
+ PS=2.02U PD=2.72U
* device instance $267 r0 *1 86.635,36.285 nfet
M$267 \$320 A1|A2|ZN B|ZN$4 vsubs nfet L=0.6U W=1.32U AS=0.5808P AD=0.2112P
+ PS=3.52U PD=1.64U
* device instance $268 r0 *1 87.555,36.285 nfet
M$268 VSS A2|A3|Z$1 \$320 vsubs nfet L=0.6U W=1.32U AS=0.2112P AD=0.5808P
+ PS=1.64U PD=3.52U
* device instance $269 r0 *1 90.36,34.15 nfet
M$269 \$254 A1|data[1] VSS vsubs nfet L=0.6U W=0.66U AS=0.363P AD=0.1716P
+ PS=2.02U PD=1.18U
* device instance $270 r0 *1 91.48,34.15 nfet
M$270 VSS A1|A2|data[3] \$254 vsubs nfet L=0.6U W=0.66U AS=0.1716P AD=0.2904P
+ PS=1.18U PD=2.2U
* device instance $271 r0 *1 87.02,34.28 nfet
M$271 \$295 A1|A2|data[3] VSS vsubs nfet L=0.6U W=1.32U AS=0.5808P AD=0.2112P
+ PS=3.52U PD=1.64U
* device instance $272 r0 *1 87.94,34.28 nfet
M$272 A2|A3|Z$1 A1|data[1] \$295 vsubs nfet L=0.6U W=1.32U AS=0.2112P
+ AD=0.3432P PS=1.64U PD=1.84U
* device instance $273 r0 *1 89.06,34.28 nfet
M$273 VSS \$254 A2|A3|Z$1 vsubs nfet L=0.6U W=1.32U AS=0.3432P AD=0.363P
+ PS=1.84U PD=2.02U
* device instance $274 r0 *1 110.16,36.615 nfet
M$274 \$318 A1|A2|B2|Z \$307 vsubs nfet L=0.6U W=0.66U AS=0.2904P AD=0.1056P
+ PS=2.2U PD=0.98U
* device instance $275 r0 *1 111.08,36.615 nfet
M$275 \$318 A1|A2|ZN VSS vsubs nfet L=0.6U W=0.66U AS=0.363P AD=0.1056P
+ PS=2.02U PD=0.98U
* device instance $276 r0 *1 112.38,36.285 nfet
M$276 \$308 \$307 VSS vsubs nfet L=0.6U W=1.32U AS=0.363P AD=0.3432P PS=2.02U
+ PD=1.84U
* device instance $277 r0 *1 113.5,36.285 nfet
M$277 A2|ZN$11 A1|A2|ZN \$308 vsubs nfet L=0.6U W=1.32U AS=0.3432P AD=0.3432P
+ PS=1.84U PD=1.84U
* device instance $278 r0 *1 114.62,36.285 nfet
M$278 \$308 A1|A2|B2|Z A2|ZN$11 vsubs nfet L=0.6U W=1.32U AS=0.3432P AD=0.5808P
+ PS=1.84U PD=3.52U
* device instance $279 r0 *1 120.2,34.37 nfet
M$279 \$257 A1|A2|data[3] VSS vsubs nfet L=0.6U W=0.36U AS=0.1584P AD=0.0936P
+ PS=1.6U PD=0.88U
* device instance $280 r0 *1 121.32,34.37 nfet
M$280 \$257 A1|ZN VSS vsubs nfet L=0.6U W=0.36U AS=0.186P AD=0.0936P PS=1.36U
+ PD=0.88U
* device instance $281 r0 *1 122.62,34.22 nfet
M$281 \$259 \$257 VSS vsubs nfet L=0.6U W=0.66U AS=0.186P AD=0.1716P PS=1.36U
+ PD=1.18U
* device instance $282 r0 *1 123.74,34.22 nfet
M$282 \$287 A1|ZN \$259 vsubs nfet L=0.6U W=0.66U AS=0.1716P AD=0.1056P
+ PS=1.18U PD=0.98U
* device instance $283 r0 *1 124.66,34.22 nfet
M$283 VSS A1|A2|data[3] \$287 vsubs nfet L=0.6U W=0.66U AS=0.1056P AD=0.2904P
+ PS=0.98U PD=2.2U
* device instance $284 r0 *1 126.365,36.285 nfet
M$284 \$316 A1|A2|ZN VSS vsubs nfet L=0.6U W=1.32U AS=0.5808P AD=0.2112P
+ PS=3.52U PD=1.64U
* device instance $285 r0 *1 127.285,36.285 nfet
M$285 A2|ZN$14 A1|data[5] \$316 vsubs nfet L=0.6U W=1.32U AS=0.2112P AD=0.5808P
+ PS=1.64U PD=3.52U
* device instance $286 r0 *1 142.075,36.285 nfet
M$286 \$313 A1|Z$2 A2|A3|ZN vsubs nfet L=0.6U W=1.32U AS=0.5808P AD=0.2112P
+ PS=3.52U PD=1.64U
* device instance $287 r0 *1 142.995,36.285 nfet
M$287 VSS A2|ZN$14 \$313 vsubs nfet L=0.6U W=1.32U AS=0.2112P AD=0.5808P
+ PS=1.64U PD=3.52U
* device instance $288 r0 *1 8.2,36.19 nfet
M$288 \$298 A1|A2|A3|data[2] VSS vsubs nfet L=0.6U W=0.36U AS=0.1584P
+ AD=0.0936P PS=1.6U PD=0.88U
* device instance $289 r0 *1 9.32,36.19 nfet
M$289 VSS A1|B2|ZN \$298 vsubs nfet L=0.6U W=0.36U AS=0.0936P AD=0.186P
+ PS=0.88U PD=1.36U
* device instance $290 r0 *1 10.62,36.34 nfet
M$290 \$299 \$298 VSS vsubs nfet L=0.6U W=0.66U AS=0.186P AD=0.1716P PS=1.36U
+ PD=1.18U
* device instance $291 r0 *1 11.74,36.34 nfet
M$291 \$314 A1|B2|ZN \$299 vsubs nfet L=0.6U W=0.66U AS=0.1716P AD=0.1056P
+ PS=1.18U PD=0.98U
* device instance $292 r0 *1 12.66,36.34 nfet
M$292 VSS A1|A2|A3|data[2] \$314 vsubs nfet L=0.6U W=0.66U AS=0.1056P
+ AD=0.2904P PS=0.98U PD=2.2U
* device instance $293 r0 *1 18.28,44.355 nfet
M$293 A2|ZN$19 A1|A2|ZN$1 \$367 vsubs nfet L=0.6U W=1.32U AS=0.5808P AD=0.3432P
+ PS=3.52U PD=1.84U
* device instance $294 r0 *1 19.4,44.355 nfet
M$294 \$367 A1|ZN$4 A2|ZN$19 vsubs nfet L=0.6U W=1.32U AS=0.3432P AD=0.3432P
+ PS=1.84U PD=1.84U
* device instance $295 r0 *1 20.52,44.355 nfet
M$295 VSS B|ZN$4 \$367 vsubs nfet L=0.6U W=1.32U AS=0.3432P AD=0.5808P PS=1.84U
+ PD=3.52U
* device instance $296 r0 *1 49.62,44.155 nfet
M$296 VSS B|ZN$1 D|ZN$9 vsubs nfet L=0.6U W=0.92U AS=0.402P AD=0.4048P PS=2.02U
+ PD=2.72U
* device instance $297 r0 *1 47.4,44.355 nfet
M$297 \$380 A2|ZN$16 VSS vsubs nfet L=0.6U W=1.32U AS=0.5808P AD=0.2112P
+ PS=3.52U PD=1.64U
* device instance $298 r0 *1 48.32,44.355 nfet
M$298 D|ZN$9 A1|A2|C|I|de \$380 vsubs nfet L=0.6U W=1.32U AS=0.2112P AD=0.402P
+ PS=1.64U PD=2.02U
* device instance $299 r0 *1 66.3,44.155 nfet
M$299 D|ZN$7 B|ZN$1 VSS vsubs nfet L=0.6U W=0.92U AS=0.4048P AD=0.402P PS=2.72U
+ PD=2.02U
* device instance $300 r0 *1 67.6,44.355 nfet
M$300 \$381 A1|ZN$5 D|ZN$7 vsubs nfet L=0.6U W=1.32U AS=0.402P AD=0.2112P
+ PS=2.02U PD=1.64U
* device instance $301 r0 *1 68.52,44.355 nfet
M$301 VSS A2|ZN$13 \$381 vsubs nfet L=0.6U W=1.32U AS=0.2112P AD=0.5808P
+ PS=1.64U PD=3.52U
* device instance $302 r0 *1 83.38,44.2 nfet
M$302 \$342 \$341 VSS vsubs nfet L=0.6U W=0.66U AS=0.2904P AD=0.1716P PS=2.2U
+ PD=1.18U
* device instance $303 r0 *1 84.5,44.2 nfet
M$303 \$342 A2|A3|Z$1 VSS vsubs nfet L=0.6U W=0.66U AS=0.363P AD=0.1716P
+ PS=2.02U PD=1.18U
* device instance $304 r0 *1 85.8,44.355 nfet
M$304 A3|Z$1 \$342 VSS vsubs nfet L=0.6U W=1.32U AS=0.363P AD=0.3432P PS=2.02U
+ PD=1.84U
* device instance $305 r0 *1 86.92,44.355 nfet
M$305 \$377 A2|A3|Z$1 A3|Z$1 vsubs nfet L=0.6U W=1.32U AS=0.3432P AD=0.2112P
+ PS=1.84U PD=1.64U
* device instance $306 r0 *1 87.84,44.355 nfet
M$306 VSS \$341 \$377 vsubs nfet L=0.6U W=1.32U AS=0.2112P AD=0.5808P PS=1.64U
+ PD=3.52U
* device instance $307 r0 *1 105.64,44.355 nfet
M$307 A2|ZN$7 A2|ZN$17 \$368 vsubs nfet L=0.6U W=1.32U AS=0.5808P AD=0.3432P
+ PS=3.52U PD=1.84U
* device instance $308 r0 *1 106.76,44.355 nfet
M$308 \$368 A1|A2|C|S|ZN A2|ZN$7 vsubs nfet L=0.6U W=1.32U AS=0.3432P AD=0.363P
+ PS=1.84U PD=1.87U
* device instance $309 r0 *1 107.91,44.355 nfet
M$309 \$375 B|ZN$5 \$368 vsubs nfet L=0.6U W=1.32U AS=0.363P AD=0.2442P
+ PS=1.87U PD=1.69U
* device instance $310 r0 *1 108.88,44.355 nfet
M$310 VSS A1|A2|C|I|de \$375 vsubs nfet L=0.6U W=1.32U AS=0.2442P AD=0.5808P
+ PS=1.69U PD=3.52U
* device instance $311 r0 *1 128.04,44.025 nfet
M$311 \$373 A1|A2|data[3] VSS vsubs nfet L=0.6U W=0.66U AS=0.363P AD=0.1056P
+ PS=2.02U PD=0.98U
* device instance $312 r0 *1 128.96,44.025 nfet
M$312 \$346 A2|A3|Z \$373 vsubs nfet L=0.6U W=0.66U AS=0.1056P AD=0.2904P
+ PS=0.98U PD=2.2U
* device instance $313 r0 *1 124.5,44.355 nfet
M$313 A1|A2|I0|ZN A2|A3|Z \$369 vsubs nfet L=0.6U W=1.32U AS=0.5808P AD=0.3432P
+ PS=3.52U PD=1.84U
* device instance $314 r0 *1 125.62,44.355 nfet
M$314 \$369 A1|A2|data[3] A1|A2|I0|ZN vsubs nfet L=0.6U W=1.32U AS=0.3432P
+ AD=0.3432P PS=1.84U PD=1.84U
* device instance $315 r0 *1 126.74,44.355 nfet
M$315 VSS \$346 \$369 vsubs nfet L=0.6U W=1.32U AS=0.3432P AD=0.363P PS=1.84U
+ PD=2.02U
* device instance $316 r0 *1 142.5,44.3 nfet
M$316 \$372 A2|A3|ZN VSS vsubs nfet L=0.6U W=0.66U AS=0.363P AD=0.1056P
+ PS=2.02U PD=0.98U
* device instance $317 r0 *1 143.42,44.3 nfet
M$317 \$330 \$348 \$372 vsubs nfet L=0.6U W=0.66U AS=0.1056P AD=0.2904P
+ PS=0.98U PD=2.2U
* device instance $318 r0 *1 138.96,44.355 nfet
M$318 B1|ZN$1 \$348 \$370 vsubs nfet L=0.6U W=1.32U AS=0.5808P AD=0.3432P
+ PS=3.52U PD=1.84U
* device instance $319 r0 *1 140.08,44.355 nfet
M$319 \$370 A2|A3|ZN B1|ZN$1 vsubs nfet L=0.6U W=1.32U AS=0.3432P AD=0.3432P
+ PS=1.84U PD=1.84U
* device instance $320 r0 *1 141.2,44.355 nfet
M$320 VSS \$330 \$370 vsubs nfet L=0.6U W=1.32U AS=0.3432P AD=0.363P PS=1.84U
+ PD=2.02U
* device instance $321 r0 *1 33.62,44.62 nfet
M$321 VSS A1|A2|C|S|ZN \$335 vsubs nfet L=0.6U W=0.66U AS=0.2904P AD=0.1716P
+ PS=2.2U PD=1.18U
* device instance $322 r0 *1 34.74,44.62 nfet
M$322 \$378 A1|A2|I0|ZN VSS vsubs nfet L=0.6U W=0.66U AS=0.1716P AD=0.0792P
+ PS=1.18U PD=0.9U
* device instance $323 r0 *1 35.58,44.62 nfet
M$323 \$336 \$335 \$378 vsubs nfet L=0.6U W=0.66U AS=0.0792P AD=0.1716P PS=0.9U
+ PD=1.18U
* device instance $324 r0 *1 36.7,44.62 nfet
M$324 \$379 A1|A2|C|S|ZN \$336 vsubs nfet L=0.6U W=0.66U AS=0.1716P AD=0.0792P
+ PS=1.18U PD=0.9U
* device instance $325 r0 *1 37.54,44.62 nfet
M$325 \$379 I1|Z VSS vsubs nfet L=0.6U W=0.66U AS=0.363P AD=0.0792P PS=2.02U
+ PD=0.9U
* device instance $326 r0 *1 38.84,44.36 nfet
M$326 A2|Z$1 \$336 VSS vsubs nfet L=0.6U W=1.32U AS=0.363P AD=0.5808P PS=2.02U
+ PD=3.52U
* device instance $327 r0 *1 77.08,44.35 nfet
M$327 \$355 A1|A2|A3|ZN VSS vsubs nfet L=0.6U W=0.36U AS=0.1584P AD=0.0936P
+ PS=1.6U PD=0.88U
* device instance $328 r0 *1 78.2,44.35 nfet
M$328 \$355 A1|data[5] VSS vsubs nfet L=0.6U W=0.36U AS=0.186P AD=0.0936P
+ PS=1.36U PD=0.88U
* device instance $329 r0 *1 79.5,44.2 nfet
M$329 \$341 \$355 VSS vsubs nfet L=0.6U W=0.66U AS=0.186P AD=0.1716P PS=1.36U
+ PD=1.18U
* device instance $330 r0 *1 80.62,44.2 nfet
M$330 \$374 A1|data[5] \$341 vsubs nfet L=0.6U W=0.66U AS=0.1716P AD=0.1056P
+ PS=1.18U PD=0.98U
* device instance $331 r0 *1 81.54,44.2 nfet
M$331 VSS A1|A2|A3|ZN \$374 vsubs nfet L=0.6U W=0.66U AS=0.1056P AD=0.2904P
+ PS=0.98U PD=2.2U
* device instance $332 r0 *1 97.64,44.23 nfet
M$332 \$329 A1|data[5] VSS vsubs nfet L=0.6U W=0.66U AS=0.363P AD=0.1716P
+ PS=2.02U PD=1.18U
* device instance $333 r0 *1 98.76,44.23 nfet
M$333 VSS A1|A2|ZN \$329 vsubs nfet L=0.6U W=0.66U AS=0.1716P AD=0.2904P
+ PS=1.18U PD=2.2U
* device instance $334 r0 *1 94.3,44.36 nfet
M$334 \$376 A1|A2|ZN VSS vsubs nfet L=0.6U W=1.32U AS=0.5808P AD=0.2112P
+ PS=3.52U PD=1.64U
* device instance $335 r0 *1 95.22,44.36 nfet
M$335 A1|A2|Z$1 A1|data[5] \$376 vsubs nfet L=0.6U W=1.32U AS=0.2112P
+ AD=0.3432P PS=1.64U PD=1.84U
* device instance $336 r0 *1 96.34,44.36 nfet
M$336 VSS \$329 A1|A2|Z$1 vsubs nfet L=0.6U W=1.32U AS=0.3432P AD=0.363P
+ PS=1.84U PD=2.02U
* device instance $337 r0 *1 145.26,44.3 nfet
M$337 \$371 A2|A3|B|ZN VSS vsubs nfet L=0.6U W=0.66U AS=0.2904P AD=0.1056P
+ PS=2.2U PD=0.98U
* device instance $338 r0 *1 146.18,44.3 nfet
M$338 \$348 A1|B|Z \$371 vsubs nfet L=0.6U W=0.66U AS=0.1056P AD=0.1716P
+ PS=0.98U PD=1.18U
* device instance $339 r0 *1 147.3,44.3 nfet
M$339 VSS \$332 \$348 vsubs nfet L=0.6U W=0.66U AS=0.1716P AD=0.186P PS=1.18U
+ PD=1.36U
* device instance $340 r0 *1 148.6,44.45 nfet
M$340 \$332 A1|B|Z VSS vsubs nfet L=0.6U W=0.36U AS=0.186P AD=0.0936P PS=1.36U
+ PD=0.88U
* device instance $341 r0 *1 149.72,44.45 nfet
M$341 VSS A2|A3|B|ZN \$332 vsubs nfet L=0.6U W=0.36U AS=0.0936P AD=0.1584P
+ PS=0.88U PD=1.6U
* device instance $342 r0 *1 15.06,54.28 nfet
M$342 \$423 \$422 VSS vsubs nfet L=0.6U W=0.66U AS=0.2904P AD=0.1716P PS=2.2U
+ PD=1.18U
* device instance $343 r0 *1 16.18,54.28 nfet
M$343 \$423 A3|B|ZN VSS vsubs nfet L=0.6U W=0.66U AS=0.363P AD=0.1716P PS=2.02U
+ PD=1.18U
* device instance $344 r0 *1 17.48,54.435 nfet
M$344 A2|A3|Z$3 \$423 VSS vsubs nfet L=0.6U W=1.32U AS=0.363P AD=0.3432P
+ PS=2.02U PD=1.84U
* device instance $345 r0 *1 18.6,54.435 nfet
M$345 \$454 A3|B|ZN A2|A3|Z$3 vsubs nfet L=0.6U W=1.32U AS=0.3432P AD=0.2112P
+ PS=1.84U PD=1.64U
* device instance $346 r0 *1 19.52,54.435 nfet
M$346 VSS \$422 \$454 vsubs nfet L=0.6U W=1.32U AS=0.2112P AD=0.5808P PS=1.64U
+ PD=3.52U
* device instance $347 r0 *1 29.3,46.365 nfet
M$347 A1|A2|ZN$1 A1|A2|A3|ZN \$382 vsubs nfet L=0.6U W=1.32U AS=0.5808P
+ AD=0.3432P PS=3.52U PD=1.84U
* device instance $348 r0 *1 30.42,46.365 nfet
M$348 \$382 A1|A2|I0|ZN A1|A2|ZN$1 vsubs nfet L=0.6U W=1.32U AS=0.3432P
+ AD=0.3432P PS=1.84U PD=1.84U
* device instance $349 r0 *1 31.54,46.365 nfet
M$349 VSS \$383 \$382 vsubs nfet L=0.6U W=1.32U AS=0.3432P AD=0.363P PS=1.84U
+ PD=2.02U
* device instance $350 r0 *1 32.84,46.695 nfet
M$350 \$403 A1|A2|I0|ZN VSS vsubs nfet L=0.6U W=0.66U AS=0.363P AD=0.1056P
+ PS=2.02U PD=0.98U
* device instance $351 r0 *1 33.76,46.695 nfet
M$351 \$383 A1|A2|A3|ZN \$403 vsubs nfet L=0.6U W=0.66U AS=0.1056P AD=0.2904P
+ PS=0.98U PD=2.2U
* device instance $352 r0 *1 36.2,54.105 nfet
M$352 \$452 A1|A2|ZN$2 VSS vsubs nfet L=0.6U W=0.66U AS=0.363P AD=0.1056P
+ PS=2.02U PD=0.98U
* device instance $353 r0 *1 37.12,54.105 nfet
M$353 \$426 A1|A2|A3|ZN \$452 vsubs nfet L=0.6U W=0.66U AS=0.1056P AD=0.2904P
+ PS=0.98U PD=2.2U
* device instance $354 r0 *1 32.66,54.435 nfet
M$354 A1|A2|ZN$3 A1|A2|A3|ZN \$446 vsubs nfet L=0.6U W=1.32U AS=0.5808P
+ AD=0.3432P PS=3.52U PD=1.84U
* device instance $355 r0 *1 33.78,54.435 nfet
M$355 \$446 A1|A2|ZN$2 A1|A2|ZN$3 vsubs nfet L=0.6U W=1.32U AS=0.3432P
+ AD=0.3432P PS=1.84U PD=1.84U
* device instance $356 r0 *1 34.9,54.435 nfet
M$356 VSS \$426 \$446 vsubs nfet L=0.6U W=1.32U AS=0.3432P AD=0.363P PS=1.84U
+ PD=2.02U
* device instance $357 r0 *1 45.72,54.435 nfet
M$357 A2|ZN$16 A2|ZN$20 \$447 vsubs nfet L=0.6U W=1.32U AS=0.5808P AD=0.3432P
+ PS=3.52U PD=1.84U
* device instance $358 r0 *1 46.84,54.435 nfet
M$358 \$447 A1|A2|B|B2|C|Z A2|ZN$16 vsubs nfet L=0.6U W=1.32U AS=0.3432P
+ AD=0.3432P PS=1.84U PD=1.84U
* device instance $359 r0 *1 47.96,54.435 nfet
M$359 VSS B|ZN$6 \$447 vsubs nfet L=0.6U W=1.32U AS=0.3432P AD=0.5808P PS=1.84U
+ PD=3.52U
* device instance $360 r0 *1 46.84,46.63 nfet
M$360 VSS CLK|clk \$397 vsubs nfet L=0.6U W=0.79U AS=0.3476P AD=0.2054P
+ PS=2.46U PD=1.31U
* device instance $361 r0 *1 47.96,46.63 nfet
M$361 \$384 \$397 VSS vsubs nfet L=0.6U W=0.79U AS=0.2054P AD=0.3476P PS=1.31U
+ PD=2.46U
* device instance $362 r0 *1 49.8,46.735 nfet
M$362 \$404 \$397 VSS vsubs nfet L=0.6U W=0.58U AS=0.2552P AD=0.0696P PS=2.04U
+ PD=0.82U
* device instance $363 r0 *1 50.64,46.735 nfet
M$363 \$398 D|ZN$9 \$404 vsubs nfet L=0.6U W=0.58U AS=0.0696P AD=0.1508P
+ PS=0.82U PD=1.1U
* device instance $364 r0 *1 51.76,46.735 nfet
M$364 \$405 \$384 \$398 vsubs nfet L=0.6U W=0.58U AS=0.1508P AD=0.0696P PS=1.1U
+ PD=0.82U
* device instance $365 r0 *1 52.6,46.735 nfet
M$365 \$405 \$385 VSS vsubs nfet L=0.6U W=0.58U AS=0.39315P AD=0.0696P PS=2.35U
+ PD=0.82U
* device instance $366 r0 *1 54.1,46.735 nfet
M$366 \$385 \$398 VSS vsubs nfet L=0.6U W=0.58U AS=0.39315P AD=0.1508P PS=2.35U
+ PD=1.1U
* device instance $367 r0 *1 55.22,46.735 nfet
M$367 \$399 \$384 \$385 vsubs nfet L=0.6U W=0.58U AS=0.1508P AD=0.1508P PS=1.1U
+ PD=1.1U
* device instance $368 r0 *1 56.34,46.735 nfet
M$368 \$406 \$397 \$399 vsubs nfet L=0.6U W=0.58U AS=0.1508P AD=0.0696P PS=1.1U
+ PD=0.82U
* device instance $369 r0 *1 57.18,46.735 nfet
M$369 \$406 \$386 VSS vsubs nfet L=0.6U W=0.58U AS=0.252P AD=0.0696P PS=1.49U
+ PD=0.82U
* device instance $370 r0 *1 58.52,46.65 nfet
M$370 \$386 \$399 VSS vsubs nfet L=0.6U W=0.75U AS=0.252P AD=0.33P PS=1.49U
+ PD=2.38U
* device instance $371 r0 *1 60.36,46.365 nfet
M$371 Q|tmds[7] \$386 VSS vsubs nfet L=0.6U W=1.32U AS=0.5808P AD=0.5808P
+ PS=3.52U PD=3.52U
* device instance $372 r0 *1 66.82,46.365 nfet
M$372 A2|ZN$15 A1|A2|B2|Z \$387 vsubs nfet L=0.6U W=1.32U AS=0.5808P AD=0.3432P
+ PS=3.52U PD=1.84U
* device instance $373 r0 *1 67.94,46.365 nfet
M$373 \$387 A1|A2|B1|Z A2|ZN$15 vsubs nfet L=0.6U W=1.32U AS=0.3432P AD=0.3432P
+ PS=1.84U PD=1.84U
* device instance $374 r0 *1 69.06,46.365 nfet
M$374 VSS \$389 \$387 vsubs nfet L=0.6U W=1.32U AS=0.3432P AD=0.363P PS=1.84U
+ PD=2.02U
* device instance $375 r0 *1 70.36,46.695 nfet
M$375 \$408 A1|A2|B1|Z VSS vsubs nfet L=0.6U W=0.66U AS=0.363P AD=0.1056P
+ PS=2.02U PD=0.98U
* device instance $376 r0 *1 71.28,46.695 nfet
M$376 \$389 A1|A2|B2|Z \$408 vsubs nfet L=0.6U W=0.66U AS=0.1056P AD=0.2904P
+ PS=0.98U PD=2.2U
* device instance $377 r0 *1 85.48,54.435 nfet
M$377 \$448 A3|Z$1 VSS vsubs nfet L=0.6U W=1.32U AS=0.5808P AD=0.3432P PS=3.52U
+ PD=1.84U
* device instance $378 r0 *1 86.6,54.435 nfet
M$378 VSS A2|ZN$18 \$448 vsubs nfet L=0.6U W=1.32U AS=0.3432P AD=0.3432P
+ PS=1.84U PD=1.84U
* device instance $379 r0 *1 87.72,54.435 nfet
M$379 \$448 A1|B|Z VSS vsubs nfet L=0.6U W=1.32U AS=0.3432P AD=0.3432P PS=1.84U
+ PD=1.84U
* device instance $380 r0 *1 88.84,54.435 nfet
M$380 A3|B|ZN A1|A2|B1|Z \$448 vsubs nfet L=0.6U W=1.32U AS=0.3432P AD=0.3432P
+ PS=1.84U PD=1.84U
* device instance $381 r0 *1 89.96,54.435 nfet
M$381 \$448 A3|B2|ZN A3|B|ZN vsubs nfet L=0.6U W=1.32U AS=0.3432P AD=0.5808P
+ PS=1.84U PD=3.52U
* device instance $382 r0 *1 86.44,46.4 nfet
M$382 A2|ZN$18 A1|data[6] VSS vsubs nfet L=0.6U W=0.92U AS=0.4048P AD=0.2392P
+ PS=2.72U PD=1.44U
* device instance $383 r0 *1 87.56,46.4 nfet
M$383 VSS A1|A2|Z$1 A2|ZN$18 vsubs nfet L=0.6U W=0.92U AS=0.2392P AD=0.4048P
+ PS=1.44U PD=2.72U
* device instance $384 r0 *1 97.84,46.695 nfet
M$384 \$407 A1|A2|B1|Z \$391 vsubs nfet L=0.6U W=0.66U AS=0.2904P AD=0.1056P
+ PS=2.2U PD=0.98U
* device instance $385 r0 *1 98.76,46.695 nfet
M$385 \$407 A1|data[6] VSS vsubs nfet L=0.6U W=0.66U AS=0.363P AD=0.1056P
+ PS=2.02U PD=0.98U
* device instance $386 r0 *1 100.06,46.365 nfet
M$386 \$392 \$391 VSS vsubs nfet L=0.6U W=1.32U AS=0.363P AD=0.3432P PS=2.02U
+ PD=1.84U
* device instance $387 r0 *1 101.18,46.365 nfet
M$387 A2|ZN$17 A1|data[6] \$392 vsubs nfet L=0.6U W=1.32U AS=0.3432P AD=0.3432P
+ PS=1.84U PD=1.84U
* device instance $388 r0 *1 102.3,46.365 nfet
M$388 \$392 A1|A2|B1|Z A2|ZN$17 vsubs nfet L=0.6U W=1.32U AS=0.3432P AD=0.5808P
+ PS=1.84U PD=3.52U
* device instance $389 r0 *1 109.595,54.435 nfet
M$389 \$456 A1|A2|C|S|ZN B|ZN$5 vsubs nfet L=0.6U W=1.32U AS=0.5808P AD=0.2112P
+ PS=3.52U PD=1.64U
* device instance $390 r0 *1 110.515,54.435 nfet
M$390 VSS A2|ZN$21 \$456 vsubs nfet L=0.6U W=1.32U AS=0.2112P AD=0.5808P
+ PS=1.64U PD=3.52U
* device instance $391 r0 *1 119.085,54.435 nfet
M$391 \$455 A1|A2|ZN$2 VSS vsubs nfet L=0.6U W=1.32U AS=0.5808P AD=0.2112P
+ PS=3.52U PD=1.64U
* device instance $392 r0 *1 120.005,54.435 nfet
M$392 A1|B1|ZN A1|A2|I|data[0] \$455 vsubs nfet L=0.6U W=1.32U AS=0.2112P
+ AD=0.5808P PS=1.64U PD=3.52U
* device instance $393 r0 *1 125.855,46.035 nfet
M$393 \$393 A1|ZN VSS vsubs nfet L=0.6U W=0.66U AS=0.2904P AD=0.1716P PS=2.2U
+ PD=1.18U
* device instance $394 r0 *1 126.975,46.035 nfet
M$394 VSS A1|A2|I0|ZN \$393 vsubs nfet L=0.6U W=0.66U AS=0.1716P AD=0.3828P
+ PS=1.18U PD=2.08U
* device instance $395 r0 *1 128.335,46.365 nfet
M$395 A1|Z$2 \$393 VSS vsubs nfet L=0.6U W=1.32U AS=0.3828P AD=0.5808P PS=2.08U
+ PD=3.52U
* device instance $396 r0 *1 141.48,46.695 nfet
M$396 \$402 A1|Z$2 \$394 vsubs nfet L=0.6U W=0.66U AS=0.2904P AD=0.1056P
+ PS=2.2U PD=0.98U
* device instance $397 r0 *1 142.4,46.695 nfet
M$397 \$401 A2|ZN$14 \$402 vsubs nfet L=0.6U W=0.66U AS=0.1056P AD=0.1386P
+ PS=0.98U PD=1.08U
* device instance $398 r0 *1 143.42,46.695 nfet
M$398 \$401 A2|A3|B|ZN VSS vsubs nfet L=0.6U W=0.66U AS=0.4158P AD=0.1386P
+ PS=2.18U PD=1.08U
* device instance $399 r0 *1 144.88,46.365 nfet
M$399 A1|Z$3 \$394 VSS vsubs nfet L=0.6U W=1.32U AS=0.4158P AD=0.5808P PS=2.18U
+ PD=3.52U
* device instance $400 r0 *1 142.6,54.435 nfet
M$400 A1|ZN$6 A2|ZN$12 \$450 vsubs nfet L=0.6U W=1.32U AS=0.5808P AD=0.3432P
+ PS=3.52U PD=1.84U
* device instance $401 r0 *1 143.72,54.435 nfet
M$401 \$450 A1|Z$3 A1|ZN$6 vsubs nfet L=0.6U W=1.32U AS=0.3432P AD=0.3432P
+ PS=1.84U PD=1.84U
* device instance $402 r0 *1 144.84,54.435 nfet
M$402 VSS A1|B|Z \$450 vsubs nfet L=0.6U W=1.32U AS=0.3432P AD=0.5808P PS=1.84U
+ PD=3.52U
* device instance $403 r0 *1 8.76,54.43 nfet
M$403 \$419 A2|ZN$19 VSS vsubs nfet L=0.6U W=0.36U AS=0.1584P AD=0.0936P
+ PS=1.6U PD=0.88U
* device instance $404 r0 *1 9.88,54.43 nfet
M$404 \$419 A1|ZN$3 VSS vsubs nfet L=0.6U W=0.36U AS=0.186P AD=0.0936P PS=1.36U
+ PD=0.88U
* device instance $405 r0 *1 11.18,54.28 nfet
M$405 \$422 \$419 VSS vsubs nfet L=0.6U W=0.66U AS=0.186P AD=0.1716P PS=1.36U
+ PD=1.18U
* device instance $406 r0 *1 12.3,54.28 nfet
M$406 \$451 A1|ZN$3 \$422 vsubs nfet L=0.6U W=0.66U AS=0.1716P AD=0.1056P
+ PS=1.18U PD=0.98U
* device instance $407 r0 *1 13.22,54.28 nfet
M$407 VSS A2|ZN$19 \$451 vsubs nfet L=0.6U W=0.66U AS=0.1056P AD=0.2904P
+ PS=0.98U PD=2.2U
* device instance $408 r0 *1 13.8,56.445 nfet
M$408 \$476 A2|ZN$19 VSS vsubs nfet L=0.6U W=1.32U AS=0.5808P AD=0.2112P
+ PS=3.52U PD=1.64U
* device instance $409 r0 *1 14.72,56.445 nfet
M$409 A2|A4|B1|ZN A1|ZN$3 \$476 vsubs nfet L=0.6U W=1.32U AS=0.2112P AD=0.402P
+ PS=1.64U PD=2.02U
* device instance $410 r0 *1 16.02,56.645 nfet
M$410 VSS A3|B|ZN A2|A4|B1|ZN vsubs nfet L=0.6U W=0.92U AS=0.402P AD=0.4048P
+ PS=2.02U PD=2.72U
* device instance $411 r0 *1 33.44,56.775 nfet
M$411 \$477 A1|A2|B2|Z \$460 vsubs nfet L=0.6U W=0.66U AS=0.2904P AD=0.1056P
+ PS=2.2U PD=0.98U
* device instance $412 r0 *1 34.36,56.775 nfet
M$412 \$477 A1|A2|ZN$3 VSS vsubs nfet L=0.6U W=0.66U AS=0.363P AD=0.1056P
+ PS=2.02U PD=0.98U
* device instance $413 r0 *1 35.66,56.445 nfet
M$413 \$461 \$460 VSS vsubs nfet L=0.6U W=1.32U AS=0.363P AD=0.3432P PS=2.02U
+ PD=1.84U
* device instance $414 r0 *1 36.78,56.445 nfet
M$414 A2|ZN$20 A1|A2|ZN$3 \$461 vsubs nfet L=0.6U W=1.32U AS=0.3432P AD=0.3432P
+ PS=1.84U PD=1.84U
* device instance $415 r0 *1 37.9,56.445 nfet
M$415 \$461 A1|A2|B2|Z A2|ZN$20 vsubs nfet L=0.6U W=1.32U AS=0.3432P AD=0.5808P
+ PS=1.84U PD=3.52U
* device instance $416 r0 *1 48.555,56.445 nfet
M$416 \$478 A1|A2|ZN$2 B|ZN$6 vsubs nfet L=0.6U W=1.32U AS=0.5808P AD=0.2112P
+ PS=3.52U PD=1.64U
* device instance $417 r0 *1 49.475,56.445 nfet
M$417 VSS A1|A2|B|B2|C|Z \$478 vsubs nfet L=0.6U W=1.32U AS=0.2112P AD=0.5808P
+ PS=1.64U PD=3.52U
* device instance $418 r0 *1 68.715,56.445 nfet
M$418 \$480 A1|A2|Z$1 A1|ZN$5 vsubs nfet L=0.6U W=1.32U AS=0.5808P AD=0.2112P
+ PS=3.52U PD=1.64U
* device instance $419 r0 *1 69.635,56.445 nfet
M$419 VSS A1|A2|B|B2|C|Z \$480 vsubs nfet L=0.6U W=1.32U AS=0.2112P AD=0.5808P
+ PS=1.64U PD=3.52U
* device instance $420 r0 *1 69.8,54.31 nfet
M$420 \$427 A1|A2|A3|ZN VSS vsubs nfet L=0.6U W=0.66U AS=0.2904P AD=0.1716P
+ PS=2.2U PD=1.18U
* device instance $421 r0 *1 70.92,54.31 nfet
M$421 \$427 A1|A2|Z$1 VSS vsubs nfet L=0.6U W=0.66U AS=0.363P AD=0.1716P
+ PS=2.02U PD=1.18U
* device instance $422 r0 *1 72.22,54.44 nfet
M$422 A1|A2|B1|Z \$427 VSS vsubs nfet L=0.6U W=1.32U AS=0.363P AD=0.3432P
+ PS=2.02U PD=1.84U
* device instance $423 r0 *1 73.34,54.44 nfet
M$423 \$457 A1|A2|Z$1 A1|A2|B1|Z vsubs nfet L=0.6U W=1.32U AS=0.3432P
+ AD=0.2112P PS=1.84U PD=1.64U
* device instance $424 r0 *1 74.26,54.44 nfet
M$424 VSS A1|A2|A3|ZN \$457 vsubs nfet L=0.6U W=1.32U AS=0.2112P AD=0.5808P
+ PS=1.64U PD=3.52U
* device instance $425 r0 *1 83.14,56.5 nfet
M$425 \$470 A3|B2|ZN VSS vsubs nfet L=0.6U W=0.66U AS=0.363P AD=0.1056P
+ PS=2.02U PD=0.98U
* device instance $426 r0 *1 84.06,56.5 nfet
M$426 \$453 \$463 \$470 vsubs nfet L=0.6U W=0.66U AS=0.1056P AD=0.2904P
+ PS=0.98U PD=2.2U
* device instance $427 r0 *1 79.6,56.445 nfet
M$427 A1|ZN$10 \$463 \$462 vsubs nfet L=0.6U W=1.32U AS=0.5808P AD=0.3432P
+ PS=3.52U PD=1.84U
* device instance $428 r0 *1 80.72,56.445 nfet
M$428 \$462 A3|B2|ZN A1|ZN$10 vsubs nfet L=0.6U W=1.32U AS=0.3432P AD=0.3432P
+ PS=1.84U PD=1.84U
* device instance $429 r0 *1 81.84,56.445 nfet
M$429 VSS \$453 \$462 vsubs nfet L=0.6U W=1.32U AS=0.3432P AD=0.363P PS=1.84U
+ PD=2.02U
* device instance $430 r0 *1 98.36,56.57 nfet
M$430 \$465 A1|A2|Z$1 VSS vsubs nfet L=0.6U W=0.66U AS=0.2904P AD=0.1716P
+ PS=2.2U PD=1.18U
* device instance $431 r0 *1 99.48,56.57 nfet
M$431 \$465 A1|data[6] VSS vsubs nfet L=0.6U W=0.66U AS=0.363P AD=0.1716P
+ PS=2.02U PD=1.18U
* device instance $432 r0 *1 100.78,56.44 nfet
M$432 A1|A2|Z$2 \$465 VSS vsubs nfet L=0.6U W=1.32U AS=0.363P AD=0.3432P
+ PS=2.02U PD=1.84U
* device instance $433 r0 *1 101.9,56.44 nfet
M$433 \$481 A1|data[6] A1|A2|Z$2 vsubs nfet L=0.6U W=1.32U AS=0.3432P
+ AD=0.2112P PS=1.84U PD=1.64U
* device instance $434 r0 *1 102.82,56.44 nfet
M$434 VSS A1|A2|Z$1 \$481 vsubs nfet L=0.6U W=1.32U AS=0.2112P AD=0.5808P
+ PS=1.64U PD=3.52U
* device instance $435 r0 *1 108.445,56.445 nfet
M$435 \$479 A1|A2|Z$2 VSS vsubs nfet L=0.6U W=1.32U AS=0.5808P AD=0.2112P
+ PS=3.52U PD=1.64U
* device instance $436 r0 *1 109.365,56.445 nfet
M$436 A1|B2|ZN$1 A1|data[7] \$479 vsubs nfet L=0.6U W=1.32U AS=0.2112P
+ AD=0.5808P PS=1.64U PD=3.52U
* device instance $437 r0 *1 123.56,54.4 nfet
M$437 A1|A2|B|ZN A2|ZN$22 VSS vsubs nfet L=0.6U W=0.92U AS=0.4048P AD=0.2392P
+ PS=2.72U PD=1.44U
* device instance $438 r0 *1 124.68,54.4 nfet
M$438 VSS A1|ZN$7 A1|A2|B|ZN vsubs nfet L=0.6U W=0.92U AS=0.2392P AD=0.4048P
+ PS=1.44U PD=2.72U
* device instance $439 r0 *1 140.985,56.445 nfet
M$439 \$475 A1|B2|ZN$1 VSS vsubs nfet L=0.6U W=1.32U AS=0.5808P AD=0.2112P
+ PS=3.52U PD=1.64U
* device instance $440 r0 *1 141.905,56.445 nfet
M$440 A2|B2|ZN B1|ZN$1 \$475 vsubs nfet L=0.6U W=1.32U AS=0.2112P AD=0.3432P
+ PS=1.64U PD=1.84U
* device instance $441 r0 *1 143.025,56.445 nfet
M$441 \$474 A1|ZN$6 A2|B2|ZN vsubs nfet L=0.6U W=1.32U AS=0.3432P AD=0.2112P
+ PS=1.84U PD=1.64U
* device instance $442 r0 *1 143.945,56.445 nfet
M$442 VSS A2|ZN$10 \$474 vsubs nfet L=0.6U W=1.32U AS=0.2112P AD=0.5808P
+ PS=1.64U PD=3.52U
* device instance $443 r0 *1 10.44,56.48 nfet
M$443 A1|A2|B2|ZN A2|ZN$19 VSS vsubs nfet L=0.6U W=0.92U AS=0.4048P AD=0.2392P
+ PS=2.72U PD=1.44U
* device instance $444 r0 *1 11.56,56.48 nfet
M$444 VSS A1|ZN$3 A1|A2|B2|ZN vsubs nfet L=0.6U W=0.92U AS=0.2392P AD=0.4048P
+ PS=1.44U PD=2.72U
* device instance $445 r0 *1 17.86,64.46 nfet
M$445 \$534 \$505 \$506 vsubs nfet L=0.6U W=0.66U AS=0.2904P AD=0.1056P PS=2.2U
+ PD=0.98U
* device instance $446 r0 *1 18.78,64.46 nfet
M$446 \$534 A3|B|ZN VSS vsubs nfet L=0.6U W=0.66U AS=0.363P AD=0.1056P PS=2.02U
+ PD=0.98U
* device instance $447 r0 *1 20.08,64.515 nfet
M$447 \$528 \$506 VSS vsubs nfet L=0.6U W=1.32U AS=0.363P AD=0.3432P PS=2.02U
+ PD=1.84U
* device instance $448 r0 *1 21.2,64.515 nfet
M$448 A2|A3|I1|ZN A3|B|ZN \$528 vsubs nfet L=0.6U W=1.32U AS=0.3432P AD=0.3432P
+ PS=1.84U PD=1.84U
* device instance $449 r0 *1 22.32,64.515 nfet
M$449 \$528 \$505 A2|A3|I1|ZN vsubs nfet L=0.6U W=1.32U AS=0.3432P AD=0.5808P
+ PS=1.84U PD=3.52U
* device instance $450 r0 *1 35.08,64.185 nfet
M$450 \$532 A1|ZN$10 VSS vsubs nfet L=0.6U W=0.66U AS=0.363P AD=0.1056P
+ PS=2.02U PD=0.98U
* device instance $451 r0 *1 36,64.185 nfet
M$451 \$490 A1|A2|ZN$3 \$532 vsubs nfet L=0.6U W=0.66U AS=0.1056P AD=0.2904P
+ PS=0.98U PD=2.2U
* device instance $452 r0 *1 31.54,64.515 nfet
M$452 A2|B1|I|ZN A1|A2|ZN$3 \$525 vsubs nfet L=0.6U W=1.32U AS=0.5808P
+ AD=0.3432P PS=3.52U PD=1.84U
* device instance $453 r0 *1 32.66,64.515 nfet
M$453 \$525 A1|ZN$10 A2|B1|I|ZN vsubs nfet L=0.6U W=1.32U AS=0.3432P AD=0.3432P
+ PS=1.84U PD=1.84U
* device instance $454 r0 *1 33.78,64.515 nfet
M$454 VSS \$490 \$525 vsubs nfet L=0.6U W=1.32U AS=0.3432P AD=0.363P PS=1.84U
+ PD=2.02U
* device instance $455 r0 *1 50.9,64.46 nfet
M$455 \$536 \$509 \$510 vsubs nfet L=0.6U W=0.66U AS=0.2904P AD=0.1056P PS=2.2U
+ PD=0.98U
* device instance $456 r0 *1 51.82,64.46 nfet
M$456 \$536 A2|A3|ZN$1 VSS vsubs nfet L=0.6U W=0.66U AS=0.363P AD=0.1056P
+ PS=2.02U PD=0.98U
* device instance $457 r0 *1 53.12,64.515 nfet
M$457 \$529 \$510 VSS vsubs nfet L=0.6U W=1.32U AS=0.363P AD=0.3432P PS=2.02U
+ PD=1.84U
* device instance $458 r0 *1 54.24,64.515 nfet
M$458 A2|ZN$24 A2|A3|ZN$1 \$529 vsubs nfet L=0.6U W=1.32U AS=0.3432P AD=0.3432P
+ PS=1.84U PD=1.84U
* device instance $459 r0 *1 55.36,64.515 nfet
M$459 \$529 \$509 A2|ZN$24 vsubs nfet L=0.6U W=1.32U AS=0.3432P AD=0.5808P
+ PS=1.84U PD=3.52U
* device instance $460 r0 *1 57.485,64.4475 nfet
M$460 \$535 A2|A3|ZN$1 VSS vsubs nfet L=0.6U W=1.185U AS=0.5214P AD=0.1422P
+ PS=3.25U PD=1.425U
* device instance $461 r0 *1 58.325,64.4475 nfet
M$461 D|ZN$10 A1|A2|B|B2|C|Z \$535 vsubs nfet L=0.6U W=1.185U AS=0.1422P
+ AD=0.3555P PS=1.425U PD=1.885U
* device instance $462 r0 *1 59.625,64.645 nfet
M$462 VSS B|ZN$7 D|ZN$10 vsubs nfet L=0.6U W=0.79U AS=0.3555P AD=0.2054P
+ PS=1.885U PD=1.31U
* device instance $463 r0 *1 60.745,64.645 nfet
M$463 D|ZN$10 A1|B|C|I|ZN VSS vsubs nfet L=0.6U W=0.79U AS=0.2054P AD=0.3476P
+ PS=1.31U PD=2.46U
* device instance $464 r0 *1 73.02,64.315 nfet
M$464 A2|ZN$1 A1|B|Z$1 VSS vsubs nfet L=0.6U W=0.92U AS=0.4048P AD=0.402P
+ PS=2.72U PD=2.02U
* device instance $465 r0 *1 74.32,64.515 nfet
M$465 \$538 A1|A2|B|ZN A2|ZN$1 vsubs nfet L=0.6U W=1.32U AS=0.402P AD=0.2112P
+ PS=2.02U PD=1.64U
* device instance $466 r0 *1 75.24,64.515 nfet
M$466 VSS A1|A2|B|B2|C|Z \$538 vsubs nfet L=0.6U W=1.32U AS=0.2112P AD=0.5808P
+ PS=1.64U PD=3.52U
* device instance $467 r0 *1 89.24,56.35 nfet
M$467 \$464 A1|data[6] VSS vsubs nfet L=0.6U W=0.36U AS=0.186P AD=0.0936P
+ PS=1.36U PD=0.88U
* device instance $468 r0 *1 90.36,56.35 nfet
M$468 VSS A1|A2|A3|ZN \$464 vsubs nfet L=0.6U W=0.36U AS=0.0936P AD=0.1584P
+ PS=0.88U PD=1.6U
* device instance $469 r0 *1 85.9,56.5 nfet
M$469 \$471 A1|A2|A3|ZN VSS vsubs nfet L=0.6U W=0.66U AS=0.2904P AD=0.1056P
+ PS=2.2U PD=0.98U
* device instance $470 r0 *1 86.82,56.5 nfet
M$470 \$463 A1|data[6] \$471 vsubs nfet L=0.6U W=0.66U AS=0.1056P AD=0.1716P
+ PS=0.98U PD=1.18U
* device instance $471 r0 *1 87.94,56.5 nfet
M$471 VSS \$464 \$463 vsubs nfet L=0.6U W=0.66U AS=0.1716P AD=0.186P PS=1.18U
+ PD=1.36U
* device instance $472 r0 *1 97.28,64.185 nfet
M$472 \$531 A1|A2|Z$1 VSS vsubs nfet L=0.6U W=0.66U AS=0.3894P AD=0.1056P
+ PS=2.06U PD=0.98U
* device instance $473 r0 *1 98.2,64.185 nfet
M$473 \$496 A1|data[6] \$531 vsubs nfet L=0.6U W=0.66U AS=0.1056P AD=0.2904P
+ PS=0.98U PD=2.2U
* device instance $474 r0 *1 95.94,64.515 nfet
M$474 VSS \$496 A1|B|Z vsubs nfet L=0.6U W=1.32U AS=0.5808P AD=0.3894P PS=3.52U
+ PD=2.06U
* device instance $475 r0 *1 109,64.185 nfet
M$475 \$530 A1|data[7] VSS vsubs nfet L=0.6U W=0.66U AS=0.363P AD=0.1056P
+ PS=2.02U PD=0.98U
* device instance $476 r0 *1 109.92,64.185 nfet
M$476 \$497 A1|A2|Z$2 \$530 vsubs nfet L=0.6U W=0.66U AS=0.1056P AD=0.2904P
+ PS=0.98U PD=2.2U
* device instance $477 r0 *1 105.46,64.515 nfet
M$477 A1|A2|ZN$2 A1|A2|Z$2 \$526 vsubs nfet L=0.6U W=1.32U AS=0.5808P
+ AD=0.3432P PS=3.52U PD=1.84U
* device instance $478 r0 *1 106.58,64.515 nfet
M$478 \$526 A1|data[7] A1|A2|ZN$2 vsubs nfet L=0.6U W=1.32U AS=0.3432P
+ AD=0.3432P PS=1.84U PD=1.84U
* device instance $479 r0 *1 107.7,64.515 nfet
M$479 VSS \$497 \$526 vsubs nfet L=0.6U W=1.32U AS=0.3432P AD=0.363P PS=1.84U
+ PD=2.02U
* device instance $480 r0 *1 123.4,56.48 nfet
M$480 A2|ZN$22 A1|B1|ZN VSS vsubs nfet L=0.6U W=0.92U AS=0.4048P AD=0.2392P
+ PS=2.72U PD=1.44U
* device instance $481 r0 *1 124.52,56.48 nfet
M$481 VSS A2|B2|ZN A2|ZN$22 vsubs nfet L=0.6U W=0.92U AS=0.2392P AD=0.4048P
+ PS=1.44U PD=2.72U
* device instance $482 r0 *1 123.56,64.515 nfet
M$482 VSS A2|B2|ZN \$527 vsubs nfet L=0.6U W=1.32U AS=0.5808P AD=0.3432P
+ PS=3.52U PD=1.84U
* device instance $483 r0 *1 124.68,64.515 nfet
M$483 \$527 A1|B1|ZN VSS vsubs nfet L=0.6U W=1.32U AS=0.3432P AD=0.3432P
+ PS=1.84U PD=1.84U
* device instance $484 r0 *1 125.8,64.515 nfet
M$484 A1|A2|A3|ZN A1|ZN$8 \$527 vsubs nfet L=0.6U W=1.32U AS=0.3432P AD=0.3432P
+ PS=1.84U PD=1.84U
* device instance $485 r0 *1 126.92,64.515 nfet
M$485 \$527 A2|ZN$25 A1|A2|A3|ZN vsubs nfet L=0.6U W=1.32U AS=0.3432P
+ AD=0.5808P PS=1.84U PD=3.52U
* device instance $486 r0 *1 127.32,56.48 nfet
M$486 A1|ZN$7 A1|ZN$8 VSS vsubs nfet L=0.6U W=0.92U AS=0.4048P AD=0.2392P
+ PS=2.72U PD=1.44U
* device instance $487 r0 *1 128.44,56.48 nfet
M$487 VSS A2|ZN$25 A1|ZN$7 vsubs nfet L=0.6U W=0.92U AS=0.2392P AD=0.4048P
+ PS=1.44U PD=2.72U
* device instance $488 r0 *1 137.4,56.48 nfet
M$488 A1|ZN$8 A1|B2|ZN$1 VSS vsubs nfet L=0.6U W=0.92U AS=0.4048P AD=0.2392P
+ PS=2.72U PD=1.44U
* device instance $489 r0 *1 138.52,56.48 nfet
M$489 VSS A2|ZN$23 A1|ZN$8 vsubs nfet L=0.6U W=0.92U AS=0.2392P AD=0.4048P
+ PS=1.44U PD=2.72U
* device instance $490 r0 *1 11.56,64.61 nfet
M$490 \$504 A2|ZN$19 VSS vsubs nfet L=0.6U W=0.36U AS=0.1584P AD=0.0936P
+ PS=1.6U PD=0.88U
* device instance $491 r0 *1 12.68,64.61 nfet
M$491 \$504 A1|ZN$3 VSS vsubs nfet L=0.6U W=0.36U AS=0.186P AD=0.0936P PS=1.36U
+ PD=0.88U
* device instance $492 r0 *1 13.98,64.46 nfet
M$492 \$505 \$504 VSS vsubs nfet L=0.6U W=0.66U AS=0.186P AD=0.1716P PS=1.36U
+ PD=1.18U
* device instance $493 r0 *1 15.1,64.46 nfet
M$493 \$533 A1|ZN$3 \$505 vsubs nfet L=0.6U W=0.66U AS=0.1716P AD=0.1056P
+ PS=1.18U PD=0.98U
* device instance $494 r0 *1 16.02,64.46 nfet
M$494 VSS A2|ZN$19 \$533 vsubs nfet L=0.6U W=0.66U AS=0.1056P AD=0.2904P
+ PS=0.98U PD=2.2U
* device instance $495 r0 *1 12.68,66.525 nfet
M$495 VSS A1|A2|B2|ZN \$539 vsubs nfet L=0.6U W=1.32U AS=0.5808P AD=0.3432P
+ PS=3.52U PD=1.84U
* device instance $496 r0 *1 13.8,66.525 nfet
M$496 \$539 A2|A4|B1|ZN VSS vsubs nfet L=0.6U W=1.32U AS=0.3432P AD=0.3432P
+ PS=1.84U PD=1.84U
* device instance $497 r0 *1 14.92,66.525 nfet
M$497 A1|A2|ZN$4 A1|ZN$9 \$539 vsubs nfet L=0.6U W=1.32U AS=0.3432P AD=0.3432P
+ PS=1.84U PD=1.84U
* device instance $498 r0 *1 16.04,66.525 nfet
M$498 \$539 A2|A3|I1|ZN A1|A2|ZN$4 vsubs nfet L=0.6U W=1.32U AS=0.3432P
+ AD=0.5808P PS=1.84U PD=3.52U
* device instance $499 r0 *1 36.8,66.855 nfet
M$499 \$559 A2|B1|I|ZN \$543 vsubs nfet L=0.6U W=0.66U AS=0.2904P AD=0.1056P
+ PS=2.2U PD=0.98U
* device instance $500 r0 *1 37.72,66.855 nfet
M$500 \$559 A1|B3|ZN VSS vsubs nfet L=0.6U W=0.66U AS=0.363P AD=0.1056P
+ PS=2.02U PD=0.98U
* device instance $501 r0 *1 39.02,66.525 nfet
M$501 \$545 \$543 VSS vsubs nfet L=0.6U W=1.32U AS=0.363P AD=0.3432P PS=2.02U
+ PD=1.84U
* device instance $502 r0 *1 40.14,66.525 nfet
M$502 A2|A3|ZN$1 A1|B3|ZN \$545 vsubs nfet L=0.6U W=1.32U AS=0.3432P AD=0.3432P
+ PS=1.84U PD=1.84U
* device instance $503 r0 *1 41.26,66.525 nfet
M$503 \$545 A2|B1|I|ZN A2|A3|ZN$1 vsubs nfet L=0.6U W=1.32U AS=0.3432P
+ AD=0.5808P PS=1.84U PD=3.52U
* device instance $504 r0 *1 44.6,64.61 nfet
M$504 \$507 A1|A2|B2|Z VSS vsubs nfet L=0.6U W=0.36U AS=0.1584P AD=0.0936P
+ PS=1.6U PD=0.88U
* device instance $505 r0 *1 45.72,64.61 nfet
M$505 \$507 A1|A2|B|ZN VSS vsubs nfet L=0.6U W=0.36U AS=0.186P AD=0.0936P
+ PS=1.36U PD=0.88U
* device instance $506 r0 *1 47.02,64.46 nfet
M$506 \$509 \$507 VSS vsubs nfet L=0.6U W=0.66U AS=0.186P AD=0.1716P PS=1.36U
+ PD=1.18U
* device instance $507 r0 *1 48.14,64.46 nfet
M$507 \$537 A1|A2|B|ZN \$509 vsubs nfet L=0.6U W=0.66U AS=0.1716P AD=0.1056P
+ PS=1.18U PD=0.98U
* device instance $508 r0 *1 49.06,64.46 nfet
M$508 VSS A1|A2|B2|Z \$537 vsubs nfet L=0.6U W=0.66U AS=0.1056P AD=0.2904P
+ PS=0.98U PD=2.2U
* device instance $509 r0 *1 75.48,66.525 nfet
M$509 A1|I|Q \$551 VSS vsubs nfet L=0.6U W=1.32U AS=0.5808P AD=0.5808P PS=3.52U
+ PD=3.52U
* device instance $510 r0 *1 93.935,66.195 nfet
M$510 \$553 A1|Z$4 VSS vsubs nfet L=0.6U W=0.66U AS=0.2904P AD=0.1716P PS=2.2U
+ PD=1.18U
* device instance $511 r0 *1 95.055,66.195 nfet
M$511 VSS A2|ZN$26 \$553 vsubs nfet L=0.6U W=0.66U AS=0.1716P AD=0.3828P
+ PS=1.18U PD=2.08U
* device instance $512 r0 *1 96.415,66.525 nfet
M$512 A1|A2|B|B2|C|Z \$553 VSS vsubs nfet L=0.6U W=1.32U AS=0.3828P AD=0.5808P
+ PS=2.08U PD=3.52U
* device instance $513 r0 *1 106.24,66.855 nfet
M$513 \$564 A1|A2|B2|Z \$555 vsubs nfet L=0.6U W=0.66U AS=0.2904P AD=0.1056P
+ PS=2.2U PD=0.98U
* device instance $514 r0 *1 107.16,66.855 nfet
M$514 \$564 A1|A2|Z$2 VSS vsubs nfet L=0.6U W=0.66U AS=0.363P AD=0.1056P
+ PS=2.02U PD=0.98U
* device instance $515 r0 *1 108.46,66.525 nfet
M$515 \$556 \$555 VSS vsubs nfet L=0.6U W=1.32U AS=0.363P AD=0.3432P PS=2.02U
+ PD=1.84U
* device instance $516 r0 *1 109.58,66.525 nfet
M$516 A2|ZN$21 A1|A2|Z$2 \$556 vsubs nfet L=0.6U W=1.32U AS=0.3432P AD=0.3432P
+ PS=1.84U PD=1.84U
* device instance $517 r0 *1 110.7,66.525 nfet
M$517 \$556 A1|A2|B2|Z A2|ZN$21 vsubs nfet L=0.6U W=1.32U AS=0.3432P AD=0.5808P
+ PS=1.84U PD=3.52U
* device instance $518 r0 *1 142.075,66.525 nfet
M$518 \$558 A1|ZN$6 A2|ZN$25 vsubs nfet L=0.6U W=1.32U AS=0.5808P AD=0.2112P
+ PS=3.52U PD=1.64U
* device instance $519 r0 *1 142.995,66.525 nfet
M$519 VSS A2|ZN$10 \$558 vsubs nfet L=0.6U W=1.32U AS=0.2112P AD=0.5808P
+ PS=1.64U PD=3.52U
* device instance $520 r0 *1 142.6,64.48 nfet
M$520 A2|ZN$23 A2|ZN$12 VSS vsubs nfet L=0.6U W=0.92U AS=0.4048P AD=0.2392P
+ PS=2.72U PD=1.44U
* device instance $521 r0 *1 143.72,64.48 nfet
M$521 VSS A1|Z$3 A2|ZN$23 vsubs nfet L=0.6U W=0.92U AS=0.2392P AD=0.4048P
+ PS=1.44U PD=2.72U
* device instance $522 r0 *1 31,66.56 nfet
M$522 A1|A2|I|ZN A1|ZN$10 VSS vsubs nfet L=0.6U W=0.92U AS=0.4048P AD=0.2392P
+ PS=2.72U PD=1.44U
* device instance $523 r0 *1 32.12,66.56 nfet
M$523 VSS A1|A2|ZN$3 A1|A2|I|ZN vsubs nfet L=0.6U W=0.92U AS=0.2392P AD=0.4048P
+ PS=1.44U PD=2.72U
* device instance $524 r0 *1 56.36,66.56 nfet
M$524 B|ZN$7 A2|ZN$24 VSS vsubs nfet L=0.6U W=0.92U AS=0.4048P AD=0.2392P
+ PS=2.72U PD=1.44U
* device instance $525 r0 *1 57.48,66.56 nfet
M$525 VSS A1|A2|B|B2|C|Z B|ZN$7 vsubs nfet L=0.6U W=0.92U AS=0.2392P AD=0.4048P
+ PS=1.44U PD=2.72U
* device instance $526 r0 *1 61.96,66.79 nfet
M$526 VSS CLK|clk \$546 vsubs nfet L=0.6U W=0.79U AS=0.3476P AD=0.2054P
+ PS=2.46U PD=1.31U
* device instance $527 r0 *1 63.08,66.79 nfet
M$527 \$547 \$546 VSS vsubs nfet L=0.6U W=0.79U AS=0.2054P AD=0.3476P PS=1.31U
+ PD=2.46U
* device instance $528 r0 *1 64.92,66.895 nfet
M$528 \$561 \$546 VSS vsubs nfet L=0.6U W=0.58U AS=0.2552P AD=0.0696P PS=2.04U
+ PD=0.82U
* device instance $529 r0 *1 65.76,66.895 nfet
M$529 \$548 D|ZN$10 \$561 vsubs nfet L=0.6U W=0.58U AS=0.0696P AD=0.1508P
+ PS=0.82U PD=1.1U
* device instance $530 r0 *1 66.88,66.895 nfet
M$530 \$562 \$547 \$548 vsubs nfet L=0.6U W=0.58U AS=0.1508P AD=0.0696P PS=1.1U
+ PD=0.82U
* device instance $531 r0 *1 67.72,66.895 nfet
M$531 \$562 \$549 VSS vsubs nfet L=0.6U W=0.58U AS=0.39315P AD=0.0696P PS=2.35U
+ PD=0.82U
* device instance $532 r0 *1 69.22,66.895 nfet
M$532 \$549 \$548 VSS vsubs nfet L=0.6U W=0.58U AS=0.39315P AD=0.1508P PS=2.35U
+ PD=1.1U
* device instance $533 r0 *1 70.34,66.895 nfet
M$533 \$550 \$547 \$549 vsubs nfet L=0.6U W=0.58U AS=0.1508P AD=0.1508P PS=1.1U
+ PD=1.1U
* device instance $534 r0 *1 71.46,66.895 nfet
M$534 \$563 \$546 \$550 vsubs nfet L=0.6U W=0.58U AS=0.1508P AD=0.0696P PS=1.1U
+ PD=0.82U
* device instance $535 r0 *1 72.3,66.895 nfet
M$535 \$563 \$551 VSS vsubs nfet L=0.6U W=0.58U AS=0.252P AD=0.0696P PS=1.49U
+ PD=0.82U
* device instance $536 r0 *1 73.64,66.81 nfet
M$536 \$551 \$550 VSS vsubs nfet L=0.6U W=0.75U AS=0.252P AD=0.33P PS=1.49U
+ PD=2.38U
* device instance $537 r0 *1 124.12,66.855 nfet
M$537 \$560 A1|A2|C|S|ZN \$557 vsubs nfet L=0.6U W=0.66U AS=0.2904P AD=0.1056P
+ PS=2.2U PD=0.98U
* device instance $538 r0 *1 125.04,66.855 nfet
M$538 \$560 A1|A2|B2|Z VSS vsubs nfet L=0.6U W=0.66U AS=0.3894P AD=0.1056P
+ PS=2.06U PD=0.98U
* device instance $539 r0 *1 126.38,66.525 nfet
M$539 A1|B|Z$1 \$557 VSS vsubs nfet L=0.6U W=1.32U AS=0.3894P AD=0.5808P
+ PS=2.06U PD=3.52U
* device instance $540 r0 *1 11,74.3 nfet
M$540 A1|ZN$9 A1|A2|I|ZN VSS vsubs nfet L=0.6U W=0.73U AS=0.3212P AD=0.3212P
+ PS=2.34U PD=2.34U
* device instance $541 r0 *1 13.8,74.56 nfet
M$541 A2|ZN$27 A2|A4|B1|ZN VSS vsubs nfet L=0.6U W=0.92U AS=0.4048P AD=0.2392P
+ PS=2.72U PD=1.44U
* device instance $542 r0 *1 14.92,74.56 nfet
M$542 VSS A1|A2|B2|ZN A2|ZN$27 vsubs nfet L=0.6U W=0.92U AS=0.2392P AD=0.4048P
+ PS=1.44U PD=2.72U
* device instance $543 r0 *1 27.64,74.56 nfet
M$543 S|ZN A1|A2|A3|ZN VSS vsubs nfet L=0.6U W=0.92U AS=0.4048P AD=0.2392P
+ PS=2.72U PD=1.44U
* device instance $544 r0 *1 28.76,74.56 nfet
M$544 VSS A2|B1|I|ZN S|ZN vsubs nfet L=0.6U W=0.92U AS=0.2392P AD=0.4048P
+ PS=1.44U PD=2.72U
* device instance $545 r0 *1 32.12,74.56 nfet
M$545 A2|ZN$28 A1|I|Q VSS vsubs nfet L=0.6U W=0.92U AS=0.4048P AD=0.2392P
+ PS=2.72U PD=1.44U
* device instance $546 r0 *1 33.24,74.56 nfet
M$546 VSS A1|A2|A3|ZN A2|ZN$28 vsubs nfet L=0.6U W=0.92U AS=0.2392P AD=0.4048P
+ PS=1.44U PD=2.72U
* device instance $547 r0 *1 36.04,74.3 nfet
M$547 VSS A1|I|Q A1|B3|ZN vsubs nfet L=0.6U W=0.73U AS=0.3212P AD=0.3212P
+ PS=2.34U PD=2.34U
* device instance $548 r0 *1 49.085,74.595 nfet
M$548 \$618 A2|A3|ZN$1 VSS vsubs nfet L=0.6U W=1.32U AS=0.5808P AD=0.2112P
+ PS=3.52U PD=1.64U
* device instance $549 r0 *1 50.005,74.595 nfet
M$549 A1|ZN$11 A1|A2|B|ZN \$618 vsubs nfet L=0.6U W=1.32U AS=0.2112P AD=0.5808P
+ PS=1.64U PD=3.52U
* device instance $550 r0 *1 81.04,74.265 nfet
M$550 \$616 A1|A2|ZN$4 \$581 vsubs nfet L=0.6U W=0.66U AS=0.2904P AD=0.1056P
+ PS=2.2U PD=0.98U
* device instance $551 r0 *1 81.96,74.265 nfet
M$551 VSS A1|A2|A3|ZN \$616 vsubs nfet L=0.6U W=0.66U AS=0.1056P AD=0.363P
+ PS=0.98U PD=2.02U
* device instance $552 r0 *1 83.26,74.595 nfet
M$552 \$611 \$581 VSS vsubs nfet L=0.6U W=1.32U AS=0.363P AD=0.3432P PS=2.02U
+ PD=1.84U
* device instance $553 r0 *1 84.38,74.595 nfet
M$553 B|ZN$8 A1|A2|A3|ZN \$611 vsubs nfet L=0.6U W=1.32U AS=0.3432P AD=0.3432P
+ PS=1.84U PD=1.84U
* device instance $554 r0 *1 85.5,74.595 nfet
M$554 \$611 A1|A2|ZN$4 B|ZN$8 vsubs nfet L=0.6U W=1.32U AS=0.3432P AD=0.5808P
+ PS=1.84U PD=3.52U
* device instance $555 r0 *1 91.64,74.9 nfet
M$555 A2|ZN$26 A4|Z VSS vsubs nfet L=0.6U W=0.66U AS=0.2904P AD=0.1716P PS=2.2U
+ PD=1.18U
* device instance $556 r0 *1 92.76,74.9 nfet
M$556 VSS A1|A3|I|Q A2|ZN$26 vsubs nfet L=0.6U W=0.66U AS=0.1716P AD=0.1716P
+ PS=1.18U PD=1.18U
* device instance $557 r0 *1 93.88,74.9 nfet
M$557 A2|ZN$26 A1|A2|Q VSS vsubs nfet L=0.6U W=0.66U AS=0.1716P AD=0.1716P
+ PS=1.18U PD=1.18U
* device instance $558 r0 *1 95,74.9 nfet
M$558 VSS A1|I|Q A2|ZN$26 vsubs nfet L=0.6U W=0.66U AS=0.1716P AD=0.2904P
+ PS=1.18U PD=2.2U
* device instance $559 r0 *1 106.2,74.47 nfet
M$559 \$583 A1|A2|ZN$4 VSS vsubs nfet L=0.6U W=0.66U AS=0.2904P AD=0.1716P
+ PS=2.2U PD=1.18U
* device instance $560 r0 *1 107.32,74.47 nfet
M$560 \$583 A1|Q VSS vsubs nfet L=0.6U W=0.66U AS=0.363P AD=0.1716P PS=2.02U
+ PD=1.18U
* device instance $561 r0 *1 108.62,74.6 nfet
M$561 A1|A2|B2|Z \$583 VSS vsubs nfet L=0.6U W=1.32U AS=0.363P AD=0.3432P
+ PS=2.02U PD=1.84U
* device instance $562 r0 *1 109.74,74.6 nfet
M$562 \$617 A1|Q A1|A2|B2|Z vsubs nfet L=0.6U W=1.32U AS=0.3432P AD=0.2112P
+ PS=1.84U PD=1.64U
* device instance $563 r0 *1 110.66,74.6 nfet
M$563 VSS A1|A2|ZN$4 \$617 vsubs nfet L=0.6U W=1.32U AS=0.2112P AD=0.5808P
+ PS=1.64U PD=3.52U
* device instance $564 r0 *1 114.04,74.56 nfet
M$564 D|ZN$11 A2|ZN$29 VSS vsubs nfet L=0.6U W=0.92U AS=0.4048P AD=0.2392P
+ PS=2.72U PD=1.44U
* device instance $565 r0 *1 115.16,74.56 nfet
M$565 VSS A1|B|C|I|ZN D|ZN$11 vsubs nfet L=0.6U W=0.92U AS=0.2392P AD=0.4048P
+ PS=1.44U PD=2.72U
* device instance $566 r0 *1 130.84,74.33 nfet
M$566 VSS CLK|clk \$587 vsubs nfet L=0.6U W=0.79U AS=0.3476P AD=0.2054P
+ PS=2.46U PD=1.31U
* device instance $567 r0 *1 131.96,74.33 nfet
M$567 \$588 \$587 VSS vsubs nfet L=0.6U W=0.79U AS=0.2054P AD=0.3476P PS=1.31U
+ PD=2.46U
* device instance $568 r0 *1 133.8,74.225 nfet
M$568 \$615 \$587 VSS vsubs nfet L=0.6U W=0.58U AS=0.2552P AD=0.0696P PS=2.04U
+ PD=0.82U
* device instance $569 r0 *1 134.64,74.225 nfet
M$569 \$589 D|ZN$12 \$615 vsubs nfet L=0.6U W=0.58U AS=0.0696P AD=0.1508P
+ PS=0.82U PD=1.1U
* device instance $570 r0 *1 135.76,74.225 nfet
M$570 \$614 \$588 \$589 vsubs nfet L=0.6U W=0.58U AS=0.1508P AD=0.0696P PS=1.1U
+ PD=0.82U
* device instance $571 r0 *1 136.6,74.225 nfet
M$571 VSS \$590 \$614 vsubs nfet L=0.6U W=0.58U AS=0.0696P AD=0.39315P PS=0.82U
+ PD=2.35U
* device instance $572 r0 *1 138.1,74.225 nfet
M$572 \$590 \$589 VSS vsubs nfet L=0.6U W=0.58U AS=0.39315P AD=0.1508P PS=2.35U
+ PD=1.1U
* device instance $573 r0 *1 139.22,74.225 nfet
M$573 \$591 \$588 \$590 vsubs nfet L=0.6U W=0.58U AS=0.1508P AD=0.1508P PS=1.1U
+ PD=1.1U
* device instance $574 r0 *1 140.34,74.225 nfet
M$574 \$613 \$587 \$591 vsubs nfet L=0.6U W=0.58U AS=0.1508P AD=0.0696P PS=1.1U
+ PD=0.82U
* device instance $575 r0 *1 141.18,74.225 nfet
M$575 VSS \$592 \$613 vsubs nfet L=0.6U W=0.58U AS=0.0696P AD=0.252P PS=0.82U
+ PD=1.49U
* device instance $576 r0 *1 142.52,74.31 nfet
M$576 \$592 \$591 VSS vsubs nfet L=0.6U W=0.75U AS=0.252P AD=0.33P PS=1.49U
+ PD=2.38U
* device instance $577 r0 *1 144.36,74.595 nfet
M$577 A1|Q \$592 VSS vsubs nfet L=0.6U W=1.32U AS=0.5808P AD=0.5808P PS=3.52U
+ PD=3.52U
* device instance $578 r0 *1 15.84,76.3925 nfet
M$578 \$619 A2|A4|B1|ZN VSS vsubs nfet L=0.6U W=0.395U AS=0.32325P AD=0.14025P
+ PS=2.02U PD=1.135U
* device instance $579 r0 *1 12.12,76.4275 nfet
M$579 \$619 A1|ZN$9 VSS vsubs nfet L=0.6U W=0.395U AS=0.1738P AD=0.1385P
+ PS=1.67U PD=1.1U
* device instance $580 r0 *1 13.42,76.4325 nfet
M$580 VSS A1|A2|B2|ZN \$619 vsubs nfet L=0.6U W=0.395U AS=0.1385P AD=0.1027P
+ PS=1.1U PD=0.915U
* device instance $581 r0 *1 14.54,76.4325 nfet
M$581 VSS A2|A3|I1|ZN \$619 vsubs nfet L=0.6U W=0.395U AS=0.14025P AD=0.1027P
+ PS=1.135U PD=0.915U
* device instance $582 r0 *1 17.14,76.605 nfet
M$582 A2|A3|Z$2 \$619 VSS vsubs nfet L=0.6U W=1.32U AS=0.32325P AD=0.5808P
+ PS=2.02U PD=3.52U
* device instance $583 r0 *1 24.1,76.34 nfet
M$583 VSS S|ZN \$621 vsubs nfet L=0.6U W=0.66U AS=0.2904P AD=0.1716P PS=2.2U
+ PD=1.18U
* device instance $584 r0 *1 25.22,76.34 nfet
M$584 \$645 A1|I0|ZN VSS vsubs nfet L=0.6U W=0.66U AS=0.1716P AD=0.0792P
+ PS=1.18U PD=0.9U
* device instance $585 r0 *1 26.06,76.34 nfet
M$585 \$622 \$621 \$645 vsubs nfet L=0.6U W=0.66U AS=0.0792P AD=0.1716P PS=0.9U
+ PD=1.18U
* device instance $586 r0 *1 27.18,76.34 nfet
M$586 \$646 S|ZN \$622 vsubs nfet L=0.6U W=0.66U AS=0.1716P AD=0.0792P PS=1.18U
+ PD=0.9U
* device instance $587 r0 *1 28.02,76.34 nfet
M$587 \$646 A2|A3|I1|ZN VSS vsubs nfet L=0.6U W=0.66U AS=0.363P AD=0.0792P
+ PS=2.02U PD=0.9U
* device instance $588 r0 *1 29.32,76.6 nfet
M$588 A2|Z$2 \$622 VSS vsubs nfet L=0.6U W=1.32U AS=0.363P AD=0.5808P PS=2.02U
+ PD=3.52U
* device instance $589 r0 *1 47.96,76.51 nfet
M$589 \$624 A2|Z$2 VSS vsubs nfet L=0.6U W=0.36U AS=0.1584P AD=0.0936P PS=1.6U
+ PD=0.88U
* device instance $590 r0 *1 49.08,76.51 nfet
M$590 VSS A1|A2|I|Q \$624 vsubs nfet L=0.6U W=0.36U AS=0.0936P AD=0.186P
+ PS=0.88U PD=1.36U
* device instance $591 r0 *1 50.38,76.66 nfet
M$591 \$625 \$624 VSS vsubs nfet L=0.6U W=0.66U AS=0.186P AD=0.1716P PS=1.36U
+ PD=1.18U
* device instance $592 r0 *1 51.5,76.66 nfet
M$592 \$649 A1|A2|I|Q \$625 vsubs nfet L=0.6U W=0.66U AS=0.1716P AD=0.1056P
+ PS=1.18U PD=0.98U
* device instance $593 r0 *1 52.42,76.66 nfet
M$593 VSS A2|Z$2 \$649 vsubs nfet L=0.6U W=0.66U AS=0.1056P AD=0.2904P PS=0.98U
+ PD=2.2U
* device instance $594 r0 *1 54.26,76.66 nfet
M$594 \$650 \$625 \$633 vsubs nfet L=0.6U W=0.66U AS=0.2904P AD=0.1056P PS=2.2U
+ PD=0.98U
* device instance $595 r0 *1 55.18,76.66 nfet
M$595 \$650 A1|A3|B1|ZN VSS vsubs nfet L=0.6U W=0.66U AS=0.363P AD=0.1056P
+ PS=2.02U PD=0.98U
* device instance $596 r0 *1 56.48,76.605 nfet
M$596 \$626 \$633 VSS vsubs nfet L=0.6U W=1.32U AS=0.363P AD=0.3432P PS=2.02U
+ PD=1.84U
* device instance $597 r0 *1 57.6,76.605 nfet
M$597 A2|ZN$32 A1|A3|B1|ZN \$626 vsubs nfet L=0.6U W=1.32U AS=0.3432P
+ AD=0.3432P PS=1.84U PD=1.84U
* device instance $598 r0 *1 58.72,76.605 nfet
M$598 \$626 \$625 A2|ZN$32 vsubs nfet L=0.6U W=1.32U AS=0.3432P AD=0.5808P
+ PS=1.84U PD=3.52U
* device instance $599 r0 *1 79.4,76.605 nfet
M$599 A1|A2|I|Q \$638 VSS vsubs nfet L=0.6U W=1.32U AS=0.5808P AD=0.5808P
+ PS=3.52U PD=3.52U
* device instance $600 r0 *1 81.56,76.605 nfet
M$600 \$656 A2|Z$3 VSS vsubs nfet L=0.6U W=1.32U AS=0.5808P AD=0.2112P PS=3.52U
+ PD=1.64U
* device instance $601 r0 *1 82.48,76.605 nfet
M$601 A2|ZN$30 A1|ZN$12 \$656 vsubs nfet L=0.6U W=1.32U AS=0.2112P AD=0.402P
+ PS=1.64U PD=2.02U
* device instance $602 r0 *1 83.78,76.805 nfet
M$602 VSS B|ZN$8 A2|ZN$30 vsubs nfet L=0.6U W=0.92U AS=0.402P AD=0.4048P
+ PS=2.02U PD=2.72U
* device instance $603 r0 *1 94.28,76.64 nfet
M$603 A1|A2|C|S|ZN A1|Z$4 VSS vsubs nfet L=0.6U W=0.92U AS=0.4048P AD=0.2392P
+ PS=2.72U PD=1.44U
* device instance $604 r0 *1 95.4,76.64 nfet
M$604 VSS A2|ZN$26 A1|A2|C|S|ZN vsubs nfet L=0.6U W=0.92U AS=0.2392P AD=0.4048P
+ PS=1.44U PD=2.72U
* device instance $605 r0 *1 125.88,76.605 nfet
M$605 A1|A2|Q \$643 VSS vsubs nfet L=0.6U W=1.32U AS=0.5808P AD=0.5808P
+ PS=3.52U PD=3.52U
* device instance $606 r0 *1 133.5,76.805 nfet
M$606 VSS A1|B|C|I|ZN D|ZN$12 vsubs nfet L=0.6U W=0.92U AS=0.402P AD=0.4048P
+ PS=2.02U PD=2.72U
* device instance $607 r0 *1 134.8,76.605 nfet
M$607 \$644 A1|ZN$19 D|ZN$12 vsubs nfet L=0.6U W=1.32U AS=0.402P AD=0.2112P
+ PS=2.02U PD=1.64U
* device instance $608 r0 *1 135.72,76.605 nfet
M$608 VSS A2|ZN$31 \$644 vsubs nfet L=0.6U W=1.32U AS=0.2112P AD=0.5808P
+ PS=1.64U PD=3.52U
* device instance $609 r0 *1 11.6,84.345 nfet
M$609 \$706 A2|A3|Z$3 \$679 vsubs nfet L=0.6U W=0.66U AS=0.2904P AD=0.1056P
+ PS=2.2U PD=0.98U
* device instance $610 r0 *1 12.52,84.345 nfet
M$610 VSS A1|ZN$9 \$706 vsubs nfet L=0.6U W=0.66U AS=0.1056P AD=0.363P PS=0.98U
+ PD=2.02U
* device instance $611 r0 *1 13.82,84.675 nfet
M$611 \$703 \$679 VSS vsubs nfet L=0.6U W=1.32U AS=0.363P AD=0.3432P PS=2.02U
+ PD=1.84U
* device instance $612 r0 *1 14.94,84.675 nfet
M$612 A1|I0|ZN A1|ZN$9 \$703 vsubs nfet L=0.6U W=1.32U AS=0.3432P AD=0.3432P
+ PS=1.84U PD=1.84U
* device instance $613 r0 *1 16.06,84.675 nfet
M$613 \$703 A2|A3|Z$3 A1|I0|ZN vsubs nfet L=0.6U W=1.32U AS=0.3432P AD=0.5808P
+ PS=1.84U PD=3.52U
* device instance $614 r0 *1 39.56,76.935 nfet
M$614 \$647 A1|A2|ZN$4 \$631 vsubs nfet L=0.6U W=0.66U AS=0.2904P AD=0.1056P
+ PS=2.2U PD=0.98U
* device instance $615 r0 *1 40.48,76.935 nfet
M$615 \$647 A2|A3|Z$2 VSS vsubs nfet L=0.6U W=0.66U AS=0.3894P AD=0.1056P
+ PS=2.06U PD=0.98U
* device instance $616 r0 *1 41.82,76.605 nfet
M$616 A2|Z$3 \$631 VSS vsubs nfet L=0.6U W=1.32U AS=0.3894P AD=0.5808P PS=2.06U
+ PD=3.52U
* device instance $617 r0 *1 62.525,84.6075 nfet
M$617 \$709 A2|ZN$32 VSS vsubs nfet L=0.6U W=1.185U AS=0.5214P AD=0.1422P
+ PS=3.25U PD=1.425U
* device instance $618 r0 *1 63.365,84.6075 nfet
M$618 D|ZN$13 A1|A2|B|B2|C|Z \$709 vsubs nfet L=0.6U W=1.185U AS=0.1422P
+ AD=0.3555P PS=1.425U PD=1.885U
* device instance $619 r0 *1 64.665,84.805 nfet
M$619 VSS B|ZN$9 D|ZN$13 vsubs nfet L=0.6U W=0.79U AS=0.3555P AD=0.2054P
+ PS=1.885U PD=1.31U
* device instance $620 r0 *1 65.785,84.805 nfet
M$620 D|ZN$13 A1|B|C|I|ZN VSS vsubs nfet L=0.6U W=0.79U AS=0.2054P AD=0.3476P
+ PS=1.31U PD=2.46U
* device instance $621 r0 *1 65.88,76.87 nfet
M$621 VSS CLK|clk \$634 vsubs nfet L=0.6U W=0.79U AS=0.3476P AD=0.2054P
+ PS=2.46U PD=1.31U
* device instance $622 r0 *1 67,76.87 nfet
M$622 \$627 \$634 VSS vsubs nfet L=0.6U W=0.79U AS=0.2054P AD=0.3476P PS=1.31U
+ PD=2.46U
* device instance $623 r0 *1 68.84,76.975 nfet
M$623 \$652 \$634 VSS vsubs nfet L=0.6U W=0.58U AS=0.2552P AD=0.0696P PS=2.04U
+ PD=0.82U
* device instance $624 r0 *1 69.68,76.975 nfet
M$624 \$635 D|ZN$13 \$652 vsubs nfet L=0.6U W=0.58U AS=0.0696P AD=0.1508P
+ PS=0.82U PD=1.1U
* device instance $625 r0 *1 70.8,76.975 nfet
M$625 \$653 \$627 \$635 vsubs nfet L=0.6U W=0.58U AS=0.1508P AD=0.0696P PS=1.1U
+ PD=0.82U
* device instance $626 r0 *1 71.64,76.975 nfet
M$626 \$653 \$636 VSS vsubs nfet L=0.6U W=0.58U AS=0.39315P AD=0.0696P PS=2.35U
+ PD=0.82U
* device instance $627 r0 *1 73.14,76.975 nfet
M$627 \$636 \$635 VSS vsubs nfet L=0.6U W=0.58U AS=0.39315P AD=0.1508P PS=2.35U
+ PD=1.1U
* device instance $628 r0 *1 74.26,76.975 nfet
M$628 \$637 \$627 \$636 vsubs nfet L=0.6U W=0.58U AS=0.1508P AD=0.1508P PS=1.1U
+ PD=1.1U
* device instance $629 r0 *1 75.38,76.975 nfet
M$629 \$655 \$634 \$637 vsubs nfet L=0.6U W=0.58U AS=0.1508P AD=0.0696P PS=1.1U
+ PD=0.82U
* device instance $630 r0 *1 76.22,76.975 nfet
M$630 \$655 \$638 VSS vsubs nfet L=0.6U W=0.58U AS=0.252P AD=0.0696P PS=1.49U
+ PD=0.82U
* device instance $631 r0 *1 77.56,76.89 nfet
M$631 \$638 \$637 VSS vsubs nfet L=0.6U W=0.75U AS=0.252P AD=0.33P PS=1.49U
+ PD=2.38U
* device instance $632 r0 *1 82.68,84.345 nfet
M$632 \$708 A1|ZN$12 \$685 vsubs nfet L=0.6U W=0.66U AS=0.2904P AD=0.1056P
+ PS=2.2U PD=0.98U
* device instance $633 r0 *1 83.6,84.345 nfet
M$633 VSS A2|Z$3 \$708 vsubs nfet L=0.6U W=0.66U AS=0.1056P AD=0.3894P PS=0.98U
+ PD=2.06U
* device instance $634 r0 *1 84.94,84.675 nfet
M$634 A1|Z$4 \$685 VSS vsubs nfet L=0.6U W=1.32U AS=0.3894P AD=0.5808P PS=2.06U
+ PD=3.52U
* device instance $635 r0 *1 91.745,84.675 nfet
M$635 VSS \$687 A3|B2|Z vsubs nfet L=0.6U W=1.32U AS=0.5808P AD=0.3828P
+ PS=3.52U PD=2.08U
* device instance $636 r0 *1 93.105,85.005 nfet
M$636 \$687 A2|A3|ZN$4 VSS vsubs nfet L=0.6U W=0.66U AS=0.3828P AD=0.1716P
+ PS=2.08U PD=1.18U
* device instance $637 r0 *1 94.225,85.005 nfet
M$637 VSS A1|A2|ZN$6 \$687 vsubs nfet L=0.6U W=0.66U AS=0.1716P AD=0.2904P
+ PS=1.18U PD=2.2U
* device instance $638 r0 *1 112.36,76.87 nfet
M$638 VSS CLK|clk \$639 vsubs nfet L=0.6U W=0.79U AS=0.3476P AD=0.2054P
+ PS=2.46U PD=1.31U
* device instance $639 r0 *1 113.48,76.87 nfet
M$639 \$629 \$639 VSS vsubs nfet L=0.6U W=0.79U AS=0.2054P AD=0.3476P PS=1.31U
+ PD=2.46U
* device instance $640 r0 *1 115.32,76.975 nfet
M$640 \$654 \$639 VSS vsubs nfet L=0.6U W=0.58U AS=0.2552P AD=0.0696P PS=2.04U
+ PD=0.82U
* device instance $641 r0 *1 116.16,76.975 nfet
M$641 \$640 D|ZN$11 \$654 vsubs nfet L=0.6U W=0.58U AS=0.0696P AD=0.1508P
+ PS=0.82U PD=1.1U
* device instance $642 r0 *1 117.28,76.975 nfet
M$642 \$651 \$629 \$640 vsubs nfet L=0.6U W=0.58U AS=0.1508P AD=0.0696P PS=1.1U
+ PD=0.82U
* device instance $643 r0 *1 118.12,76.975 nfet
M$643 \$651 \$641 VSS vsubs nfet L=0.6U W=0.58U AS=0.39315P AD=0.0696P PS=2.35U
+ PD=0.82U
* device instance $644 r0 *1 119.62,76.975 nfet
M$644 \$641 \$640 VSS vsubs nfet L=0.6U W=0.58U AS=0.39315P AD=0.1508P PS=2.35U
+ PD=1.1U
* device instance $645 r0 *1 120.74,76.975 nfet
M$645 \$642 \$629 \$641 vsubs nfet L=0.6U W=0.58U AS=0.1508P AD=0.1508P PS=1.1U
+ PD=1.1U
* device instance $646 r0 *1 121.86,76.975 nfet
M$646 \$648 \$639 \$642 vsubs nfet L=0.6U W=0.58U AS=0.1508P AD=0.0696P PS=1.1U
+ PD=0.82U
* device instance $647 r0 *1 122.7,76.975 nfet
M$647 \$648 \$643 VSS vsubs nfet L=0.6U W=0.58U AS=0.252P AD=0.0696P PS=1.49U
+ PD=0.82U
* device instance $648 r0 *1 124.04,76.89 nfet
M$648 \$643 \$642 VSS vsubs nfet L=0.6U W=0.75U AS=0.252P AD=0.33P PS=1.49U
+ PD=2.38U
* device instance $649 r0 *1 123.56,84.675 nfet
M$649 A2|A3|ZN$2 A2|ZN$33 \$704 vsubs nfet L=0.6U W=1.32U AS=0.5808P AD=0.3432P
+ PS=3.52U PD=1.84U
* device instance $650 r0 *1 124.68,84.675 nfet
M$650 \$704 A1|Z$5 A2|A3|ZN$2 vsubs nfet L=0.6U W=1.32U AS=0.3432P AD=0.3432P
+ PS=1.84U PD=1.84U
* device instance $651 r0 *1 125.8,84.675 nfet
M$651 VSS B|Z$1 \$704 vsubs nfet L=0.6U W=1.32U AS=0.3432P AD=0.5808P PS=1.84U
+ PD=3.52U
* device instance $652 r0 *1 136.475,84.675 nfet
M$652 \$711 A1|A2|B|B2|C|Z A2|ZN$31 vsubs nfet L=0.6U W=1.32U AS=0.5808P
+ AD=0.2112P PS=3.52U PD=1.64U
* device instance $653 r0 *1 137.395,84.675 nfet
M$653 VSS A2|ZN$34 \$711 vsubs nfet L=0.6U W=1.32U AS=0.2112P AD=0.5808P
+ PS=1.64U PD=3.52U
* device instance $654 r0 *1 143.2,84.345 nfet
M$654 \$707 A2|ZN$30 \$694 vsubs nfet L=0.6U W=0.66U AS=0.2904P AD=0.1056P
+ PS=2.2U PD=0.98U
* device instance $655 r0 *1 144.12,84.345 nfet
M$655 VSS A1|Q \$707 vsubs nfet L=0.6U W=0.66U AS=0.1056P AD=0.363P PS=0.98U
+ PD=2.02U
* device instance $656 r0 *1 145.42,84.675 nfet
M$656 \$705 \$694 VSS vsubs nfet L=0.6U W=1.32U AS=0.363P AD=0.3432P PS=2.02U
+ PD=1.84U
* device instance $657 r0 *1 146.54,84.675 nfet
M$657 B|ZN$10 A1|Q \$705 vsubs nfet L=0.6U W=1.32U AS=0.3432P AD=0.3432P
+ PS=1.84U PD=1.84U
* device instance $658 r0 *1 147.66,84.675 nfet
M$658 \$705 A2|ZN$30 B|ZN$10 vsubs nfet L=0.6U W=1.32U AS=0.3432P AD=0.5808P
+ PS=1.84U PD=3.52U
* device instance $659 r0 *1 13.38,86.74 nfet
M$659 \$731 \$713 \$714 vsubs nfet L=0.6U W=0.66U AS=0.2904P AD=0.1056P PS=2.2U
+ PD=0.98U
* device instance $660 r0 *1 14.3,86.74 nfet
M$660 \$731 A2|A3|Z$3 VSS vsubs nfet L=0.6U W=0.66U AS=0.363P AD=0.1056P
+ PS=2.02U PD=0.98U
* device instance $661 r0 *1 15.6,86.685 nfet
M$661 \$715 \$714 VSS vsubs nfet L=0.6U W=1.32U AS=0.363P AD=0.3432P PS=2.02U
+ PD=1.84U
* device instance $662 r0 *1 16.72,86.685 nfet
M$662 A2|B2|ZN$1 A2|A3|Z$3 \$715 vsubs nfet L=0.6U W=1.32U AS=0.3432P
+ AD=0.3432P PS=1.84U PD=1.84U
* device instance $663 r0 *1 17.84,86.685 nfet
M$663 \$715 \$713 A2|B2|ZN$1 vsubs nfet L=0.6U W=1.32U AS=0.3432P AD=0.5808P
+ PS=1.84U PD=3.52U
* device instance $664 r0 *1 37.32,84.64 nfet
M$664 A1|A3|B1|ZN A2|B1|I|ZN VSS vsubs nfet L=0.6U W=0.92U AS=0.4048P
+ AD=0.2392P PS=2.72U PD=1.44U
* device instance $665 r0 *1 38.44,84.64 nfet
M$665 VSS A1|B3|ZN A1|A3|B1|ZN vsubs nfet L=0.6U W=0.92U AS=0.2392P AD=0.4048P
+ PS=1.44U PD=2.72U
* device instance $666 r0 *1 48.575,86.355 nfet
M$666 \$719 A1|A2|I|Q VSS vsubs nfet L=0.6U W=0.66U AS=0.2904P AD=0.1716P
+ PS=2.2U PD=1.18U
* device instance $667 r0 *1 49.695,86.355 nfet
M$667 VSS A2|Z$2 \$719 vsubs nfet L=0.6U W=0.66U AS=0.1716P AD=0.3828P PS=1.18U
+ PD=2.08U
* device instance $668 r0 *1 51.055,86.685 nfet
M$668 A2|B2|Z \$719 VSS vsubs nfet L=0.6U W=1.32U AS=0.3828P AD=0.5808P
+ PS=2.08U PD=3.52U
* device instance $669 r0 *1 55.24,86.685 nfet
M$669 \$736 A2|B2|Z VSS vsubs nfet L=0.6U W=1.32U AS=0.5808P AD=0.2112P
+ PS=3.52U PD=1.64U
* device instance $670 r0 *1 56.16,86.685 nfet
M$670 B|ZN$11 A1|A3|B1|ZN \$736 vsubs nfet L=0.6U W=1.32U AS=0.2112P AD=0.402P
+ PS=1.64U PD=2.02U
* device instance $671 r0 *1 57.46,86.885 nfet
M$671 VSS B|C|Z B|ZN$11 vsubs nfet L=0.6U W=0.92U AS=0.402P AD=0.4048P PS=2.02U
+ PD=2.72U
* device instance $672 r0 *1 69.275,86.685 nfet
M$672 \$737 A1|A2|A4|I|Q I|ZN vsubs nfet L=0.6U W=1.32U AS=0.5808P AD=0.2112P
+ PS=3.52U PD=1.64U
* device instance $673 r0 *1 70.195,86.685 nfet
M$673 VSS A2|ZN$39 \$737 vsubs nfet L=0.6U W=1.32U AS=0.2112P AD=0.5808P
+ PS=1.64U PD=3.52U
* device instance $674 r0 *1 102.285,86.685 nfet
M$674 \$735 A2|ZN$30 VSS vsubs nfet L=0.6U W=1.32U AS=0.5808P AD=0.2112P
+ PS=3.52U PD=1.64U
* device instance $675 r0 *1 103.205,86.685 nfet
M$675 B|C|ZN A1|A3|I|Q \$735 vsubs nfet L=0.6U W=1.32U AS=0.2112P AD=0.5808P
+ PS=1.64U PD=3.52U
* device instance $676 r0 *1 103.96,84.64 nfet
M$676 A1|B1|ZN$1 A2|ZN$30 VSS vsubs nfet L=0.6U W=0.92U AS=0.4048P AD=0.2392P
+ PS=2.72U PD=1.44U
* device instance $677 r0 *1 105.08,84.64 nfet
M$677 VSS A1|A3|I|Q A1|B1|ZN$1 vsubs nfet L=0.6U W=0.92U AS=0.2392P AD=0.4048P
+ PS=1.44U PD=2.72U
* device instance $678 r0 *1 106.2,86.685 nfet
M$678 VSS A3|B2|Z \$726 vsubs nfet L=0.6U W=1.32U AS=0.5808P AD=0.3432P
+ PS=3.52U PD=1.84U
* device instance $679 r0 *1 107.32,86.685 nfet
M$679 \$726 A1|B1|ZN$1 VSS vsubs nfet L=0.6U W=1.32U AS=0.3432P AD=0.363P
+ PS=1.84U PD=1.87U
* device instance $680 r0 *1 108.47,86.685 nfet
M$680 \$727 B|C|ZN \$726 vsubs nfet L=0.6U W=1.32U AS=0.363P AD=0.363P PS=1.87U
+ PD=1.87U
* device instance $681 r0 *1 109.62,86.685 nfet
M$681 B1|ZN$2 A2|ZN$35 \$727 vsubs nfet L=0.6U W=1.32U AS=0.363P AD=0.3432P
+ PS=1.87U PD=1.84U
* device instance $682 r0 *1 110.74,86.685 nfet
M$682 \$727 A1|Z$5 B1|ZN$2 vsubs nfet L=0.6U W=1.32U AS=0.3432P AD=0.5808P
+ PS=1.84U PD=3.52U
* device instance $683 r0 *1 122.26,86.685 nfet
M$683 VSS \$728 A1|Z$5 vsubs nfet L=0.6U W=1.32U AS=0.5808P AD=0.3894P PS=3.52U
+ PD=2.06U
* device instance $684 r0 *1 123.6,87.015 nfet
M$684 \$734 A2|ZN$30 VSS vsubs nfet L=0.6U W=0.66U AS=0.3894P AD=0.1056P
+ PS=2.06U PD=0.98U
* device instance $685 r0 *1 124.52,87.015 nfet
M$685 \$728 A1|A2|Q \$734 vsubs nfet L=0.6U W=0.66U AS=0.1056P AD=0.2904P
+ PS=0.98U PD=2.2U
* device instance $686 r0 *1 146.525,86.685 nfet
M$686 \$733 A2|ZN$30 VSS vsubs nfet L=0.6U W=1.32U AS=0.5808P AD=0.2112P
+ PS=3.52U PD=1.64U
* device instance $687 r0 *1 147.445,86.685 nfet
M$687 C|ZN A1|A3|B|Q \$733 vsubs nfet L=0.6U W=1.32U AS=0.2112P AD=0.5808P
+ PS=1.64U PD=3.52U
* device instance $688 r0 *1 7.08,86.59 nfet
M$688 \$712 A1|A2|I|ZN VSS vsubs nfet L=0.6U W=0.36U AS=0.1584P AD=0.0936P
+ PS=1.6U PD=0.88U
* device instance $689 r0 *1 8.2,86.59 nfet
M$689 VSS A1|A2|I|Q \$712 vsubs nfet L=0.6U W=0.36U AS=0.0936P AD=0.186P
+ PS=0.88U PD=1.36U
* device instance $690 r0 *1 9.5,86.74 nfet
M$690 \$713 \$712 VSS vsubs nfet L=0.6U W=0.66U AS=0.186P AD=0.1716P PS=1.36U
+ PD=1.18U
* device instance $691 r0 *1 10.62,86.74 nfet
M$691 \$730 A1|A2|I|Q \$713 vsubs nfet L=0.6U W=0.66U AS=0.1716P AD=0.1056P
+ PS=1.18U PD=0.98U
* device instance $692 r0 *1 11.54,86.74 nfet
M$692 VSS A1|A2|I|ZN \$730 vsubs nfet L=0.6U W=0.66U AS=0.1056P AD=0.2904P
+ PS=0.98U PD=2.2U
* device instance $693 r0 *1 20.52,86.72 nfet
M$693 A3|ZN A2|A3|Z$3 VSS vsubs nfet L=0.6U W=0.92U AS=0.4048P AD=0.2392P
+ PS=2.72U PD=1.44U
* device instance $694 r0 *1 21.64,86.72 nfet
M$694 VSS A1|A2|I|ZN A3|ZN vsubs nfet L=0.6U W=0.92U AS=0.2392P AD=0.4048P
+ PS=1.44U PD=2.72U
* device instance $695 r0 *1 25.4,86.98 nfet
M$695 VSS A1|A2|I|Q A1|ZN$13 vsubs nfet L=0.6U W=0.73U AS=0.3212P AD=0.3212P
+ PS=2.34U PD=2.34U
* device instance $696 r0 *1 35.08,86.98 nfet
M$696 A2|B|ZN$1 A2|B1|I|ZN VSS vsubs nfet L=0.6U W=0.73U AS=0.3212P AD=0.3212P
+ PS=2.34U PD=2.34U
* device instance $697 r0 *1 37.32,86.72 nfet
M$697 A1|ZN$12 A2|B|ZN$1 VSS vsubs nfet L=0.6U W=0.92U AS=0.4048P AD=0.2392P
+ PS=2.72U PD=1.44U
* device instance $698 r0 *1 38.44,86.72 nfet
M$698 VSS A1|I0|ZN A1|ZN$12 vsubs nfet L=0.6U W=0.92U AS=0.2392P AD=0.4048P
+ PS=1.44U PD=2.72U
* device instance $699 r0 *1 89.76,86.4725 nfet
M$699 \$724 A1|A2|A4|I|Q VSS vsubs nfet L=0.6U W=0.395U AS=0.32325P AD=0.14025P
+ PS=2.02U PD=1.135U
* device instance $700 r0 *1 86.04,86.5075 nfet
M$700 \$724 A1|Q VSS vsubs nfet L=0.6U W=0.395U AS=0.1738P AD=0.1385P PS=1.67U
+ PD=1.1U
* device instance $701 r0 *1 87.34,86.5125 nfet
M$701 VSS A1|A2|I|Q \$724 vsubs nfet L=0.6U W=0.395U AS=0.1385P AD=0.1027P
+ PS=1.1U PD=0.915U
* device instance $702 r0 *1 88.46,86.5125 nfet
M$702 VSS A1|A3|B|Q \$724 vsubs nfet L=0.6U W=0.395U AS=0.14025P AD=0.1027P
+ PS=1.135U PD=0.915U
* device instance $703 r0 *1 91.06,86.685 nfet
M$703 A4|Z \$724 VSS vsubs nfet L=0.6U W=1.32U AS=0.32325P AD=0.5808P PS=2.02U
+ PD=3.52U
* device instance $704 r0 *1 113.32,86.72 nfet
M$704 A2|ZN$35 A1|A2|Q VSS vsubs nfet L=0.6U W=0.92U AS=0.4048P AD=0.2392P
+ PS=2.72U PD=1.44U
* device instance $705 r0 *1 114.44,86.72 nfet
M$705 VSS A2|ZN$30 A2|ZN$35 vsubs nfet L=0.6U W=0.92U AS=0.2392P AD=0.4048P
+ PS=1.44U PD=2.72U
* device instance $706 r0 *1 12.68,94.72 nfet
M$706 A1|A2|ZN$5 A2|A3|I1|ZN VSS vsubs nfet L=0.6U W=0.92U AS=0.4048P
+ AD=0.2392P PS=2.72U PD=1.44U
* device instance $707 r0 *1 13.8,94.72 nfet
M$707 VSS A1|ZN$9 A1|A2|ZN$5 vsubs nfet L=0.6U W=0.92U AS=0.2392P AD=0.4048P
+ PS=1.44U PD=2.72U
* device instance $708 r0 *1 22.6,94.755 nfet
M$708 \$795 A3|ZN A2|A3|ZN$3 vsubs nfet L=0.6U W=1.32U AS=0.5808P AD=0.3432P
+ PS=3.52U PD=1.84U
* device instance $709 r0 *1 23.72,94.755 nfet
M$709 A2|A3|ZN$3 A1|A2|ZN$5 \$795 vsubs nfet L=0.6U W=1.32U AS=0.3432P
+ AD=0.3432P PS=1.84U PD=1.84U
* device instance $710 r0 *1 24.84,94.755 nfet
M$710 \$795 A1|ZN$13 A2|A3|ZN$3 vsubs nfet L=0.6U W=1.32U AS=0.3432P AD=0.3432P
+ PS=1.84U PD=1.84U
* device instance $711 r0 *1 25.96,94.755 nfet
M$711 VSS A2|B1|I|ZN \$795 vsubs nfet L=0.6U W=1.32U AS=0.3432P AD=0.3432P
+ PS=1.84U PD=1.84U
* device instance $712 r0 *1 27.08,94.755 nfet
M$712 \$795 A2|B2|ZN$1 VSS vsubs nfet L=0.6U W=1.32U AS=0.3432P AD=0.3432P
+ PS=1.84U PD=1.84U
* device instance $713 r0 *1 28.2,94.755 nfet
M$713 VSS A1|B3|ZN \$795 vsubs nfet L=0.6U W=1.32U AS=0.3432P AD=0.5808P
+ PS=1.84U PD=3.52U
* device instance $714 r0 *1 39.04,94.425 nfet
M$714 \$803 A2|B2|ZN$1 \$755 vsubs nfet L=0.6U W=0.66U AS=0.2904P AD=0.1056P
+ PS=2.2U PD=0.98U
* device instance $715 r0 *1 39.96,94.425 nfet
M$715 VSS A1|A3|B1|ZN \$803 vsubs nfet L=0.6U W=0.66U AS=0.1056P AD=0.363P
+ PS=0.98U PD=2.02U
* device instance $716 r0 *1 41.26,94.755 nfet
M$716 \$796 \$755 VSS vsubs nfet L=0.6U W=1.32U AS=0.363P AD=0.3432P PS=2.02U
+ PD=1.84U
* device instance $717 r0 *1 42.38,94.755 nfet
M$717 A2|ZN$36 A1|A3|B1|ZN \$796 vsubs nfet L=0.6U W=1.32U AS=0.3432P
+ AD=0.3432P PS=1.84U PD=1.84U
* device instance $718 r0 *1 43.5,94.755 nfet
M$718 \$796 A2|B2|ZN$1 A2|ZN$36 vsubs nfet L=0.6U W=1.32U AS=0.3432P AD=0.5808P
+ PS=1.84U PD=3.52U
* device instance $719 r0 *1 50.2,94.425 nfet
M$719 \$804 A1|A2|I|Q \$757 vsubs nfet L=0.6U W=0.66U AS=0.2904P AD=0.1056P
+ PS=2.2U PD=0.98U
* device instance $720 r0 *1 51.12,94.425 nfet
M$720 VSS A2|Z$2 \$804 vsubs nfet L=0.6U W=0.66U AS=0.1056P AD=0.3894P PS=0.98U
+ PD=2.06U
* device instance $721 r0 *1 52.46,94.755 nfet
M$721 B|C|Z \$757 VSS vsubs nfet L=0.6U W=1.32U AS=0.3894P AD=0.5808P PS=2.06U
+ PD=3.52U
* device instance $722 r0 *1 57.42,94.73 nfet
M$722 VSS B|C|Z A2|A3|ZN$4 vsubs nfet L=0.6U W=0.79U AS=0.3555P AD=0.3555P
+ PS=1.885U PD=1.885U
* device instance $723 r0 *1 55.28,94.6875 nfet
M$723 \$806 A2|B2|Z VSS vsubs nfet L=0.6U W=1.185U AS=0.5214P AD=0.1422P
+ PS=3.25U PD=1.425U
* device instance $724 r0 *1 56.12,94.6875 nfet
M$724 A2|A3|ZN$4 A1|A3|B1|ZN \$806 vsubs nfet L=0.6U W=1.185U AS=0.1422P
+ AD=0.3555P PS=1.425U PD=1.885U
* device instance $725 r0 *1 58.72,94.6875 nfet
M$725 \$807 A2|ZN$39 VSS vsubs nfet L=0.6U W=1.185U AS=0.3555P AD=0.1422P
+ PS=1.885U PD=1.425U
* device instance $726 r0 *1 59.56,94.6875 nfet
M$726 A2|A3|ZN$4 A1|A2|A4|I|Q \$807 vsubs nfet L=0.6U W=1.185U AS=0.1422P
+ AD=0.5214P PS=1.425U PD=3.25U
* device instance $727 r0 *1 68.12,94.46 nfet
M$727 A1|ZN$15 I|ZN VSS vsubs nfet L=0.6U W=0.73U AS=0.3212P AD=0.3212P
+ PS=2.34U PD=2.34U
* device instance $728 r0 *1 70.76,94.755 nfet
M$728 \$797 B|ZN$11 VSS vsubs nfet L=0.6U W=1.32U AS=0.5808P AD=0.3432P
+ PS=3.52U PD=1.84U
* device instance $729 r0 *1 71.88,94.755 nfet
M$729 A2|ZN$37 A1|ZN$15 \$797 vsubs nfet L=0.6U W=1.32U AS=0.3432P AD=0.3432P
+ PS=1.84U PD=1.84U
* device instance $730 r0 *1 73,94.755 nfet
M$730 \$797 A1|A2|ZN$6 A2|ZN$37 vsubs nfet L=0.6U W=1.32U AS=0.3432P AD=0.5808P
+ PS=1.84U PD=3.52U
* device instance $731 r0 *1 82.68,94.85 nfet
M$731 \$792 A2|ZN$30 VSS vsubs nfet L=0.6U W=0.36U AS=0.1584P AD=0.0936P
+ PS=1.6U PD=0.88U
* device instance $732 r0 *1 83.8,94.85 nfet
M$732 \$792 A1|ZN$23 VSS vsubs nfet L=0.6U W=0.36U AS=0.186P AD=0.0936P
+ PS=1.36U PD=0.88U
* device instance $733 r0 *1 85.1,94.7 nfet
M$733 \$765 \$792 VSS vsubs nfet L=0.6U W=0.66U AS=0.186P AD=0.1716P PS=1.36U
+ PD=1.18U
* device instance $734 r0 *1 86.22,94.7 nfet
M$734 \$802 A1|ZN$23 \$765 vsubs nfet L=0.6U W=0.66U AS=0.1716P AD=0.1056P
+ PS=1.18U PD=0.98U
* device instance $735 r0 *1 87.14,94.7 nfet
M$735 VSS A2|ZN$30 \$802 vsubs nfet L=0.6U W=0.66U AS=0.1056P AD=0.2904P
+ PS=0.98U PD=2.2U
* device instance $736 r0 *1 88.98,94.7 nfet
M$736 \$801 \$765 \$766 vsubs nfet L=0.6U W=0.66U AS=0.2904P AD=0.1056P PS=2.2U
+ PD=0.98U
* device instance $737 r0 *1 89.9,94.7 nfet
M$737 \$801 A3|B2|Z VSS vsubs nfet L=0.6U W=0.66U AS=0.363P AD=0.1056P PS=2.02U
+ PD=0.98U
* device instance $738 r0 *1 91.2,94.755 nfet
M$738 \$798 \$766 VSS vsubs nfet L=0.6U W=1.32U AS=0.363P AD=0.3432P PS=2.02U
+ PD=1.84U
* device instance $739 r0 *1 92.32,94.755 nfet
M$739 A2|ZN$38 A3|B2|Z \$798 vsubs nfet L=0.6U W=1.32U AS=0.3432P AD=0.3432P
+ PS=1.84U PD=1.84U
* device instance $740 r0 *1 93.44,94.755 nfet
M$740 \$798 \$765 A2|ZN$38 vsubs nfet L=0.6U W=1.32U AS=0.3432P AD=0.5808P
+ PS=1.84U PD=3.52U
* device instance $741 r0 *1 104.36,94.755 nfet
M$741 \$799 A2|A3|ZN$4 A2|ZN$33 vsubs nfet L=0.6U W=1.32U AS=0.5808P AD=0.3432P
+ PS=3.52U PD=1.84U
* device instance $742 r0 *1 105.48,94.755 nfet
M$742 A2|ZN$33 A1|A2|ZN$6 \$799 vsubs nfet L=0.6U W=1.32U AS=0.3432P AD=0.3432P
+ PS=1.84U PD=1.84U
* device instance $743 r0 *1 106.6,94.755 nfet
M$743 \$799 A1|B1|ZN$1 A2|ZN$33 vsubs nfet L=0.6U W=1.32U AS=0.3432P AD=0.3432P
+ PS=1.84U PD=1.84U
* device instance $744 r0 *1 107.72,94.755 nfet
M$744 VSS B|C|ZN \$799 vsubs nfet L=0.6U W=1.32U AS=0.3432P AD=0.5808P PS=1.84U
+ PD=3.52U
* device instance $745 r0 *1 131.96,94.75 nfet
M$745 \$793 A2|ZN$30 VSS vsubs nfet L=0.6U W=0.36U AS=0.1584P AD=0.0936P
+ PS=1.6U PD=0.88U
* device instance $746 r0 *1 133.08,94.75 nfet
M$746 \$793 A1|A3|B|Q VSS vsubs nfet L=0.6U W=0.36U AS=0.186P AD=0.0936P
+ PS=1.36U PD=0.88U
* device instance $747 r0 *1 134.38,94.6 nfet
M$747 \$770 \$793 VSS vsubs nfet L=0.6U W=0.66U AS=0.186P AD=0.1716P PS=1.36U
+ PD=1.18U
* device instance $748 r0 *1 135.5,94.6 nfet
M$748 \$800 A1|A3|B|Q \$770 vsubs nfet L=0.6U W=0.66U AS=0.1716P AD=0.1056P
+ PS=1.18U PD=0.98U
* device instance $749 r0 *1 136.42,94.6 nfet
M$749 VSS A2|ZN$30 \$800 vsubs nfet L=0.6U W=0.66U AS=0.1056P AD=0.2904P
+ PS=0.98U PD=2.2U
* device instance $750 r0 *1 138.26,94.6 nfet
M$750 \$771 \$770 VSS vsubs nfet L=0.6U W=0.66U AS=0.2904P AD=0.1716P PS=2.2U
+ PD=1.18U
* device instance $751 r0 *1 139.38,94.6 nfet
M$751 \$771 A2|A3|ZN$2 VSS vsubs nfet L=0.6U W=0.66U AS=0.363P AD=0.1716P
+ PS=2.02U PD=1.18U
* device instance $752 r0 *1 140.68,94.755 nfet
M$752 A2|Z$4 \$771 VSS vsubs nfet L=0.6U W=1.32U AS=0.363P AD=0.3432P PS=2.02U
+ PD=1.84U
* device instance $753 r0 *1 141.8,94.755 nfet
M$753 \$805 A2|A3|ZN$2 A2|Z$4 vsubs nfet L=0.6U W=1.32U AS=0.3432P AD=0.2112P
+ PS=1.84U PD=1.64U
* device instance $754 r0 *1 142.72,94.755 nfet
M$754 VSS \$770 \$805 vsubs nfet L=0.6U W=1.32U AS=0.2112P AD=0.5808P PS=1.64U
+ PD=3.52U
* device instance $755 r0 *1 145.96,94.72 nfet
M$755 A1|ZN$14 A2|ZN$30 VSS vsubs nfet L=0.6U W=0.92U AS=0.4048P AD=0.2392P
+ PS=2.72U PD=1.44U
* device instance $756 r0 *1 147.08,94.72 nfet
M$756 VSS A1|A3|B|Q A1|ZN$14 vsubs nfet L=0.6U W=0.92U AS=0.2392P AD=0.4048P
+ PS=1.44U PD=2.72U
* device instance $757 r0 *1 12.72,97.095 nfet
M$757 \$817 A1|A2|A3|ZN$1 \$809 vsubs nfet L=0.6U W=0.66U AS=0.2904P AD=0.1056P
+ PS=2.2U PD=0.98U
* device instance $758 r0 *1 13.64,97.095 nfet
M$758 \$817 A1|A2|I|Q VSS vsubs nfet L=0.6U W=0.66U AS=0.363P AD=0.1056P
+ PS=2.02U PD=0.98U
* device instance $759 r0 *1 14.94,96.765 nfet
M$759 \$811 \$809 VSS vsubs nfet L=0.6U W=1.32U AS=0.363P AD=0.3432P PS=2.02U
+ PD=1.84U
* device instance $760 r0 *1 16.06,96.765 nfet
M$760 A2|A3|ZN$5 A1|A2|I|Q \$811 vsubs nfet L=0.6U W=1.32U AS=0.3432P
+ AD=0.3432P PS=1.84U PD=1.84U
* device instance $761 r0 *1 17.18,96.765 nfet
M$761 \$811 A1|A2|A3|ZN$1 A2|A3|ZN$5 vsubs nfet L=0.6U W=1.32U AS=0.3432P
+ AD=0.5808P PS=1.84U PD=3.52U
* device instance $762 r0 *1 26.16,104.505 nfet
M$762 \$863 A2|ZN$48 \$829 vsubs nfet L=0.6U W=0.66U AS=0.2904P AD=0.1056P
+ PS=2.2U PD=0.98U
* device instance $763 r0 *1 27.08,104.505 nfet
M$763 VSS A1|ZN$16 \$863 vsubs nfet L=0.6U W=0.66U AS=0.1056P AD=0.363P
+ PS=0.98U PD=2.02U
* device instance $764 r0 *1 28.38,104.835 nfet
M$764 \$858 \$829 VSS vsubs nfet L=0.6U W=1.32U AS=0.363P AD=0.3432P PS=2.02U
+ PD=1.84U
* device instance $765 r0 *1 29.5,104.835 nfet
M$765 B1|ZN$3 A1|ZN$16 \$858 vsubs nfet L=0.6U W=1.32U AS=0.3432P AD=0.3432P
+ PS=1.84U PD=1.84U
* device instance $766 r0 *1 30.62,104.835 nfet
M$766 \$858 A2|ZN$48 B1|ZN$3 vsubs nfet L=0.6U W=1.32U AS=0.3432P AD=0.5808P
+ PS=1.84U PD=3.52U
* device instance $767 r0 *1 31.16,96.765 nfet
M$767 A1|ZN$16 A2|ZN$28 \$813 vsubs nfet L=0.6U W=1.32U AS=0.5808P AD=0.3432P
+ PS=3.52U PD=1.84U
* device instance $768 r0 *1 32.28,96.765 nfet
M$768 \$813 A1|A2|A3|ZN$1 A1|ZN$16 vsubs nfet L=0.6U W=1.32U AS=0.3432P
+ AD=0.3432P PS=1.84U PD=1.84U
* device instance $769 r0 *1 33.4,96.765 nfet
M$769 VSS A2|B|ZN$1 \$813 vsubs nfet L=0.6U W=1.32U AS=0.3432P AD=0.5808P
+ PS=1.84U PD=3.52U
* device instance $770 r0 *1 39.4,96.8 nfet
M$770 A1|A2|A3|ZN$1 A1|B3|ZN VSS vsubs nfet L=0.6U W=0.92U AS=0.4048P
+ AD=0.2392P PS=2.72U PD=1.44U
* device instance $771 r0 *1 40.52,96.8 nfet
M$771 VSS A1|A2|B|ZN A1|A2|A3|ZN$1 vsubs nfet L=0.6U W=0.92U AS=0.2392P
+ AD=0.4048P PS=1.44U PD=2.72U
* device instance $772 r0 *1 40.16,104.505 nfet
M$772 \$864 A2|ZN$40 \$831 vsubs nfet L=0.6U W=0.66U AS=0.2904P AD=0.1056P
+ PS=2.2U PD=0.98U
* device instance $773 r0 *1 41.08,104.505 nfet
M$773 VSS A1|A2|ZN$7 \$864 vsubs nfet L=0.6U W=0.66U AS=0.1056P AD=0.363P
+ PS=0.98U PD=2.02U
* device instance $774 r0 *1 42.38,104.835 nfet
M$774 \$859 \$831 VSS vsubs nfet L=0.6U W=1.32U AS=0.363P AD=0.3432P PS=2.02U
+ PD=1.84U
* device instance $775 r0 *1 43.5,104.835 nfet
M$775 A2|ZN$39 A1|A2|ZN$7 \$859 vsubs nfet L=0.6U W=1.32U AS=0.3432P AD=0.3432P
+ PS=1.84U PD=1.84U
* device instance $776 r0 *1 44.62,104.835 nfet
M$776 \$859 A2|ZN$40 A2|ZN$39 vsubs nfet L=0.6U W=1.32U AS=0.3432P AD=0.5808P
+ PS=1.84U PD=3.52U
* device instance $777 r0 *1 69.8,96.8 nfet
M$777 A1|A2|ZN$6 A2|ZN$39 VSS vsubs nfet L=0.6U W=0.92U AS=0.4048P AD=0.2392P
+ PS=2.72U PD=1.44U
* device instance $778 r0 *1 70.92,96.8 nfet
M$778 VSS A1|A2|A4|I|Q A1|A2|ZN$6 vsubs nfet L=0.6U W=0.92U AS=0.2392P
+ AD=0.4048P PS=1.44U PD=2.72U
* device instance $779 r0 *1 70.395,104.835 nfet
M$779 \$871 A1|A2|B|B2|C|Z A2|ZN$41 vsubs nfet L=0.6U W=1.32U AS=0.5808P
+ AD=0.2112P PS=3.52U PD=1.64U
* device instance $780 r0 *1 71.315,104.835 nfet
M$780 VSS A2|ZN$37 \$871 vsubs nfet L=0.6U W=1.32U AS=0.2112P AD=0.5808P
+ PS=1.64U PD=3.52U
* device instance $781 r0 *1 89.335,104.965 nfet
M$781 VSS A1|B|C|I|ZN D|ZN$14 vsubs nfet L=0.6U W=0.79U AS=0.3476P AD=0.2054P
+ PS=2.46U PD=1.31U
* device instance $782 r0 *1 90.455,104.965 nfet
M$782 VSS B|ZN$13 D|ZN$14 vsubs nfet L=0.6U W=0.79U AS=0.3555P AD=0.2054P
+ PS=1.885U PD=1.31U
* device instance $783 r0 *1 91.755,104.7675 nfet
M$783 \$866 A1|A2|B|B2|C|Z D|ZN$14 vsubs nfet L=0.6U W=1.185U AS=0.3555P
+ AD=0.1422P PS=1.885U PD=1.425U
* device instance $784 r0 *1 92.595,104.7675 nfet
M$784 VSS A2|ZN$38 \$866 vsubs nfet L=0.6U W=1.185U AS=0.1422P AD=0.5214P
+ PS=1.425U PD=3.25U
* device instance $785 r0 *1 108.98,104.635 nfet
M$785 VSS A1|A2|B|B2|C|Z A2|ZN$42 vsubs nfet L=0.6U W=0.92U AS=0.402P
+ AD=0.4048P PS=2.02U PD=2.72U
* device instance $786 r0 *1 106.76,104.835 nfet
M$786 \$872 A2|ZN$63 VSS vsubs nfet L=0.6U W=1.32U AS=0.5808P AD=0.2112P
+ PS=3.52U PD=1.64U
* device instance $787 r0 *1 107.68,104.835 nfet
M$787 A2|ZN$42 A1|B|Z$1 \$872 vsubs nfet L=0.6U W=1.32U AS=0.2112P AD=0.402P
+ PS=1.64U PD=2.02U
* device instance $788 r0 *1 110.745,96.765 nfet
M$788 \$819 A1|A2|B|B2|C|Z VSS vsubs nfet L=0.6U W=1.32U AS=0.5808P AD=0.2112P
+ PS=3.52U PD=1.64U
* device instance $789 r0 *1 111.665,96.765 nfet
M$789 A2|ZN$29 B1|ZN$2 \$819 vsubs nfet L=0.6U W=1.32U AS=0.2112P AD=0.3432P
+ PS=1.64U PD=1.84U
* device instance $790 r0 *1 112.785,96.765 nfet
M$790 \$820 A1|ZN$17 A2|ZN$29 vsubs nfet L=0.6U W=1.32U AS=0.3432P AD=0.2112P
+ PS=1.84U PD=1.64U
* device instance $791 r0 *1 113.705,96.765 nfet
M$791 VSS A2|ZN$42 \$820 vsubs nfet L=0.6U W=1.32U AS=0.2112P AD=0.5808P
+ PS=1.64U PD=3.52U
* device instance $792 r0 *1 122.42,104.635 nfet
M$792 VSS B|ZN$16 B|ZN$12 vsubs nfet L=0.6U W=0.92U AS=0.402P AD=0.4048P
+ PS=2.02U PD=2.72U
* device instance $793 r0 *1 120.2,104.835 nfet
M$793 \$869 A2|ZN$43 VSS vsubs nfet L=0.6U W=1.32U AS=0.5808P AD=0.2112P
+ PS=3.52U PD=1.64U
* device instance $794 r0 *1 121.12,104.835 nfet
M$794 B|ZN$12 A1|ZN$18 \$869 vsubs nfet L=0.6U W=1.32U AS=0.2112P AD=0.402P
+ PS=1.64U PD=2.02U
* device instance $795 r0 *1 123.615,95.085 nfet
M$795 \$768 A1|A2|Q VSS vsubs nfet L=0.6U W=0.66U AS=0.2904P AD=0.1716P PS=2.2U
+ PD=1.18U
* device instance $796 r0 *1 124.735,95.085 nfet
M$796 \$768 A2|ZN$30 VSS vsubs nfet L=0.6U W=0.66U AS=0.3828P AD=0.1716P
+ PS=2.08U PD=1.18U
* device instance $797 r0 *1 126.095,94.755 nfet
M$797 B|Z$1 \$768 VSS vsubs nfet L=0.6U W=1.32U AS=0.3828P AD=0.5808P PS=2.08U
+ PD=3.52U
* device instance $798 r0 *1 129.12,104.835 nfet
M$798 \$868 A1|A2|C|S|ZN VSS vsubs nfet L=0.6U W=1.32U AS=0.5808P AD=0.2442P
+ PS=3.52U PD=1.69U
* device instance $799 r0 *1 130.09,104.835 nfet
M$799 \$861 B|Z$2 \$868 vsubs nfet L=0.6U W=1.32U AS=0.2442P AD=0.363P PS=1.69U
+ PD=1.87U
* device instance $800 r0 *1 131.24,104.835 nfet
M$800 A1|ZN$19 A1|B|Z$1 \$861 vsubs nfet L=0.6U W=1.32U AS=0.363P AD=0.3432P
+ PS=1.87U PD=1.84U
* device instance $801 r0 *1 132.36,104.835 nfet
M$801 \$861 A2|ZN$44 A1|ZN$19 vsubs nfet L=0.6U W=1.32U AS=0.3432P AD=0.5808P
+ PS=1.84U PD=3.52U
* device instance $802 r0 *1 140.295,104.965 nfet
M$802 VSS A1|B|C|I|ZN D|ZN$15 vsubs nfet L=0.6U W=0.79U AS=0.3476P AD=0.2054P
+ PS=2.46U PD=1.31U
* device instance $803 r0 *1 141.415,104.965 nfet
M$803 VSS B|ZN$14 D|ZN$15 vsubs nfet L=0.6U W=0.79U AS=0.3555P AD=0.2054P
+ PS=1.885U PD=1.31U
* device instance $804 r0 *1 142.715,104.7675 nfet
M$804 \$865 A1|A2|B|B2|C|Z D|ZN$15 vsubs nfet L=0.6U W=1.185U AS=0.3555P
+ AD=0.1422P PS=1.885U PD=1.425U
* device instance $805 r0 *1 143.555,104.7675 nfet
M$805 VSS A2|Z$4 \$865 vsubs nfet L=0.6U W=1.185U AS=0.1422P AD=0.5214P
+ PS=1.425U PD=3.25U
* device instance $806 r0 *1 143.72,96.765 nfet
M$806 A2|ZN$34 A2|A3|ZN$2 \$816 vsubs nfet L=0.6U W=1.32U AS=0.5808P AD=0.3432P
+ PS=3.52U PD=1.84U
* device instance $807 r0 *1 144.84,96.765 nfet
M$807 \$816 A1|ZN$14 A2|ZN$34 vsubs nfet L=0.6U W=1.32U AS=0.3432P AD=0.363P
+ PS=1.84U PD=1.87U
* device instance $808 r0 *1 145.99,96.765 nfet
M$808 \$818 B|ZN$10 \$816 vsubs nfet L=0.6U W=1.32U AS=0.363P AD=0.2442P
+ PS=1.87U PD=1.69U
* device instance $809 r0 *1 146.96,96.765 nfet
M$809 VSS C|ZN \$818 vsubs nfet L=0.6U W=1.32U AS=0.2442P AD=0.5808P PS=1.69U
+ PD=3.52U
* device instance $810 r0 *1 14.5,106.9 nfet
M$810 \$900 \$874 \$875 vsubs nfet L=0.6U W=0.66U AS=0.2904P AD=0.1056P PS=2.2U
+ PD=0.98U
* device instance $811 r0 *1 15.42,106.9 nfet
M$811 \$900 A2|A3|ZN$5 VSS vsubs nfet L=0.6U W=0.66U AS=0.363P AD=0.1056P
+ PS=2.02U PD=0.98U
* device instance $812 r0 *1 16.72,106.845 nfet
M$812 \$876 \$875 VSS vsubs nfet L=0.6U W=1.32U AS=0.363P AD=0.3432P PS=2.02U
+ PD=1.84U
* device instance $813 r0 *1 17.84,106.845 nfet
M$813 A2|ZN$48 A2|A3|ZN$5 \$876 vsubs nfet L=0.6U W=1.32U AS=0.3432P AD=0.3432P
+ PS=1.84U PD=1.84U
* device instance $814 r0 *1 18.96,106.845 nfet
M$814 \$876 \$874 A2|ZN$48 vsubs nfet L=0.6U W=1.32U AS=0.3432P AD=0.5808P
+ PS=1.84U PD=3.52U
* device instance $815 r0 *1 17.775,105.165 nfet
M$815 \$827 A1|I0|ZN VSS vsubs nfet L=0.6U W=0.66U AS=0.2904P AD=0.1716P
+ PS=2.2U PD=1.18U
* device instance $816 r0 *1 18.895,105.165 nfet
M$816 \$827 A2|A3|ZN$5 VSS vsubs nfet L=0.6U W=0.66U AS=0.3828P AD=0.1716P
+ PS=2.08U PD=1.18U
* device instance $817 r0 *1 20.255,104.835 nfet
M$817 A1|Z$6 \$827 VSS vsubs nfet L=0.6U W=1.32U AS=0.3828P AD=0.5808P PS=2.08U
+ PD=3.52U
* device instance $818 r0 *1 25.035,106.845 nfet
M$818 \$902 A1|ZN$16 A2|ZN$45 vsubs nfet L=0.6U W=1.32U AS=0.5808P AD=0.2112P
+ PS=3.52U PD=1.64U
* device instance $819 r0 *1 25.955,106.845 nfet
M$819 VSS A2|ZN$48 \$902 vsubs nfet L=0.6U W=1.32U AS=0.2112P AD=0.5808P
+ PS=1.64U PD=3.52U
* device instance $820 r0 *1 37.88,106.845 nfet
M$820 A2|ZN$40 A2|B|ZN$1 \$878 vsubs nfet L=0.6U W=1.32U AS=0.5808P AD=0.3432P
+ PS=3.52U PD=1.84U
* device instance $821 r0 *1 39,106.845 nfet
M$821 \$878 A1|I0|ZN A2|ZN$40 vsubs nfet L=0.6U W=1.32U AS=0.3432P AD=0.3432P
+ PS=1.84U PD=1.84U
* device instance $822 r0 *1 40.12,106.845 nfet
M$822 VSS A1|A2|B|ZN \$878 vsubs nfet L=0.6U W=1.32U AS=0.3432P AD=0.5808P
+ PS=1.84U PD=3.52U
* device instance $823 r0 *1 49.64,104.71 nfet
M$823 \$834 A2|ZN$36 VSS vsubs nfet L=0.6U W=0.66U AS=0.2904P AD=0.1716P
+ PS=2.2U PD=1.18U
* device instance $824 r0 *1 50.76,104.71 nfet
M$824 \$834 A1|ZN$11 VSS vsubs nfet L=0.6U W=0.66U AS=0.363P AD=0.1716P
+ PS=2.02U PD=1.18U
* device instance $825 r0 *1 52.06,104.84 nfet
M$825 A2|Z$5 \$834 VSS vsubs nfet L=0.6U W=1.32U AS=0.363P AD=0.3432P PS=2.02U
+ PD=1.84U
* device instance $826 r0 *1 53.18,104.84 nfet
M$826 \$870 A1|ZN$11 A2|Z$5 vsubs nfet L=0.6U W=1.32U AS=0.3432P AD=0.2112P
+ PS=1.84U PD=1.64U
* device instance $827 r0 *1 54.1,104.84 nfet
M$827 VSS A2|ZN$36 \$870 vsubs nfet L=0.6U W=1.32U AS=0.2112P AD=0.5808P
+ PS=1.64U PD=3.52U
* device instance $828 r0 *1 53.065,106.845 nfet
M$828 \$905 A1|A2|B2|Z VSS vsubs nfet L=0.6U W=1.32U AS=0.5808P AD=0.2112P
+ PS=3.52U PD=1.64U
* device instance $829 r0 *1 53.985,106.845 nfet
M$829 A2|ZN$46 B1|ZN$3 \$905 vsubs nfet L=0.6U W=1.32U AS=0.2112P AD=0.3432P
+ PS=1.64U PD=1.84U
* device instance $830 r0 *1 55.105,106.845 nfet
M$830 \$906 A1|ZN$20 A2|ZN$46 vsubs nfet L=0.6U W=1.32U AS=0.3432P AD=0.2112P
+ PS=1.84U PD=1.64U
* device instance $831 r0 *1 56.025,106.845 nfet
M$831 VSS A2|Z$5 \$906 vsubs nfet L=0.6U W=1.32U AS=0.2112P AD=0.5808P PS=1.64U
+ PD=3.52U
* device instance $832 r0 *1 59.16,104.8 nfet
M$832 B|ZN$9 A2|ZN$46 VSS vsubs nfet L=0.6U W=0.92U AS=0.4048P AD=0.2392P
+ PS=2.72U PD=1.44U
* device instance $833 r0 *1 60.28,104.8 nfet
M$833 VSS A1|A2|B|B2|C|Z B|ZN$9 vsubs nfet L=0.6U W=0.92U AS=0.2392P AD=0.4048P
+ PS=1.44U PD=2.72U
* device instance $834 r0 *1 85,106.845 nfet
M$834 A1|A2|A4|I|Q \$882 VSS vsubs nfet L=0.6U W=1.32U AS=0.5808P AD=0.5808P
+ PS=3.52U PD=3.52U
* device instance $835 r0 *1 101.8,106.845 nfet
M$835 A1|A3|I|Q \$885 VSS vsubs nfet L=0.6U W=1.32U AS=0.5808P AD=0.5808P
+ PS=3.52U PD=3.52U
* device instance $836 r0 *1 117.26,107.045 nfet
M$836 VSS B|ZN$15 A2|ZN$47 vsubs nfet L=0.6U W=0.92U AS=0.402P AD=0.4048P
+ PS=2.02U PD=2.72U
* device instance $837 r0 *1 118.56,106.845 nfet
M$837 \$903 A1|ZN$18 A2|ZN$47 vsubs nfet L=0.6U W=1.32U AS=0.402P AD=0.2112P
+ PS=2.02U PD=1.64U
* device instance $838 r0 *1 119.48,106.845 nfet
M$838 VSS A2|ZN$43 \$903 vsubs nfet L=0.6U W=1.32U AS=0.2112P AD=0.5808P
+ PS=1.64U PD=3.52U
* device instance $839 r0 *1 125.295,106.515 nfet
M$839 \$886 A1|ZN$20 VSS vsubs nfet L=0.6U W=0.66U AS=0.2904P AD=0.1716P
+ PS=2.2U PD=1.18U
* device instance $840 r0 *1 126.415,106.515 nfet
M$840 VSS A2|ZN$47 \$886 vsubs nfet L=0.6U W=0.66U AS=0.1716P AD=0.3828P
+ PS=1.18U PD=2.08U
* device instance $841 r0 *1 127.775,106.845 nfet
M$841 B|Z$2 \$886 VSS vsubs nfet L=0.6U W=1.32U AS=0.3828P AD=0.5808P PS=2.08U
+ PD=3.52U
* device instance $842 r0 *1 8.2,106.75 nfet
M$842 \$873 A2|A3|I1|ZN VSS vsubs nfet L=0.6U W=0.36U AS=0.1584P AD=0.0936P
+ PS=1.6U PD=0.88U
* device instance $843 r0 *1 9.32,106.75 nfet
M$843 VSS A1|A2|I|ZN \$873 vsubs nfet L=0.6U W=0.36U AS=0.0936P AD=0.186P
+ PS=0.88U PD=1.36U
* device instance $844 r0 *1 10.62,106.9 nfet
M$844 \$874 \$873 VSS vsubs nfet L=0.6U W=0.66U AS=0.186P AD=0.1716P PS=1.36U
+ PD=1.18U
* device instance $845 r0 *1 11.74,106.9 nfet
M$845 \$899 A1|A2|I|ZN \$874 vsubs nfet L=0.6U W=0.66U AS=0.1716P AD=0.1056P
+ PS=1.18U PD=0.98U
* device instance $846 r0 *1 12.66,106.9 nfet
M$846 VSS A2|A3|I1|ZN \$899 vsubs nfet L=0.6U W=0.66U AS=0.1056P AD=0.2904P
+ PS=0.98U PD=2.2U
* device instance $847 r0 *1 71.48,107.11 nfet
M$847 VSS CLK|clk \$889 vsubs nfet L=0.6U W=0.79U AS=0.3476P AD=0.2054P
+ PS=2.46U PD=1.31U
* device instance $848 r0 *1 72.6,107.11 nfet
M$848 \$880 \$889 VSS vsubs nfet L=0.6U W=0.79U AS=0.2054P AD=0.3476P PS=1.31U
+ PD=2.46U
* device instance $849 r0 *1 74.44,107.215 nfet
M$849 \$909 \$889 VSS vsubs nfet L=0.6U W=0.58U AS=0.2552P AD=0.0696P PS=2.04U
+ PD=0.82U
* device instance $850 r0 *1 75.28,107.215 nfet
M$850 \$891 D|ZN$16 \$909 vsubs nfet L=0.6U W=0.58U AS=0.0696P AD=0.1508P
+ PS=0.82U PD=1.1U
* device instance $851 r0 *1 76.4,107.215 nfet
M$851 \$910 \$880 \$891 vsubs nfet L=0.6U W=0.58U AS=0.1508P AD=0.0696P PS=1.1U
+ PD=0.82U
* device instance $852 r0 *1 77.24,107.215 nfet
M$852 \$910 \$881 VSS vsubs nfet L=0.6U W=0.58U AS=0.39315P AD=0.0696P PS=2.35U
+ PD=0.82U
* device instance $853 r0 *1 78.74,107.215 nfet
M$853 \$881 \$891 VSS vsubs nfet L=0.6U W=0.58U AS=0.39315P AD=0.1508P PS=2.35U
+ PD=1.1U
* device instance $854 r0 *1 79.86,107.215 nfet
M$854 \$892 \$880 \$881 vsubs nfet L=0.6U W=0.58U AS=0.1508P AD=0.1508P PS=1.1U
+ PD=1.1U
* device instance $855 r0 *1 80.98,107.215 nfet
M$855 \$911 \$889 \$892 vsubs nfet L=0.6U W=0.58U AS=0.1508P AD=0.0696P PS=1.1U
+ PD=0.82U
* device instance $856 r0 *1 81.82,107.215 nfet
M$856 \$911 \$882 VSS vsubs nfet L=0.6U W=0.58U AS=0.252P AD=0.0696P PS=1.49U
+ PD=0.82U
* device instance $857 r0 *1 83.16,107.13 nfet
M$857 \$882 \$892 VSS vsubs nfet L=0.6U W=0.75U AS=0.252P AD=0.33P PS=1.49U
+ PD=2.38U
* device instance $858 r0 *1 88.28,107.11 nfet
M$858 VSS CLK|clk \$893 vsubs nfet L=0.6U W=0.79U AS=0.3476P AD=0.2054P
+ PS=2.46U PD=1.31U
* device instance $859 r0 *1 89.4,107.11 nfet
M$859 \$883 \$893 VSS vsubs nfet L=0.6U W=0.79U AS=0.2054P AD=0.3476P PS=1.31U
+ PD=2.46U
* device instance $860 r0 *1 91.24,107.215 nfet
M$860 \$908 \$893 VSS vsubs nfet L=0.6U W=0.58U AS=0.2552P AD=0.0696P PS=2.04U
+ PD=0.82U
* device instance $861 r0 *1 92.08,107.215 nfet
M$861 \$894 D|ZN$14 \$908 vsubs nfet L=0.6U W=0.58U AS=0.0696P AD=0.1508P
+ PS=0.82U PD=1.1U
* device instance $862 r0 *1 93.2,107.215 nfet
M$862 \$907 \$883 \$894 vsubs nfet L=0.6U W=0.58U AS=0.1508P AD=0.0696P PS=1.1U
+ PD=0.82U
* device instance $863 r0 *1 94.04,107.215 nfet
M$863 \$907 \$884 VSS vsubs nfet L=0.6U W=0.58U AS=0.39315P AD=0.0696P PS=2.35U
+ PD=0.82U
* device instance $864 r0 *1 95.54,107.215 nfet
M$864 \$884 \$894 VSS vsubs nfet L=0.6U W=0.58U AS=0.39315P AD=0.1508P PS=2.35U
+ PD=1.1U
* device instance $865 r0 *1 96.66,107.215 nfet
M$865 \$895 \$883 \$884 vsubs nfet L=0.6U W=0.58U AS=0.1508P AD=0.1508P PS=1.1U
+ PD=1.1U
* device instance $866 r0 *1 97.78,107.215 nfet
M$866 \$904 \$893 \$895 vsubs nfet L=0.6U W=0.58U AS=0.1508P AD=0.0696P PS=1.1U
+ PD=0.82U
* device instance $867 r0 *1 98.62,107.215 nfet
M$867 \$904 \$885 VSS vsubs nfet L=0.6U W=0.58U AS=0.252P AD=0.0696P PS=1.49U
+ PD=0.82U
* device instance $868 r0 *1 99.96,107.13 nfet
M$868 \$885 \$895 VSS vsubs nfet L=0.6U W=0.75U AS=0.252P AD=0.33P PS=1.49U
+ PD=2.38U
* device instance $869 r0 *1 135.785,106.715 nfet
M$869 VSS B|ZN$12 B|ZN$14 vsubs nfet L=0.6U W=0.79U AS=0.3555P AD=0.2054P
+ PS=1.885U PD=1.31U
* device instance $870 r0 *1 136.905,106.715 nfet
M$870 B|ZN$14 A1|A2|B|B2|C|Z VSS vsubs nfet L=0.6U W=0.79U AS=0.2054P
+ AD=0.3476P PS=1.31U PD=2.46U
* device instance $871 r0 *1 133.645,106.9125 nfet
M$871 \$901 A2|Z$6 VSS vsubs nfet L=0.6U W=1.185U AS=0.5214P AD=0.1422P
+ PS=3.25U PD=1.425U
* device instance $872 r0 *1 134.485,106.9125 nfet
M$872 B|ZN$14 A1|ZN$20 \$901 vsubs nfet L=0.6U W=1.185U AS=0.1422P AD=0.3555P
+ PS=1.425U PD=1.885U
* device instance $873 r0 *1 25.005,114.915 nfet
M$873 \$960 A2|ZN$45 VSS vsubs nfet L=0.6U W=1.32U AS=0.5808P AD=0.2112P
+ PS=3.52U PD=1.64U
* device instance $874 r0 *1 25.925,114.915 nfet
M$874 A2|ZN$49 A1|Z$6 \$960 vsubs nfet L=0.6U W=1.32U AS=0.2112P AD=0.5808P
+ PS=1.64U PD=3.52U
* device instance $875 r0 *1 27.24,117.05 nfet
M$875 \$965 A2|ZN$49 VSS vsubs nfet L=0.6U W=0.66U AS=0.2904P AD=0.1716P
+ PS=2.2U PD=1.18U
* device instance $876 r0 *1 28.36,117.05 nfet
M$876 \$965 A1|B|Z$2 VSS vsubs nfet L=0.6U W=0.66U AS=0.363P AD=0.1716P
+ PS=2.02U PD=1.18U
* device instance $877 r0 *1 29.66,116.92 nfet
M$877 A2|Z$7 \$965 VSS vsubs nfet L=0.6U W=1.32U AS=0.363P AD=0.3432P PS=2.02U
+ PD=1.84U
* device instance $878 r0 *1 30.78,116.92 nfet
M$878 \$974 A1|B|Z$2 A2|Z$7 vsubs nfet L=0.6U W=1.32U AS=0.3432P AD=0.2112P
+ PS=1.84U PD=1.64U
* device instance $879 r0 *1 31.7,116.92 nfet
M$879 VSS A2|ZN$49 \$974 vsubs nfet L=0.6U W=1.32U AS=0.2112P AD=0.5808P
+ PS=1.64U PD=3.52U
* device instance $880 r0 *1 36.765,114.915 nfet
M$880 \$961 A1|A2|A3|ZN$1 VSS vsubs nfet L=0.6U W=1.32U AS=0.5808P AD=0.2112P
+ PS=3.52U PD=1.64U
* device instance $881 r0 *1 37.685,114.915 nfet
M$881 A2|ZN$51 A1|A2|I|Q \$961 vsubs nfet L=0.6U W=1.32U AS=0.2112P AD=0.5808P
+ PS=1.64U PD=3.52U
* device instance $882 r0 *1 37.325,116.925 nfet
M$882 \$975 A2|Z$7 VSS vsubs nfet L=0.6U W=1.32U AS=0.5808P AD=0.2112P PS=3.52U
+ PD=1.64U
* device instance $883 r0 *1 38.245,116.925 nfet
M$883 B|ZN$17 A1|A2|B2|Z \$975 vsubs nfet L=0.6U W=1.32U AS=0.2112P AD=0.5808P
+ PS=1.64U PD=3.52U
* device instance $884 r0 *1 51.375,115.245 nfet
M$884 \$929 A1|ZN$11 VSS vsubs nfet L=0.6U W=0.66U AS=0.2904P AD=0.1716P
+ PS=2.2U PD=1.18U
* device instance $885 r0 *1 52.495,115.245 nfet
M$885 \$929 A2|ZN$36 VSS vsubs nfet L=0.6U W=0.66U AS=0.3828P AD=0.1716P
+ PS=2.08U PD=1.18U
* device instance $886 r0 *1 53.855,114.915 nfet
M$886 A1|Z$7 \$929 VSS vsubs nfet L=0.6U W=1.32U AS=0.3828P AD=0.5808P PS=2.08U
+ PD=3.52U
* device instance $887 r0 *1 55.375,116.925 nfet
M$887 \$976 A1|A2|A3|ZN$1 VSS vsubs nfet L=0.6U W=1.32U AS=0.5808P AD=0.2112P
+ PS=3.52U PD=1.64U
* device instance $888 r0 *1 56.295,116.925 nfet
M$888 \$977 A1|A2|A4|I|Q \$976 vsubs nfet L=0.6U W=1.32U AS=0.2112P AD=0.2772P
+ PS=1.64U PD=1.74U
* device instance $889 r0 *1 57.315,116.925 nfet
M$889 A2|ZN$55 A1|A2|I|Q \$977 vsubs nfet L=0.6U W=1.32U AS=0.2772P AD=0.5808P
+ PS=1.74U PD=3.52U
* device instance $890 r0 *1 61.405,114.915 nfet
M$890 \$962 A1|A2|B2|Z VSS vsubs nfet L=0.6U W=1.32U AS=0.5808P AD=0.2112P
+ PS=3.52U PD=1.64U
* device instance $891 r0 *1 62.325,114.915 nfet
M$891 A1|ZN$20 A1|A2|C|S|ZN \$962 vsubs nfet L=0.6U W=1.32U AS=0.2112P
+ AD=0.5808P PS=1.64U PD=3.52U
* device instance $892 r0 *1 68.68,116.925 nfet
M$892 A1|ZN$21 A2|ZN$54 \$968 vsubs nfet L=0.6U W=1.32U AS=0.5808P AD=0.3432P
+ PS=3.52U PD=1.84U
* device instance $893 r0 *1 69.8,116.925 nfet
M$893 \$968 A1|B|Z$1 A1|ZN$21 vsubs nfet L=0.6U W=1.32U AS=0.3432P AD=0.363P
+ PS=1.84U PD=1.87U
* device instance $894 r0 *1 70.95,116.925 nfet
M$894 \$978 B|ZN$17 \$968 vsubs nfet L=0.6U W=1.32U AS=0.363P AD=0.2442P
+ PS=1.87U PD=1.69U
* device instance $895 r0 *1 71.92,116.925 nfet
M$895 VSS A1|A2|C|S|ZN \$978 vsubs nfet L=0.6U W=1.32U AS=0.2442P AD=0.5808P
+ PS=1.69U PD=3.52U
* device instance $896 r0 *1 73.7,114.715 nfet
M$896 VSS A1|B|C|I|ZN D|ZN$16 vsubs nfet L=0.6U W=0.92U AS=0.402P AD=0.4048P
+ PS=2.02U PD=2.72U
* device instance $897 r0 *1 71.48,114.915 nfet
M$897 \$963 A2|ZN$41 VSS vsubs nfet L=0.6U W=1.32U AS=0.5808P AD=0.2112P
+ PS=3.52U PD=1.64U
* device instance $898 r0 *1 72.4,114.915 nfet
M$898 D|ZN$16 A1|ZN$21 \$963 vsubs nfet L=0.6U W=1.32U AS=0.2112P AD=0.402P
+ PS=1.64U PD=2.02U
* device instance $899 r0 *1 83.865,116.925 nfet
M$899 \$979 A1|A2|B2|Z VSS vsubs nfet L=0.6U W=1.32U AS=0.5808P AD=0.2112P
+ PS=3.52U PD=1.64U
* device instance $900 r0 *1 84.785,116.925 nfet
M$900 A2|ZN$50 B1|ZN$4 \$979 vsubs nfet L=0.6U W=1.32U AS=0.2112P AD=0.3432P
+ PS=1.64U PD=1.84U
* device instance $901 r0 *1 85.905,116.925 nfet
M$901 \$980 A1|ZN$22 A2|ZN$50 vsubs nfet L=0.6U W=1.32U AS=0.3432P AD=0.2112P
+ PS=1.84U PD=1.64U
* device instance $902 r0 *1 86.825,116.925 nfet
M$902 VSS A2|ZN$52 \$980 vsubs nfet L=0.6U W=1.32U AS=0.2112P AD=0.5808P
+ PS=1.64U PD=3.52U
* device instance $903 r0 *1 88.28,114.88 nfet
M$903 B|ZN$13 A2|ZN$50 VSS vsubs nfet L=0.6U W=0.92U AS=0.4048P AD=0.2392P
+ PS=2.72U PD=1.44U
* device instance $904 r0 *1 89.4,114.88 nfet
M$904 VSS A1|A2|B|B2|C|Z B|ZN$13 vsubs nfet L=0.6U W=0.92U AS=0.2392P
+ AD=0.4048P PS=1.44U PD=2.72U
* device instance $905 r0 *1 99.34,117.125 nfet
M$905 VSS A1|A3|B|Q A2|ZN$53 vsubs nfet L=0.6U W=0.92U AS=0.402P AD=0.4048P
+ PS=2.02U PD=2.72U
* device instance $906 r0 *1 100.64,116.925 nfet
M$906 \$981 A1|A2|Q A2|ZN$53 vsubs nfet L=0.6U W=1.32U AS=0.402P AD=0.2112P
+ PS=2.02U PD=1.64U
* device instance $907 r0 *1 101.56,116.925 nfet
M$907 VSS A2|A3|ZN$6 \$981 vsubs nfet L=0.6U W=1.32U AS=0.2112P AD=0.5808P
+ PS=1.64U PD=3.52U
* device instance $908 r0 *1 101.72,115.01 nfet
M$908 \$932 A1|A2|ZN$4 VSS vsubs nfet L=0.6U W=0.36U AS=0.1584P AD=0.0936P
+ PS=1.6U PD=0.88U
* device instance $909 r0 *1 102.84,115.01 nfet
M$909 \$932 A1|A3|B|Q VSS vsubs nfet L=0.6U W=0.36U AS=0.186P AD=0.0936P
+ PS=1.36U PD=0.88U
* device instance $910 r0 *1 104.14,114.86 nfet
M$910 \$934 \$932 VSS vsubs nfet L=0.6U W=0.66U AS=0.186P AD=0.1716P PS=1.36U
+ PD=1.18U
* device instance $911 r0 *1 105.26,114.86 nfet
M$911 \$959 A1|A3|B|Q \$934 vsubs nfet L=0.6U W=0.66U AS=0.1716P AD=0.1056P
+ PS=1.18U PD=0.98U
* device instance $912 r0 *1 106.18,114.86 nfet
M$912 VSS A1|A2|ZN$4 \$959 vsubs nfet L=0.6U W=0.66U AS=0.1056P AD=0.2904P
+ PS=0.98U PD=2.2U
* device instance $913 r0 *1 106.205,116.925 nfet
M$913 \$982 A2|A3|ZN$6 VSS vsubs nfet L=0.6U W=1.32U AS=0.5808P AD=0.2112P
+ PS=3.52U PD=1.64U
* device instance $914 r0 *1 107.125,116.925 nfet
M$914 A3|ZN$1 A1|A2|Q \$982 vsubs nfet L=0.6U W=1.32U AS=0.2112P AD=0.5808P
+ PS=1.64U PD=3.52U
* device instance $915 r0 *1 108.02,114.86 nfet
M$915 \$958 \$934 \$935 vsubs nfet L=0.6U W=0.66U AS=0.2904P AD=0.1056P PS=2.2U
+ PD=0.98U
* device instance $916 r0 *1 108.94,114.86 nfet
M$916 \$958 A3|ZN$1 VSS vsubs nfet L=0.6U W=0.66U AS=0.363P AD=0.1056P PS=2.02U
+ PD=0.98U
* device instance $917 r0 *1 110.24,114.915 nfet
M$917 \$954 \$935 VSS vsubs nfet L=0.6U W=1.32U AS=0.363P AD=0.3432P PS=2.02U
+ PD=1.84U
* device instance $918 r0 *1 111.36,114.915 nfet
M$918 A2|ZN$43 A3|ZN$1 \$954 vsubs nfet L=0.6U W=1.32U AS=0.3432P AD=0.3432P
+ PS=1.84U PD=1.84U
* device instance $919 r0 *1 112.48,114.915 nfet
M$919 \$954 \$934 A2|ZN$43 vsubs nfet L=0.6U W=1.32U AS=0.3432P AD=0.5808P
+ PS=1.84U PD=3.52U
* device instance $920 r0 *1 119.64,114.915 nfet
M$920 B|ZN$16 A2|ZN$43 \$952 vsubs nfet L=0.6U W=1.32U AS=0.5808P AD=0.3432P
+ PS=3.52U PD=1.84U
* device instance $921 r0 *1 120.76,114.915 nfet
M$921 \$952 A1|ZN$18 B|ZN$16 vsubs nfet L=0.6U W=1.32U AS=0.3432P AD=0.3432P
+ PS=1.84U PD=1.84U
* device instance $922 r0 *1 121.88,114.915 nfet
M$922 VSS A1|B|Z$1 \$952 vsubs nfet L=0.6U W=1.32U AS=0.3432P AD=0.5808P
+ PS=1.84U PD=3.52U
* device instance $923 r0 *1 138.12,114.65 nfet
M$923 VSS CLK|clk \$937 vsubs nfet L=0.6U W=0.79U AS=0.3476P AD=0.2054P
+ PS=2.46U PD=1.31U
* device instance $924 r0 *1 139.24,114.65 nfet
M$924 \$938 \$937 VSS vsubs nfet L=0.6U W=0.79U AS=0.2054P AD=0.3476P PS=1.31U
+ PD=2.46U
* device instance $925 r0 *1 141.08,114.545 nfet
M$925 \$957 \$937 VSS vsubs nfet L=0.6U W=0.58U AS=0.2552P AD=0.0696P PS=2.04U
+ PD=0.82U
* device instance $926 r0 *1 141.92,114.545 nfet
M$926 \$939 D|ZN$15 \$957 vsubs nfet L=0.6U W=0.58U AS=0.0696P AD=0.1508P
+ PS=0.82U PD=1.1U
* device instance $927 r0 *1 143.04,114.545 nfet
M$927 \$956 \$938 \$939 vsubs nfet L=0.6U W=0.58U AS=0.1508P AD=0.0696P PS=1.1U
+ PD=0.82U
* device instance $928 r0 *1 143.88,114.545 nfet
M$928 VSS \$940 \$956 vsubs nfet L=0.6U W=0.58U AS=0.0696P AD=0.39315P PS=0.82U
+ PD=2.35U
* device instance $929 r0 *1 145.38,114.545 nfet
M$929 \$940 \$939 VSS vsubs nfet L=0.6U W=0.58U AS=0.39315P AD=0.1508P PS=2.35U
+ PD=1.1U
* device instance $930 r0 *1 146.5,114.545 nfet
M$930 \$941 \$938 \$940 vsubs nfet L=0.6U W=0.58U AS=0.1508P AD=0.1508P PS=1.1U
+ PD=1.1U
* device instance $931 r0 *1 147.62,114.545 nfet
M$931 \$955 \$937 \$941 vsubs nfet L=0.6U W=0.58U AS=0.1508P AD=0.0696P PS=1.1U
+ PD=0.82U
* device instance $932 r0 *1 148.46,114.545 nfet
M$932 VSS \$942 \$955 vsubs nfet L=0.6U W=0.58U AS=0.0696P AD=0.252P PS=0.82U
+ PD=1.49U
* device instance $933 r0 *1 149.8,114.63 nfet
M$933 \$942 \$941 VSS vsubs nfet L=0.6U W=0.75U AS=0.252P AD=0.33P PS=1.49U
+ PD=2.38U
* device instance $934 r0 *1 151.64,114.915 nfet
M$934 A1|A3|B|Q \$942 VSS vsubs nfet L=0.6U W=1.32U AS=0.5808P AD=0.5808P
+ PS=3.52U PD=3.52U
* device instance $935 r0 *1 23.46,124.84 nfet
M$935 \$993 \$992 VSS vsubs nfet L=0.6U W=0.66U AS=0.2904P AD=0.1716P PS=2.2U
+ PD=1.18U
* device instance $936 r0 *1 24.58,124.84 nfet
M$936 \$993 A2|A3|ZN$7 VSS vsubs nfet L=0.6U W=0.66U AS=0.363P AD=0.1716P
+ PS=2.02U PD=1.18U
* device instance $937 r0 *1 25.88,124.995 nfet
M$937 A1|B|Z$2 \$993 VSS vsubs nfet L=0.6U W=1.32U AS=0.363P AD=0.3432P
+ PS=2.02U PD=1.84U
* device instance $938 r0 *1 27,124.995 nfet
M$938 \$1042 A2|A3|ZN$7 A1|B|Z$2 vsubs nfet L=0.6U W=1.32U AS=0.3432P
+ AD=0.2112P PS=1.84U PD=1.64U
* device instance $939 r0 *1 27.92,124.995 nfet
M$939 VSS \$992 \$1042 vsubs nfet L=0.6U W=1.32U AS=0.2112P AD=0.5808P PS=1.64U
+ PD=3.52U
* device instance $940 r0 *1 36.24,124.665 nfet
M$940 \$1036 A2|ZN$51 \$995 vsubs nfet L=0.6U W=0.66U AS=0.2904P AD=0.1056P
+ PS=2.2U PD=0.98U
* device instance $941 r0 *1 37.16,124.665 nfet
M$941 VSS A1|B|ZN$2 \$1036 vsubs nfet L=0.6U W=0.66U AS=0.1056P AD=0.363P
+ PS=0.98U PD=2.02U
* device instance $942 r0 *1 38.46,124.995 nfet
M$942 \$1032 \$995 VSS vsubs nfet L=0.6U W=1.32U AS=0.363P AD=0.3432P PS=2.02U
+ PD=1.84U
* device instance $943 r0 *1 39.58,124.995 nfet
M$943 A2|A3|ZN$7 A1|B|ZN$2 \$1032 vsubs nfet L=0.6U W=1.32U AS=0.3432P
+ AD=0.3432P PS=1.84U PD=1.84U
* device instance $944 r0 *1 40.7,124.995 nfet
M$944 \$1032 A2|ZN$51 A2|A3|ZN$7 vsubs nfet L=0.6U W=1.32U AS=0.3432P
+ AD=0.5808P PS=1.84U PD=3.52U
* device instance $945 r0 *1 49.78,124.94 nfet
M$945 \$1038 \$999 \$1000 vsubs nfet L=0.6U W=0.66U AS=0.2904P AD=0.1056P
+ PS=2.2U PD=0.98U
* device instance $946 r0 *1 50.7,124.94 nfet
M$946 \$1038 A2|A3|ZN$3 VSS vsubs nfet L=0.6U W=0.66U AS=0.363P AD=0.1056P
+ PS=2.02U PD=0.98U
* device instance $947 r0 *1 52,124.995 nfet
M$947 \$1035 \$1000 VSS vsubs nfet L=0.6U W=1.32U AS=0.363P AD=0.3432P PS=2.02U
+ PD=1.84U
* device instance $948 r0 *1 53.12,124.995 nfet
M$948 A2|ZN$56 A2|A3|ZN$3 \$1035 vsubs nfet L=0.6U W=1.32U AS=0.3432P
+ AD=0.3432P PS=1.84U PD=1.84U
* device instance $949 r0 *1 54.24,124.995 nfet
M$949 \$1035 \$999 A2|ZN$56 vsubs nfet L=0.6U W=1.32U AS=0.3432P AD=0.5808P
+ PS=1.84U PD=3.52U
* device instance $950 r0 *1 65.325,124.995 nfet
M$950 \$1044 A2|ZN$57 VSS vsubs nfet L=0.6U W=1.32U AS=0.5808P AD=0.2112P
+ PS=3.52U PD=1.64U
* device instance $951 r0 *1 66.245,124.995 nfet
M$951 A2|ZN$54 A1|Z$8 \$1044 vsubs nfet L=0.6U W=1.32U AS=0.2112P AD=0.5808P
+ PS=1.64U PD=3.52U
* device instance $952 r0 *1 84.925,124.995 nfet
M$952 \$1045 A2|Z$8 VSS vsubs nfet L=0.6U W=1.32U AS=0.5808P AD=0.2112P
+ PS=3.52U PD=1.64U
* device instance $953 r0 *1 85.845,124.995 nfet
M$953 A1|ZN$22 A1|Z$8 \$1045 vsubs nfet L=0.6U W=1.32U AS=0.2112P AD=0.5808P
+ PS=1.64U PD=3.52U
* device instance $954 r0 *1 102.28,124.995 nfet
M$954 B|ZN$15 A2|ZN$53 \$1033 vsubs nfet L=0.6U W=1.32U AS=0.5808P AD=0.3432P
+ PS=3.52U PD=1.84U
* device instance $955 r0 *1 103.4,124.995 nfet
M$955 \$1033 A1|A2|ZN$8 B|ZN$15 vsubs nfet L=0.6U W=1.32U AS=0.3432P AD=0.3432P
+ PS=1.84U PD=1.84U
* device instance $956 r0 *1 104.52,124.995 nfet
M$956 VSS B|ZN$18 \$1033 vsubs nfet L=0.6U W=1.32U AS=0.3432P AD=0.5808P
+ PS=1.84U PD=3.52U
* device instance $957 r0 *1 119.675,124.995 nfet
M$957 \$1043 A1|A2|B|ZN$1 A1|A2|ZN$9 vsubs nfet L=0.6U W=1.32U AS=0.5808P
+ AD=0.2112P PS=3.52U PD=1.64U
* device instance $958 r0 *1 120.595,124.995 nfet
M$958 VSS A2|C|ZN \$1043 vsubs nfet L=0.6U W=1.32U AS=0.2112P AD=0.5808P
+ PS=1.64U PD=3.52U
* device instance $959 r0 *1 125.2,124.995 nfet
M$959 \$1041 A2|C|ZN VSS vsubs nfet L=0.6U W=1.32U AS=0.5808P AD=0.2442P
+ PS=3.52U PD=1.69U
* device instance $960 r0 *1 126.17,124.995 nfet
M$960 \$1034 A1|A2|B|ZN$1 \$1041 vsubs nfet L=0.6U W=1.32U AS=0.2442P AD=0.363P
+ PS=1.69U PD=1.87U
* device instance $961 r0 *1 127.32,124.995 nfet
M$961 A2|ZN$58 A1|B|Z$3 \$1034 vsubs nfet L=0.6U W=1.32U AS=0.363P AD=0.3432P
+ PS=1.87U PD=1.84U
* device instance $962 r0 *1 128.44,124.995 nfet
M$962 \$1034 A2|ZN$59 A2|ZN$58 vsubs nfet L=0.6U W=1.32U AS=0.3432P AD=0.5808P
+ PS=1.84U PD=3.52U
* device instance $963 r0 *1 134.74,124.795 nfet
M$963 VSS A1|B|Z$3 A3|ZN$2 vsubs nfet L=0.6U W=0.92U AS=0.402P AD=0.4048P
+ PS=2.02U PD=2.72U
* device instance $964 r0 *1 132.52,124.995 nfet
M$964 \$1040 A1|A2|ZN$8 VSS vsubs nfet L=0.6U W=1.32U AS=0.5808P AD=0.2112P
+ PS=3.52U PD=1.64U
* device instance $965 r0 *1 133.44,124.995 nfet
M$965 A3|ZN$2 A1|A3|B|Q \$1040 vsubs nfet L=0.6U W=1.32U AS=0.2112P AD=0.402P
+ PS=1.64U PD=2.02U
* device instance $966 r0 *1 17.16,124.99 nfet
M$966 \$1018 A2|ZN$27 VSS vsubs nfet L=0.6U W=0.36U AS=0.1584P AD=0.0936P
+ PS=1.6U PD=0.88U
* device instance $967 r0 *1 18.28,124.99 nfet
M$967 \$1018 A1|A2|ZN$5 VSS vsubs nfet L=0.6U W=0.36U AS=0.186P AD=0.0936P
+ PS=1.36U PD=0.88U
* device instance $968 r0 *1 19.58,124.84 nfet
M$968 \$992 \$1018 VSS vsubs nfet L=0.6U W=0.66U AS=0.186P AD=0.1716P PS=1.36U
+ PD=1.18U
* device instance $969 r0 *1 20.7,124.84 nfet
M$969 \$1037 A1|A2|ZN$5 \$992 vsubs nfet L=0.6U W=0.66U AS=0.1716P AD=0.1056P
+ PS=1.18U PD=0.98U
* device instance $970 r0 *1 21.62,124.84 nfet
M$970 VSS A2|ZN$27 \$1037 vsubs nfet L=0.6U W=0.66U AS=0.1056P AD=0.2904P
+ PS=0.98U PD=2.2U
* device instance $971 r0 *1 25,127.005 nfet
M$971 \$1053 A2|ZN$45 VSS vsubs nfet L=0.6U W=1.32U AS=0.5808P AD=0.2112P
+ PS=3.52U PD=1.64U
* device instance $972 r0 *1 25.92,127.005 nfet
M$972 A2|ZN$60 A1|Z$6 \$1053 vsubs nfet L=0.6U W=1.32U AS=0.2112P AD=0.402P
+ PS=1.64U PD=2.02U
* device instance $973 r0 *1 27.22,127.205 nfet
M$973 VSS A1|B|Z$2 A2|ZN$60 vsubs nfet L=0.6U W=0.92U AS=0.402P AD=0.4048P
+ PS=2.02U PD=2.72U
* device instance $974 r0 *1 39.005,127.005 nfet
M$974 \$1054 A2|A3|Z$2 VSS vsubs nfet L=0.6U W=1.32U AS=0.5808P AD=0.2112P
+ PS=3.52U PD=1.64U
* device instance $975 r0 *1 39.925,127.005 nfet
M$975 A1|A2|ZN$7 A1|A2|ZN$4 \$1054 vsubs nfet L=0.6U W=1.32U AS=0.2112P
+ AD=0.5808P PS=1.64U PD=3.52U
* device instance $976 r0 *1 43.48,125.09 nfet
M$976 \$997 A1|A2|ZN$7 VSS vsubs nfet L=0.6U W=0.36U AS=0.1584P AD=0.0936P
+ PS=1.6U PD=0.88U
* device instance $977 r0 *1 44.6,125.09 nfet
M$977 \$997 A1|B|ZN$2 VSS vsubs nfet L=0.6U W=0.36U AS=0.186P AD=0.0936P
+ PS=1.36U PD=0.88U
* device instance $978 r0 *1 45.9,124.94 nfet
M$978 \$999 \$997 VSS vsubs nfet L=0.6U W=0.66U AS=0.186P AD=0.1716P PS=1.36U
+ PD=1.18U
* device instance $979 r0 *1 47.02,124.94 nfet
M$979 \$1039 A1|B|ZN$2 \$999 vsubs nfet L=0.6U W=0.66U AS=0.1716P AD=0.1056P
+ PS=1.18U PD=0.98U
* device instance $980 r0 *1 47.94,124.94 nfet
M$980 VSS A1|A2|ZN$7 \$1039 vsubs nfet L=0.6U W=0.66U AS=0.1056P AD=0.2904P
+ PS=0.98U PD=2.2U
* device instance $981 r0 *1 59.725,127.005 nfet
M$981 \$1057 A2|ZN$56 VSS vsubs nfet L=0.6U W=1.32U AS=0.5808P AD=0.2112P
+ PS=3.52U PD=1.64U
* device instance $982 r0 *1 60.645,127.005 nfet
M$982 A2|ZN$57 A1|Z$7 \$1057 vsubs nfet L=0.6U W=1.32U AS=0.2112P AD=0.5808P
+ PS=1.64U PD=3.52U
* device instance $983 r0 *1 60.335,125.325 nfet
M$983 \$1002 A1|Z$7 VSS vsubs nfet L=0.6U W=0.66U AS=0.2904P AD=0.1716P PS=2.2U
+ PD=1.18U
* device instance $984 r0 *1 61.455,125.325 nfet
M$984 \$1002 A2|ZN$56 VSS vsubs nfet L=0.6U W=0.66U AS=0.3828P AD=0.1716P
+ PS=2.08U PD=1.18U
* device instance $985 r0 *1 62.815,124.995 nfet
M$985 A1|Z$8 \$1002 VSS vsubs nfet L=0.6U W=1.32U AS=0.3828P AD=0.5808P
+ PS=2.08U PD=3.52U
* device instance $986 r0 *1 70.74,127.005 nfet
M$986 A2|ZN$65 A2|ZN$55 \$1047 vsubs nfet L=0.6U W=1.32U AS=0.5808P AD=0.3432P
+ PS=3.52U PD=1.84U
* device instance $987 r0 *1 71.86,127.005 nfet
M$987 \$1047 A1|ZN$23 A2|ZN$65 vsubs nfet L=0.6U W=1.32U AS=0.3432P AD=0.3432P
+ PS=1.84U PD=1.84U
* device instance $988 r0 *1 72.98,127.005 nfet
M$988 VSS \$1048 \$1047 vsubs nfet L=0.6U W=1.32U AS=0.3432P AD=0.363P PS=1.84U
+ PD=2.02U
* device instance $989 r0 *1 74.28,127.335 nfet
M$989 \$1058 A1|ZN$23 VSS vsubs nfet L=0.6U W=0.66U AS=0.363P AD=0.1056P
+ PS=2.02U PD=0.98U
* device instance $990 r0 *1 75.2,127.335 nfet
M$990 \$1048 A2|ZN$55 \$1058 vsubs nfet L=0.6U W=0.66U AS=0.1056P AD=0.2904P
+ PS=0.98U PD=2.2U
* device instance $991 r0 *1 75.96,124.96 nfet
M$991 A2|A3|ZN$6 A2|ZN$55 VSS vsubs nfet L=0.6U W=0.92U AS=0.4048P AD=0.2392P
+ PS=2.72U PD=1.44U
* device instance $992 r0 *1 77.08,124.96 nfet
M$992 VSS A1|ZN$23 A2|A3|ZN$6 vsubs nfet L=0.6U W=0.92U AS=0.2392P AD=0.4048P
+ PS=1.44U PD=2.72U
* device instance $993 r0 *1 88.12,124.96 nfet
M$993 A2|ZN$52 A1|B|Z$1 VSS vsubs nfet L=0.6U W=0.92U AS=0.4048P AD=0.2392P
+ PS=2.72U PD=1.44U
* device instance $994 r0 *1 89.24,124.96 nfet
M$994 VSS A1|A2|B|ZN$1 A2|ZN$52 vsubs nfet L=0.6U W=0.92U AS=0.2392P AD=0.4048P
+ PS=1.44U PD=2.72U
* device instance $995 r0 *1 101.295,127.005 nfet
M$995 \$1061 A2|A3|ZN$6 VSS vsubs nfet L=0.6U W=1.32U AS=0.5808P AD=0.2112P
+ PS=3.52U PD=1.64U
* device instance $996 r0 *1 102.215,127.005 nfet
M$996 \$1062 A1|A2|Q \$1061 vsubs nfet L=0.6U W=1.32U AS=0.2112P AD=0.2772P
+ PS=1.64U PD=1.74U
* device instance $997 r0 *1 103.235,127.005 nfet
M$997 B|ZN$18 A1|A3|B|Q \$1062 vsubs nfet L=0.6U W=1.32U AS=0.2772P AD=0.5808P
+ PS=1.74U PD=3.52U
* device instance $998 r0 *1 115.215,125.325 nfet
M$998 \$1007 A1|A2|B|ZN$1 VSS vsubs nfet L=0.6U W=0.66U AS=0.2904P AD=0.1716P
+ PS=2.2U PD=1.18U
* device instance $999 r0 *1 116.335,125.325 nfet
M$999 \$1007 A2|C|ZN VSS vsubs nfet L=0.6U W=0.66U AS=0.3828P AD=0.1716P
+ PS=2.08U PD=1.18U
* device instance $1000 r0 *1 117.695,124.995 nfet
M$1000 A3|Z$2 \$1007 VSS vsubs nfet L=0.6U W=1.32U AS=0.3828P AD=0.5808P
+ PS=2.08U PD=3.52U
* device instance $1001 r0 *1 116.845,127.005 nfet
M$1001 \$1059 A1|ZN$20 A1|ZN$17 vsubs nfet L=0.6U W=1.32U AS=0.5808P AD=0.2772P
+ PS=3.52U PD=1.74U
* device instance $1002 r0 *1 117.865,127.005 nfet
M$1002 \$1060 A1|A2|ZN$9 \$1059 vsubs nfet L=0.6U W=1.32U AS=0.2772P AD=0.2112P
+ PS=1.74U PD=1.64U
* device instance $1003 r0 *1 118.785,127.005 nfet
M$1003 VSS A3|Z$2 \$1060 vsubs nfet L=0.6U W=1.32U AS=0.2112P AD=0.5808P
+ PS=1.64U PD=3.52U
* device instance $1004 r0 *1 133.78,127.06 nfet
M$1004 \$1055 \$1050 \$1051 vsubs nfet L=0.6U W=0.66U AS=0.2904P AD=0.1056P
+ PS=2.2U PD=0.98U
* device instance $1005 r0 *1 134.7,127.06 nfet
M$1005 \$1055 A3|ZN$2 VSS vsubs nfet L=0.6U W=0.66U AS=0.363P AD=0.1056P
+ PS=2.02U PD=0.98U
* device instance $1006 r0 *1 136,127.005 nfet
M$1006 \$1052 \$1051 VSS vsubs nfet L=0.6U W=1.32U AS=0.363P AD=0.3432P
+ PS=2.02U PD=1.84U
* device instance $1007 r0 *1 137.12,127.005 nfet
M$1007 A2|ZN$44 A3|ZN$2 \$1052 vsubs nfet L=0.6U W=1.32U AS=0.3432P AD=0.3432P
+ PS=1.84U PD=1.84U
* device instance $1008 r0 *1 138.24,127.005 nfet
M$1008 \$1052 \$1050 A2|ZN$44 vsubs nfet L=0.6U W=1.32U AS=0.3432P AD=0.5808P
+ PS=1.84U PD=3.52U
* device instance $1009 r0 *1 19.4,127.04 nfet
M$1009 A1|A2|ZN$8 A2|ZN$27 VSS vsubs nfet L=0.6U W=0.92U AS=0.4048P AD=0.2392P
+ PS=2.72U PD=1.44U
* device instance $1010 r0 *1 20.52,127.04 nfet
M$1010 VSS A1|A2|ZN$5 A1|A2|ZN$8 vsubs nfet L=0.6U W=0.92U AS=0.2392P
+ AD=0.4048P PS=1.44U PD=2.72U
* device instance $1011 r0 *1 37.74,134.875 nfet
M$1011 A1|ZN$26 B|ZN$21 VSS vsubs nfet L=0.6U W=0.92U AS=0.4048P AD=0.402P
+ PS=2.72U PD=2.02U
* device instance $1012 r0 *1 39.04,135.075 nfet
M$1012 \$1102 A1|ZN$25 A1|ZN$26 vsubs nfet L=0.6U W=1.32U AS=0.402P AD=0.2112P
+ PS=2.02U PD=1.64U
* device instance $1013 r0 *1 39.96,135.075 nfet
M$1013 VSS A2|A3|ZN$3 \$1102 vsubs nfet L=0.6U W=1.32U AS=0.2112P AD=0.5808P
+ PS=1.64U PD=3.52U
* device instance $1014 r0 *1 41.8,127.04 nfet
M$1014 A1|ZN$24 A2|A3|ZN$7 VSS vsubs nfet L=0.6U W=0.92U AS=0.4048P AD=0.2392P
+ PS=2.72U PD=1.44U
* device instance $1015 r0 *1 42.92,127.04 nfet
M$1015 VSS A1|A2|ZN$7 A1|ZN$24 vsubs nfet L=0.6U W=0.92U AS=0.2392P AD=0.4048P
+ PS=1.44U PD=2.72U
* device instance $1016 r0 *1 51.16,127.3 nfet
M$1016 VSS A1|A2|A4|I|Q A1|B|ZN$2 vsubs nfet L=0.6U W=0.73U AS=0.3212P
+ AD=0.3212P PS=2.34U PD=2.34U
* device instance $1017 r0 *1 73.12,135.075 nfet
M$1017 \$1104 A1|C|Z VSS vsubs nfet L=0.6U W=1.32U AS=0.5808P AD=0.2442P
+ PS=3.52U PD=1.69U
* device instance $1018 r0 *1 74.09,135.075 nfet
M$1018 \$1098 B|ZN$19 \$1104 vsubs nfet L=0.6U W=1.32U AS=0.2442P AD=0.363P
+ PS=1.69U PD=1.87U
* device instance $1019 r0 *1 75.24,135.075 nfet
M$1019 A1|ZN$18 A1|A2|ZN$8 \$1098 vsubs nfet L=0.6U W=1.32U AS=0.363P
+ AD=0.3432P PS=1.87U PD=1.84U
* device instance $1020 r0 *1 76.36,135.075 nfet
M$1020 \$1098 A2|ZN$61 A1|ZN$18 vsubs nfet L=0.6U W=1.32U AS=0.3432P AD=0.5808P
+ PS=1.84U PD=3.52U
* device instance $1021 r0 *1 86.6,127.04 nfet
M$1021 A1|A2|B|ZN$1 A2|Z$8 VSS vsubs nfet L=0.6U W=0.92U AS=0.4048P AD=0.2392P
+ PS=2.72U PD=1.44U
* device instance $1022 r0 *1 87.72,127.04 nfet
M$1022 VSS A1|Z$8 A1|A2|B|ZN$1 vsubs nfet L=0.6U W=0.92U AS=0.2392P AD=0.4048P
+ PS=1.44U PD=2.72U
* device instance $1023 r0 *1 90.36,134.78 nfet
M$1023 VSS A1|A3|I|Q A1|ZN$23 vsubs nfet L=0.6U W=0.73U AS=0.3212P AD=0.3212P
+ PS=2.34U PD=2.34U
* device instance $1024 r0 *1 98.92,135.075 nfet
M$1024 A2|A3|ZN$8 A2|ZN$64 \$1099 vsubs nfet L=0.6U W=1.32U AS=0.5808P
+ AD=0.3432P PS=3.52U PD=1.84U
* device instance $1025 r0 *1 100.04,135.075 nfet
M$1025 \$1099 A1|ZN$26 A2|A3|ZN$8 vsubs nfet L=0.6U W=1.32U AS=0.3432P
+ AD=0.363P PS=1.84U PD=1.87U
* device instance $1026 r0 *1 101.19,135.075 nfet
M$1026 \$1103 B|ZN$20 \$1099 vsubs nfet L=0.6U W=1.32U AS=0.363P AD=0.2442P
+ PS=1.87U PD=1.69U
* device instance $1027 r0 *1 102.16,135.075 nfet
M$1027 VSS B|C|ZN$1 \$1103 vsubs nfet L=0.6U W=1.32U AS=0.2442P AD=0.5808P
+ PS=1.69U PD=3.52U
* device instance $1028 r0 *1 127.48,126.91 nfet
M$1028 \$1049 A2|ZN$58 VSS vsubs nfet L=0.6U W=0.36U AS=0.1584P AD=0.0936P
+ PS=1.6U PD=0.88U
* device instance $1029 r0 *1 128.6,126.91 nfet
M$1029 VSS A1|A2|B2|Z \$1049 vsubs nfet L=0.6U W=0.36U AS=0.0936P AD=0.186P
+ PS=0.88U PD=1.36U
* device instance $1030 r0 *1 129.9,127.06 nfet
M$1030 \$1050 \$1049 VSS vsubs nfet L=0.6U W=0.66U AS=0.186P AD=0.1716P
+ PS=1.36U PD=1.18U
* device instance $1031 r0 *1 131.02,127.06 nfet
M$1031 \$1056 A1|A2|B2|Z \$1050 vsubs nfet L=0.6U W=0.66U AS=0.1716P AD=0.1056P
+ PS=1.18U PD=0.98U
* device instance $1032 r0 *1 131.94,127.06 nfet
M$1032 VSS A2|ZN$58 \$1056 vsubs nfet L=0.6U W=0.66U AS=0.1056P AD=0.2904P
+ PS=0.98U PD=2.2U
* device instance $1033 r0 *1 129.3,134.92 nfet
M$1033 \$1090 \$1088 VSS vsubs nfet L=0.6U W=0.66U AS=0.2904P AD=0.1716P
+ PS=2.2U PD=1.18U
* device instance $1034 r0 *1 130.42,134.92 nfet
M$1034 \$1090 A3|ZN$3 VSS vsubs nfet L=0.6U W=0.66U AS=0.363P AD=0.1716P
+ PS=2.02U PD=1.18U
* device instance $1035 r0 *1 131.72,135.075 nfet
M$1035 A2|Z$6 \$1090 VSS vsubs nfet L=0.6U W=1.32U AS=0.363P AD=0.3432P
+ PS=2.02U PD=1.84U
* device instance $1036 r0 *1 132.84,135.075 nfet
M$1036 \$1101 A3|ZN$3 A2|Z$6 vsubs nfet L=0.6U W=1.32U AS=0.3432P AD=0.2112P
+ PS=1.84U PD=1.64U
* device instance $1037 r0 *1 133.76,135.075 nfet
M$1037 VSS \$1088 \$1101 vsubs nfet L=0.6U W=1.32U AS=0.2112P AD=0.5808P
+ PS=1.64U PD=3.52U
* device instance $1038 r0 *1 36.335,137.085 nfet
M$1038 \$1118 A2|A3|Z$2 VSS vsubs nfet L=0.6U W=1.32U AS=0.5808P AD=0.2112P
+ PS=3.52U PD=1.64U
* device instance $1039 r0 *1 37.255,137.085 nfet
M$1039 \$1119 A1|A2|ZN$4 \$1118 vsubs nfet L=0.6U W=1.32U AS=0.2112P AD=0.2772P
+ PS=1.64U PD=1.74U
* device instance $1040 r0 *1 38.275,137.085 nfet
M$1040 A1|ZN$25 A1|B|ZN$2 \$1119 vsubs nfet L=0.6U W=1.32U AS=0.2772P
+ AD=0.5808P PS=1.74U PD=3.52U
* device instance $1041 r0 *1 53.56,135.3125 nfet
M$1041 VSS A1|ZN$24 \$1082 vsubs nfet L=0.6U W=0.525U AS=0.231P AD=0.1365P
+ PS=1.93U PD=1.045U
* device instance $1042 r0 *1 54.68,135.3125 nfet
M$1042 \$1082 A2|ZN$60 VSS vsubs nfet L=0.6U W=0.525U AS=0.1365P AD=0.184P
+ PS=1.045U PD=1.23U
* device instance $1043 r0 *1 55.98,135.3175 nfet
M$1043 \$1082 A3|B|ZN$1 VSS vsubs nfet L=0.6U W=0.525U AS=0.3585P AD=0.184P
+ PS=2.08U PD=1.23U
* device instance $1044 r0 *1 57.34,135.075 nfet
M$1044 A2|Z$9 \$1082 VSS vsubs nfet L=0.6U W=1.32U AS=0.3585P AD=0.5808P
+ PS=2.08U PD=3.52U
* device instance $1045 r0 *1 54.12,137.085 nfet
M$1045 A1|A2|ZN$10 A2|ZN$60 \$1105 vsubs nfet L=0.6U W=1.32U AS=0.5808P
+ AD=0.3432P PS=3.52U PD=1.84U
* device instance $1046 r0 *1 55.24,137.085 nfet
M$1046 \$1105 A1|ZN$24 A1|A2|ZN$10 vsubs nfet L=0.6U W=1.32U AS=0.3432P
+ AD=0.3432P PS=1.84U PD=1.84U
* device instance $1047 r0 *1 56.36,137.085 nfet
M$1047 VSS A3|B|ZN$1 \$1105 vsubs nfet L=0.6U W=1.32U AS=0.3432P AD=0.5808P
+ PS=1.84U PD=3.52U
* device instance $1048 r0 *1 61.405,137.085 nfet
M$1048 \$1121 A2|Z$9 VSS vsubs nfet L=0.6U W=1.32U AS=0.5808P AD=0.2112P
+ PS=3.52U PD=1.64U
* device instance $1049 r0 *1 62.325,137.085 nfet
M$1049 B1|ZN$4 A1|A2|ZN$10 \$1121 vsubs nfet L=0.6U W=1.32U AS=0.2112P
+ AD=0.5808P PS=1.64U PD=3.52U
* device instance $1050 r0 *1 70.925,137.085 nfet
M$1050 \$1122 A1|A2|ZN$10 VSS vsubs nfet L=0.6U W=1.32U AS=0.5808P AD=0.2112P
+ PS=3.52U PD=1.64U
* device instance $1051 r0 *1 71.845,137.085 nfet
M$1051 A2|ZN$62 A1|C|Z \$1122 vsubs nfet L=0.6U W=1.32U AS=0.2112P AD=0.5808P
+ PS=1.64U PD=3.52U
* device instance $1052 r0 *1 73.76,137.415 nfet
M$1052 \$1123 A2|ZN$62 \$1110 vsubs nfet L=0.6U W=0.66U AS=0.2904P AD=0.1056P
+ PS=2.2U PD=0.98U
* device instance $1053 r0 *1 74.68,137.415 nfet
M$1053 \$1123 A1|C|ZN VSS vsubs nfet L=0.6U W=0.66U AS=0.363P AD=0.1056P
+ PS=2.02U PD=0.98U
* device instance $1054 r0 *1 75.98,137.085 nfet
M$1054 \$1111 \$1110 VSS vsubs nfet L=0.6U W=1.32U AS=0.363P AD=0.3432P
+ PS=2.02U PD=1.84U
* device instance $1055 r0 *1 77.1,137.085 nfet
M$1055 A2|ZN$63 A1|C|ZN \$1111 vsubs nfet L=0.6U W=1.32U AS=0.3432P AD=0.3432P
+ PS=1.84U PD=1.84U
* device instance $1056 r0 *1 78.22,137.085 nfet
M$1056 \$1111 A2|ZN$62 A2|ZN$63 vsubs nfet L=0.6U W=1.32U AS=0.3432P AD=0.5808P
+ PS=1.84U PD=3.52U
* device instance $1057 r0 *1 86.42,137.085 nfet
M$1057 A2|ZN$61 A2|A3|ZN$6 \$1113 vsubs nfet L=0.6U W=1.32U AS=0.5808P
+ AD=0.3432P PS=3.52U PD=1.84U
* device instance $1058 r0 *1 87.54,137.085 nfet
M$1058 \$1113 A1|A2|Q A2|ZN$61 vsubs nfet L=0.6U W=1.32U AS=0.3432P AD=0.3432P
+ PS=1.84U PD=1.84U
* device instance $1059 r0 *1 88.66,137.085 nfet
M$1059 VSS \$1114 \$1113 vsubs nfet L=0.6U W=1.32U AS=0.3432P AD=0.363P
+ PS=1.84U PD=2.02U
* device instance $1060 r0 *1 89.96,137.415 nfet
M$1060 \$1124 A1|A2|Q VSS vsubs nfet L=0.6U W=0.66U AS=0.363P AD=0.1056P
+ PS=2.02U PD=0.98U
* device instance $1061 r0 *1 90.88,137.415 nfet
M$1061 \$1114 A2|A3|ZN$6 \$1124 vsubs nfet L=0.6U W=0.66U AS=0.1056P AD=0.2904P
+ PS=0.98U PD=2.2U
* device instance $1062 r0 *1 101.165,137.085 nfet
M$1062 \$1125 A1|A2|ZN$8 VSS vsubs nfet L=0.6U W=1.32U AS=0.5808P AD=0.2112P
+ PS=3.52U PD=1.64U
* device instance $1063 r0 *1 102.085,137.085 nfet
M$1063 B|C|ZN$1 A1|A3|I|Q \$1125 vsubs nfet L=0.6U W=1.32U AS=0.2112P
+ AD=0.5808P PS=1.64U PD=3.52U
* device instance $1064 r0 *1 111.84,137.415 nfet
M$1064 \$1126 A1|A2|ZN$4 \$1115 vsubs nfet L=0.6U W=0.66U AS=0.2904P AD=0.1056P
+ PS=2.2U PD=0.98U
* device instance $1065 r0 *1 112.76,137.415 nfet
M$1065 \$1126 A1|A3|B|Q VSS vsubs nfet L=0.6U W=0.66U AS=0.363P AD=0.1056P
+ PS=2.02U PD=0.98U
* device instance $1066 r0 *1 114.06,137.085 nfet
M$1066 \$1116 \$1115 VSS vsubs nfet L=0.6U W=1.32U AS=0.363P AD=0.3432P
+ PS=2.02U PD=1.84U
* device instance $1067 r0 *1 115.18,137.085 nfet
M$1067 A2|B|ZN$2 A1|A3|B|Q \$1116 vsubs nfet L=0.6U W=1.32U AS=0.3432P
+ AD=0.3432P PS=1.84U PD=1.84U
* device instance $1068 r0 *1 116.3,137.085 nfet
M$1068 \$1116 A1|A2|ZN$4 A2|B|ZN$2 vsubs nfet L=0.6U W=1.32U AS=0.3432P
+ AD=0.5808P PS=1.84U PD=3.52U
* device instance $1069 r0 *1 123,135.07 nfet
M$1069 \$1086 A2|B|ZN$2 VSS vsubs nfet L=0.6U W=0.36U AS=0.1584P AD=0.0936P
+ PS=1.6U PD=0.88U
* device instance $1070 r0 *1 124.12,135.07 nfet
M$1070 \$1086 A1|A2|ZN$9 VSS vsubs nfet L=0.6U W=0.36U AS=0.186P AD=0.0936P
+ PS=1.36U PD=0.88U
* device instance $1071 r0 *1 125.42,134.92 nfet
M$1071 \$1088 \$1086 VSS vsubs nfet L=0.6U W=0.66U AS=0.186P AD=0.1716P
+ PS=1.36U PD=1.18U
* device instance $1072 r0 *1 126.54,134.92 nfet
M$1072 \$1100 A1|A2|ZN$9 \$1088 vsubs nfet L=0.6U W=0.66U AS=0.1716P AD=0.1056P
+ PS=1.18U PD=0.98U
* device instance $1073 r0 *1 127.46,134.92 nfet
M$1073 VSS A2|B|ZN$2 \$1100 vsubs nfet L=0.6U W=0.66U AS=0.1056P AD=0.2904P
+ PS=0.98U PD=2.2U
* device instance $1074 r0 *1 124.54,137.285 nfet
M$1074 VSS A2|B|ZN$2 A2|ZN$59 vsubs nfet L=0.6U W=0.92U AS=0.402P AD=0.4048P
+ PS=2.02U PD=2.72U
* device instance $1075 r0 *1 125.84,137.085 nfet
M$1075 \$1120 A1|Z$9 A2|ZN$59 vsubs nfet L=0.6U W=1.32U AS=0.402P AD=0.2112P
+ PS=2.02U PD=1.64U
* device instance $1076 r0 *1 126.76,137.085 nfet
M$1076 VSS A2|A3|ZN$8 \$1120 vsubs nfet L=0.6U W=1.32U AS=0.2112P AD=0.5808P
+ PS=1.64U PD=3.52U
* device instance $1077 r0 *1 39.54,144.955 nfet
M$1077 VSS A1|B|ZN$2 B|ZN$21 vsubs nfet L=0.6U W=0.92U AS=0.402P AD=0.4048P
+ PS=2.02U PD=2.72U
* device instance $1078 r0 *1 37.32,145.155 nfet
M$1078 \$1159 A2|A3|Z$2 VSS vsubs nfet L=0.6U W=1.32U AS=0.5808P AD=0.2112P
+ PS=3.52U PD=1.64U
* device instance $1079 r0 *1 38.24,145.155 nfet
M$1079 B|ZN$21 A1|A2|ZN$4 \$1159 vsubs nfet L=0.6U W=1.32U AS=0.2112P AD=0.402P
+ PS=1.64U PD=2.02U
* device instance $1080 r0 *1 55.24,145.155 nfet
M$1080 B|ZN$19 A2|ZN$60 \$1152 vsubs nfet L=0.6U W=1.32U AS=0.5808P AD=0.3432P
+ PS=3.52U PD=1.84U
* device instance $1081 r0 *1 56.36,145.155 nfet
M$1081 \$1152 A1|ZN$24 B|ZN$19 vsubs nfet L=0.6U W=1.32U AS=0.3432P AD=0.363P
+ PS=1.84U PD=1.87U
* device instance $1082 r0 *1 57.51,145.155 nfet
M$1082 \$1160 A3|B|ZN$1 \$1152 vsubs nfet L=0.6U W=1.32U AS=0.363P AD=0.2442P
+ PS=1.87U PD=1.69U
* device instance $1083 r0 *1 58.48,145.155 nfet
M$1083 VSS A1|C|ZN \$1160 vsubs nfet L=0.6U W=1.32U AS=0.2442P AD=0.5808P
+ PS=1.69U PD=3.52U
* device instance $1084 r0 *1 75.4,144.825 nfet
M$1084 \$1157 A1|A2|ZN$4 VSS vsubs nfet L=0.6U W=0.66U AS=0.363P AD=0.1056P
+ PS=2.02U PD=0.98U
* device instance $1085 r0 *1 76.32,144.825 nfet
M$1085 \$1136 A2|ZN$61 \$1157 vsubs nfet L=0.6U W=0.66U AS=0.1056P AD=0.2904P
+ PS=0.98U PD=2.2U
* device instance $1086 r0 *1 71.86,145.155 nfet
M$1086 A1|C|ZN A2|ZN$61 \$1153 vsubs nfet L=0.6U W=1.32U AS=0.5808P AD=0.3432P
+ PS=3.52U PD=1.84U
* device instance $1087 r0 *1 72.98,145.155 nfet
M$1087 \$1153 A1|A2|ZN$4 A1|C|ZN vsubs nfet L=0.6U W=1.32U AS=0.3432P
+ AD=0.3432P PS=1.84U PD=1.84U
* device instance $1088 r0 *1 74.1,145.155 nfet
M$1088 VSS \$1136 \$1153 vsubs nfet L=0.6U W=1.32U AS=0.3432P AD=0.363P
+ PS=1.84U PD=2.02U
* device instance $1089 r0 *1 100.045,145.155 nfet
M$1089 \$1162 A1|A2|ZN$8 VSS vsubs nfet L=0.6U W=1.32U AS=0.5808P AD=0.2112P
+ PS=3.52U PD=1.64U
* device instance $1090 r0 *1 100.965,145.155 nfet
M$1090 B|ZN$20 A1|A2|Q \$1162 vsubs nfet L=0.6U W=1.32U AS=0.2112P AD=0.5808P
+ PS=1.64U PD=3.52U
* device instance $1091 r0 *1 112.5,145.1 nfet
M$1091 \$1155 \$1142 \$1143 vsubs nfet L=0.6U W=0.66U AS=0.2904P AD=0.1056P
+ PS=2.2U PD=0.98U
* device instance $1092 r0 *1 113.42,145.1 nfet
M$1092 \$1155 A3|ZN$4 VSS vsubs nfet L=0.6U W=0.66U AS=0.363P AD=0.1056P
+ PS=2.02U PD=0.98U
* device instance $1093 r0 *1 114.72,145.155 nfet
M$1093 \$1154 \$1143 VSS vsubs nfet L=0.6U W=1.32U AS=0.363P AD=0.3432P
+ PS=2.02U PD=1.84U
* device instance $1094 r0 *1 115.84,145.155 nfet
M$1094 A2|C|ZN A3|ZN$4 \$1154 vsubs nfet L=0.6U W=1.32U AS=0.3432P AD=0.3432P
+ PS=1.84U PD=1.84U
* device instance $1095 r0 *1 116.96,145.155 nfet
M$1095 \$1154 \$1142 A2|C|ZN vsubs nfet L=0.6U W=1.32U AS=0.3432P AD=0.5808P
+ PS=1.84U PD=3.52U
* device instance $1096 r0 *1 127.485,145.155 nfet
M$1096 \$1158 A2|A3|ZN$8 VSS vsubs nfet L=0.6U W=1.32U AS=0.5808P AD=0.2112P
+ PS=3.52U PD=1.64U
* device instance $1097 r0 *1 128.405,145.155 nfet
M$1097 A3|ZN$3 A1|Z$9 \$1158 vsubs nfet L=0.6U W=1.32U AS=0.2112P AD=0.5808P
+ PS=1.64U PD=3.52U
* device instance $1098 r0 *1 56.74,147.165 nfet
M$1098 A3|B|ZN$1 A2|ZN$65 \$1163 vsubs nfet L=0.6U W=1.32U AS=0.5808P
+ AD=0.3432P PS=3.52U PD=1.84U
* device instance $1099 r0 *1 57.86,147.165 nfet
M$1099 \$1163 A1|A2|ZN$4 A3|B|ZN$1 vsubs nfet L=0.6U W=1.32U AS=0.3432P
+ AD=0.3432P PS=1.84U PD=1.84U
* device instance $1100 r0 *1 58.98,147.165 nfet
M$1100 VSS \$1164 \$1163 vsubs nfet L=0.6U W=1.32U AS=0.3432P AD=0.363P
+ PS=1.84U PD=2.02U
* device instance $1101 r0 *1 60.28,147.495 nfet
M$1101 \$1171 A1|A2|ZN$4 VSS vsubs nfet L=0.6U W=0.66U AS=0.363P AD=0.1056P
+ PS=2.02U PD=0.98U
* device instance $1102 r0 *1 61.2,147.495 nfet
M$1102 \$1164 A2|ZN$65 \$1171 vsubs nfet L=0.6U W=0.66U AS=0.1056P AD=0.2904P
+ PS=0.98U PD=2.2U
* device instance $1103 r0 *1 69.855,146.835 nfet
M$1103 \$1166 A1|A2|ZN$8 VSS vsubs nfet L=0.6U W=0.66U AS=0.2904P AD=0.1716P
+ PS=2.2U PD=1.18U
* device instance $1104 r0 *1 70.975,146.835 nfet
M$1104 VSS A2|ZN$65 \$1166 vsubs nfet L=0.6U W=0.66U AS=0.1716P AD=0.3828P
+ PS=1.18U PD=2.08U
* device instance $1105 r0 *1 72.335,147.165 nfet
M$1105 A1|C|Z \$1166 VSS vsubs nfet L=0.6U W=1.32U AS=0.3828P AD=0.5808P
+ PS=2.08U PD=3.52U
* device instance $1106 r0 *1 89.8,145.03 nfet
M$1106 \$1139 A1|ZN$26 VSS vsubs nfet L=0.6U W=0.66U AS=0.363P AD=0.1716P
+ PS=2.02U PD=1.18U
* device instance $1107 r0 *1 90.92,145.03 nfet
M$1107 VSS A2|ZN$64 \$1139 vsubs nfet L=0.6U W=0.66U AS=0.1716P AD=0.2904P
+ PS=1.18U PD=2.2U
* device instance $1108 r0 *1 86.46,145.16 nfet
M$1108 \$1161 A2|ZN$64 VSS vsubs nfet L=0.6U W=1.32U AS=0.5808P AD=0.2112P
+ PS=3.52U PD=1.64U
* device instance $1109 r0 *1 87.38,145.16 nfet
M$1109 A2|Z$8 A1|ZN$26 \$1161 vsubs nfet L=0.6U W=1.32U AS=0.2112P AD=0.3432P
+ PS=1.64U PD=1.84U
* device instance $1110 r0 *1 88.5,145.16 nfet
M$1110 VSS \$1139 A2|Z$8 vsubs nfet L=0.6U W=1.32U AS=0.3432P AD=0.363P
+ PS=1.84U PD=2.02U
* device instance $1111 r0 *1 86.08,147.495 nfet
M$1111 \$1172 A1|A2|ZN$4 \$1167 vsubs nfet L=0.6U W=0.66U AS=0.2904P AD=0.1056P
+ PS=2.2U PD=0.98U
* device instance $1112 r0 *1 87,147.495 nfet
M$1112 \$1172 A1|ZN$23 VSS vsubs nfet L=0.6U W=0.66U AS=0.363P AD=0.1056P
+ PS=2.02U PD=0.98U
* device instance $1113 r0 *1 88.3,147.165 nfet
M$1113 \$1168 \$1167 VSS vsubs nfet L=0.6U W=1.32U AS=0.363P AD=0.3432P
+ PS=2.02U PD=1.84U
* device instance $1114 r0 *1 89.42,147.165 nfet
M$1114 A2|ZN$64 A1|ZN$23 \$1168 vsubs nfet L=0.6U W=1.32U AS=0.3432P AD=0.3432P
+ PS=1.84U PD=1.84U
* device instance $1115 r0 *1 90.54,147.165 nfet
M$1115 \$1168 A1|A2|ZN$4 A2|ZN$64 vsubs nfet L=0.6U W=1.32U AS=0.3432P
+ AD=0.5808P PS=1.84U PD=3.52U
* device instance $1116 r0 *1 99.48,147.165 nfet
M$1116 A3|ZN$4 A2|ZN$64 \$1169 vsubs nfet L=0.6U W=1.32U AS=0.5808P AD=0.3432P
+ PS=3.52U PD=1.84U
* device instance $1117 r0 *1 100.6,147.165 nfet
M$1117 \$1169 A1|ZN$26 A3|ZN$4 vsubs nfet L=0.6U W=1.32U AS=0.3432P AD=0.3432P
+ PS=1.84U PD=1.84U
* device instance $1118 r0 *1 101.72,147.165 nfet
M$1118 VSS B|C|ZN$1 \$1169 vsubs nfet L=0.6U W=1.32U AS=0.3432P AD=0.5808P
+ PS=1.84U PD=3.52U
* device instance $1119 r0 *1 106.2,145.25 nfet
M$1119 \$1140 A1|A2|ZN$8 VSS vsubs nfet L=0.6U W=0.36U AS=0.1584P AD=0.0936P
+ PS=1.6U PD=0.88U
* device instance $1120 r0 *1 107.32,145.25 nfet
M$1120 \$1140 A1|A2|Q VSS vsubs nfet L=0.6U W=0.36U AS=0.186P AD=0.0936P
+ PS=1.36U PD=0.88U
* device instance $1121 r0 *1 108.62,145.1 nfet
M$1121 \$1142 \$1140 VSS vsubs nfet L=0.6U W=0.66U AS=0.186P AD=0.1716P
+ PS=1.36U PD=1.18U
* device instance $1122 r0 *1 109.74,145.1 nfet
M$1122 \$1156 A1|A2|Q \$1142 vsubs nfet L=0.6U W=0.66U AS=0.1716P AD=0.1056P
+ PS=1.18U PD=0.98U
* device instance $1123 r0 *1 110.66,145.1 nfet
M$1123 VSS A1|A2|ZN$8 \$1156 vsubs nfet L=0.6U W=0.66U AS=0.1056P AD=0.2904P
+ PS=0.98U PD=2.2U
* device instance $1124 r0 *1 123.055,145.485 nfet
M$1124 \$1144 A1|A2|Q VSS vsubs nfet L=0.6U W=0.66U AS=0.2904P AD=0.1716P
+ PS=2.2U PD=1.18U
* device instance $1125 r0 *1 124.175,145.485 nfet
M$1125 \$1144 A1|A2|ZN$8 VSS vsubs nfet L=0.6U W=0.66U AS=0.3828P AD=0.1716P
+ PS=2.08U PD=1.18U
* device instance $1126 r0 *1 125.535,145.155 nfet
M$1126 A1|Z$9 \$1144 VSS vsubs nfet L=0.6U W=1.32U AS=0.3828P AD=0.5808P
+ PS=2.08U PD=3.52U
* device instance $1127 r0 *1 126.36,147.495 nfet
M$1127 \$1174 A1|Z$9 \$1170 vsubs nfet L=0.6U W=0.66U AS=0.2904P AD=0.1056P
+ PS=2.2U PD=0.98U
* device instance $1128 r0 *1 127.28,147.495 nfet
M$1128 \$1173 A2|B|ZN$2 \$1174 vsubs nfet L=0.6U W=0.66U AS=0.1056P AD=0.1386P
+ PS=0.98U PD=1.08U
* device instance $1129 r0 *1 128.3,147.495 nfet
M$1129 \$1173 A2|A3|ZN$8 VSS vsubs nfet L=0.6U W=0.66U AS=0.4158P AD=0.1386P
+ PS=2.18U PD=1.08U
* device instance $1130 r0 *1 129.76,147.165 nfet
M$1130 A1|B|Z$3 \$1170 VSS vsubs nfet L=0.6U W=1.32U AS=0.4158P AD=0.5808P
+ PS=2.18U PD=3.52U
* device instance $1131 r0 *1 54.17,8.595 pfet
M$1131 VDD CLK|clk \$20 \$19 pfet L=0.5U W=1.38U AS=0.6072P AD=0.3588P PS=3.64U
+ PD=1.9U
* device instance $1132 r0 *1 55.19,8.595 pfet
M$1132 \$14 \$20 VDD \$19 pfet L=0.5U W=1.38U AS=0.3588P AD=0.6072P PS=1.9U
+ PD=3.64U
* device instance $1133 r0 *1 57.23,8.405 pfet
M$1133 \$33 \$14 VDD \$19 pfet L=0.5U W=1U AS=0.9696P AD=0.12P PS=5.04U PD=1.24U
* device instance $1134 r0 *1 57.97,8.405 pfet
M$1134 \$22 D|ZN \$33 \$19 pfet L=0.5U W=1U AS=0.12P AD=0.4P PS=1.24U PD=1.8U
* device instance $1135 r0 *1 59.27,8.405 pfet
M$1135 \$34 \$20 \$22 \$19 pfet L=0.5U W=1U AS=0.4P AD=0.12P PS=1.8U PD=1.24U
* device instance $1136 r0 *1 60.01,8.405 pfet
M$1136 VDD \$15 \$34 \$19 pfet L=0.5U W=1U AS=0.12P AD=0.26P PS=1.24U PD=1.52U
* device instance $1137 r0 *1 61.03,8.405 pfet
M$1137 \$15 \$22 VDD \$19 pfet L=0.5U W=1U AS=0.26P AD=0.26P PS=1.52U PD=1.52U
* device instance $1138 r0 *1 62.05,8.405 pfet
M$1138 \$23 \$20 \$15 \$19 pfet L=0.5U W=1U AS=0.26P AD=0.6P PS=1.52U PD=2.2U
* device instance $1139 r0 *1 63.75,8.405 pfet
M$1139 \$35 \$14 \$23 \$19 pfet L=0.5U W=1U AS=0.6P AD=0.13P PS=2.2U PD=1.26U
* device instance $1140 r0 *1 64.51,8.405 pfet
M$1140 VDD \$16 \$35 \$19 pfet L=0.5U W=1U AS=0.13P AD=0.442P PS=1.26U PD=1.94U
* device instance $1141 r0 *1 65.85,8.455 pfet
M$1141 \$16 \$23 VDD \$19 pfet L=0.5U W=1.1U AS=0.442P AD=0.484P PS=1.94U
+ PD=3.08U
* device instance $1142 r0 *1 67.59,8.82 pfet
M$1142 Q|tmds[8] \$16 VDD \$19 pfet L=0.5U W=1.83U AS=0.8052P AD=0.8052P
+ PS=4.54U PD=4.54U
* device instance $1143 r0 *1 87.67,8.82 pfet
M$1143 B1|ZN A2|ctrl[1] \$32 \$19 pfet L=0.5U W=1.83U AS=0.8052P AD=0.4758P
+ PS=4.54U PD=2.35U
* device instance $1144 r0 *1 88.69,8.82 pfet
M$1144 \$32 A1|ctrl[0] B1|ZN \$19 pfet L=0.5U W=1.83U AS=0.4758P AD=0.6405P
+ PS=2.35U PD=2.53U
* device instance $1145 r0 *1 89.89,8.82 pfet
M$1145 VDD B|ZN \$32 \$19 pfet L=0.5U W=1.83U AS=0.6405P AD=0.8052P PS=2.53U
+ PD=4.54U
* device instance $1146 r0 *1 121.83,8.82 pfet
M$1146 A1|ZN I|data[4] VDD \$19 pfet L=0.5U W=1.83U AS=0.8052P AD=0.8052P
+ PS=4.54U PD=4.54U
* device instance $1147 r0 *1 14.76,11.34 pfet
M$1147 \$68 A1|A2|A3|data[2] A2|ZN \$19 pfet L=0.5U W=1.83U AS=0.8052P
+ AD=0.5673P PS=4.54U PD=2.45U
* device instance $1148 r0 *1 15.88,11.34 pfet
M$1148 VDD A1|A2|Z \$68 \$19 pfet L=0.5U W=1.83U AS=0.5673P AD=0.8052P PS=2.45U
+ PD=4.54U
* device instance $1149 r0 *1 22.81,11.7975 pfet
M$1149 \$69 A1|A2|I|data[0] \$44 \$19 pfet L=0.5U W=0.915U AS=0.4026P
+ AD=0.260775P PS=2.71U PD=1.485U
* device instance $1150 r0 *1 23.88,11.7975 pfet
M$1150 \$69 A1|data[1] VDD \$19 pfet L=0.5U W=0.915U AS=0.549P AD=0.260775P
+ PS=2.63U PD=1.485U
* device instance $1151 r0 *1 25.18,11.34 pfet
M$1151 \$38 \$44 VDD \$19 pfet L=0.5U W=1.83U AS=0.549P AD=0.52155P PS=2.63U
+ PD=2.4U
* device instance $1152 r0 *1 26.25,11.34 pfet
M$1152 A1|A2|Z A1|data[1] \$38 \$19 pfet L=0.5U W=1.83U AS=0.52155P AD=0.4758P
+ PS=2.4U PD=2.35U
* device instance $1153 r0 *1 27.27,11.34 pfet
M$1153 \$38 A1|A2|I|data[0] A1|A2|Z \$19 pfet L=0.5U W=1.83U AS=0.4758P
+ AD=0.8052P PS=2.35U PD=4.54U
* device instance $1154 r0 *1 46.31,11.34 pfet
M$1154 Q|tmds[0] \$52 VDD \$19 pfet L=0.5U W=1.83U AS=0.8052P AD=0.8052P
+ PS=4.54U PD=4.54U
* device instance $1155 r0 *1 81.03,11.34 pfet
M$1155 Q|tmds[2] \$57 VDD \$19 pfet L=0.5U W=1.83U AS=0.8052P AD=0.8052P
+ PS=4.54U PD=4.54U
* device instance $1156 r0 *1 87.67,11.34 pfet
M$1156 A2|B|ZN I|rst VDD \$19 pfet L=0.5U W=1.83U AS=0.8052P AD=0.8052P
+ PS=4.54U PD=4.54U
* device instance $1157 r0 *1 92.23,11.2475 pfet
M$1157 VDD A2|B|ZN B|ZN \$19 pfet L=0.5U W=1.645U AS=0.61275P AD=0.7238P
+ PS=2.53U PD=4.17U
* device instance $1158 r0 *1 89.96,11.34 pfet
M$1158 \$80 A2|ctrl[1] VDD \$19 pfet L=0.5U W=1.83U AS=0.8052P AD=0.52155P
+ PS=4.54U PD=2.4U
* device instance $1159 r0 *1 91.03,11.34 pfet
M$1159 B|ZN A1|ctrl[0] \$80 \$19 pfet L=0.5U W=1.83U AS=0.52155P AD=0.61275P
+ PS=2.4U PD=2.53U
* device instance $1160 r0 *1 101.53,11.34 pfet
M$1160 VDD \$58 Q|tmds[4] \$19 pfet L=0.5U W=1.83U AS=0.8052P AD=0.8052P
+ PS=4.54U PD=4.54U
* device instance $1161 r0 *1 127.095,11.7925 pfet
M$1161 \$70 \$65 \$66 \$19 pfet L=0.5U W=0.915U AS=0.4026P AD=0.2447625P
+ PS=2.71U PD=1.45U
* device instance $1162 r0 *1 128.13,11.7925 pfet
M$1162 \$70 A1|A2|A3|data[2] VDD \$19 pfet L=0.5U W=0.915U AS=0.571875P
+ AD=0.2447625P PS=2.68U PD=1.45U
* device instance $1163 r0 *1 129.48,11.335 pfet
M$1163 \$43 \$66 VDD \$19 pfet L=0.5U W=1.83U AS=0.571875P AD=0.52155P PS=2.68U
+ PD=2.4U
* device instance $1164 r0 *1 130.55,11.335 pfet
M$1164 A2|A3|Z A1|A2|A3|data[2] \$43 \$19 pfet L=0.5U W=1.83U AS=0.52155P
+ AD=0.4758P PS=2.4U PD=2.35U
* device instance $1165 r0 *1 131.57,11.335 pfet
M$1165 \$43 \$65 A2|A3|Z \$19 pfet L=0.5U W=1.83U AS=0.4758P AD=1.3176P
+ PS=2.35U PD=5.1U
* device instance $1166 r0 *1 32.89,11.565 pfet
M$1166 VDD CLK|clk \$39 \$19 pfet L=0.5U W=1.38U AS=0.6072P AD=0.3588P PS=3.64U
+ PD=1.9U
* device instance $1167 r0 *1 33.91,11.565 pfet
M$1167 \$47 \$39 VDD \$19 pfet L=0.5U W=1.38U AS=0.3588P AD=0.6072P PS=1.9U
+ PD=3.64U
* device instance $1168 r0 *1 35.95,11.755 pfet
M$1168 \$71 \$47 VDD \$19 pfet L=0.5U W=1U AS=0.9696P AD=0.12P PS=5.04U PD=1.24U
* device instance $1169 r0 *1 36.69,11.755 pfet
M$1169 \$49 D|ZN$1 \$71 \$19 pfet L=0.5U W=1U AS=0.12P AD=0.4P PS=1.24U PD=1.8U
* device instance $1170 r0 *1 37.99,11.755 pfet
M$1170 \$72 \$39 \$49 \$19 pfet L=0.5U W=1U AS=0.4P AD=0.12P PS=1.8U PD=1.24U
* device instance $1171 r0 *1 38.73,11.755 pfet
M$1171 VDD \$50 \$72 \$19 pfet L=0.5U W=1U AS=0.12P AD=0.26P PS=1.24U PD=1.52U
* device instance $1172 r0 *1 39.75,11.755 pfet
M$1172 \$50 \$49 VDD \$19 pfet L=0.5U W=1U AS=0.26P AD=0.26P PS=1.52U PD=1.52U
* device instance $1173 r0 *1 40.77,11.755 pfet
M$1173 \$51 \$39 \$50 \$19 pfet L=0.5U W=1U AS=0.26P AD=0.6P PS=1.52U PD=2.2U
* device instance $1174 r0 *1 42.47,11.755 pfet
M$1174 \$73 \$47 \$51 \$19 pfet L=0.5U W=1U AS=0.6P AD=0.13P PS=2.2U PD=1.26U
* device instance $1175 r0 *1 43.23,11.755 pfet
M$1175 \$73 \$52 VDD \$19 pfet L=0.5U W=1U AS=0.442P AD=0.13P PS=1.94U PD=1.26U
* device instance $1176 r0 *1 44.57,11.705 pfet
M$1176 \$52 \$51 VDD \$19 pfet L=0.5U W=1.1U AS=0.442P AD=0.484P PS=1.94U
+ PD=3.08U
* device instance $1177 r0 *1 67.61,11.565 pfet
M$1177 VDD CLK|clk \$40 \$19 pfet L=0.5U W=1.38U AS=0.6072P AD=0.3588P PS=3.64U
+ PD=1.9U
* device instance $1178 r0 *1 68.63,11.565 pfet
M$1178 \$53 \$40 VDD \$19 pfet L=0.5U W=1.38U AS=0.3588P AD=0.6072P PS=1.9U
+ PD=3.64U
* device instance $1179 r0 *1 70.67,11.755 pfet
M$1179 \$75 \$53 VDD \$19 pfet L=0.5U W=1U AS=0.9696P AD=0.12P PS=5.04U PD=1.24U
* device instance $1180 r0 *1 71.41,11.755 pfet
M$1180 \$54 D|ZN$3 \$75 \$19 pfet L=0.5U W=1U AS=0.12P AD=0.4P PS=1.24U PD=1.8U
* device instance $1181 r0 *1 72.71,11.755 pfet
M$1181 \$76 \$40 \$54 \$19 pfet L=0.5U W=1U AS=0.4P AD=0.12P PS=1.8U PD=1.24U
* device instance $1182 r0 *1 73.45,11.755 pfet
M$1182 VDD \$55 \$76 \$19 pfet L=0.5U W=1U AS=0.12P AD=0.26P PS=1.24U PD=1.52U
* device instance $1183 r0 *1 74.47,11.755 pfet
M$1183 \$55 \$54 VDD \$19 pfet L=0.5U W=1U AS=0.26P AD=0.26P PS=1.52U PD=1.52U
* device instance $1184 r0 *1 75.49,11.755 pfet
M$1184 \$56 \$40 \$55 \$19 pfet L=0.5U W=1U AS=0.26P AD=0.6P PS=1.52U PD=2.2U
* device instance $1185 r0 *1 77.19,11.755 pfet
M$1185 \$77 \$53 \$56 \$19 pfet L=0.5U W=1U AS=0.6P AD=0.13P PS=2.2U PD=1.26U
* device instance $1186 r0 *1 77.95,11.755 pfet
M$1186 \$77 \$57 VDD \$19 pfet L=0.5U W=1U AS=0.442P AD=0.13P PS=1.94U PD=1.26U
* device instance $1187 r0 *1 79.29,11.705 pfet
M$1187 \$57 \$56 VDD \$19 pfet L=0.5U W=1.1U AS=0.442P AD=0.484P PS=1.94U
+ PD=3.08U
* device instance $1188 r0 *1 103.27,11.705 pfet
M$1188 VDD \$59 \$58 \$19 pfet L=0.5U W=1.1U AS=0.484P AD=0.442P PS=3.08U
+ PD=1.94U
* device instance $1189 r0 *1 104.61,11.755 pfet
M$1189 \$81 \$58 VDD \$19 pfet L=0.5U W=1U AS=0.442P AD=0.13P PS=1.94U PD=1.26U
* device instance $1190 r0 *1 105.37,11.755 pfet
M$1190 \$59 \$60 \$81 \$19 pfet L=0.5U W=1U AS=0.13P AD=0.6P PS=1.26U PD=2.2U
* device instance $1191 r0 *1 107.07,11.755 pfet
M$1191 \$61 \$42 \$59 \$19 pfet L=0.5U W=1U AS=0.6P AD=0.26P PS=2.2U PD=1.52U
* device instance $1192 r0 *1 108.09,11.755 pfet
M$1192 VDD \$62 \$61 \$19 pfet L=0.5U W=1U AS=0.26P AD=0.26P PS=1.52U PD=1.52U
* device instance $1193 r0 *1 109.11,11.755 pfet
M$1193 \$79 \$61 VDD \$19 pfet L=0.5U W=1U AS=0.26P AD=0.12P PS=1.52U PD=1.24U
* device instance $1194 r0 *1 109.85,11.755 pfet
M$1194 \$62 \$42 \$79 \$19 pfet L=0.5U W=1U AS=0.12P AD=0.4P PS=1.24U PD=1.8U
* device instance $1195 r0 *1 111.15,11.755 pfet
M$1195 \$78 D|ZN$2 \$62 \$19 pfet L=0.5U W=1U AS=0.4P AD=0.12P PS=1.8U PD=1.24U
* device instance $1196 r0 *1 111.89,11.755 pfet
M$1196 \$78 \$60 VDD \$19 pfet L=0.5U W=1U AS=0.9696P AD=0.12P PS=5.04U PD=1.24U
* device instance $1197 r0 *1 113.93,11.565 pfet
M$1197 VDD \$42 \$60 \$19 pfet L=0.5U W=1.38U AS=0.6072P AD=0.3588P PS=3.64U
+ PD=1.9U
* device instance $1198 r0 *1 114.95,11.565 pfet
M$1198 \$42 CLK|clk VDD \$19 pfet L=0.5U W=1.38U AS=0.3588P AD=0.6072P PS=1.9U
+ PD=3.64U
* device instance $1199 r0 *1 120.81,11.6625 pfet
M$1199 \$74 A1|A2|I|data[0] \$83 \$19 pfet L=0.5U W=0.495U AS=0.2178P
+ AD=0.1287P PS=1.87U PD=1.015U
* device instance $1200 r0 *1 121.83,11.6625 pfet
M$1200 \$74 A1|data[1] VDD \$19 pfet L=0.5U W=0.495U AS=0.294375P AD=0.1287P
+ PS=1.765U PD=1.015U
* device instance $1201 r0 *1 123.18,11.4525 pfet
M$1201 \$64 \$83 VDD \$19 pfet L=0.5U W=0.915U AS=0.294375P AD=0.260775P
+ PS=1.765U PD=1.485U
* device instance $1202 r0 *1 124.25,11.4525 pfet
M$1202 \$65 A1|data[1] \$64 \$19 pfet L=0.5U W=0.915U AS=0.260775P AD=0.2379P
+ PS=1.485U PD=1.435U
* device instance $1203 r0 *1 125.27,11.4525 pfet
M$1203 \$64 A1|A2|I|data[0] \$65 \$19 pfet L=0.5U W=0.915U AS=0.2379P
+ AD=0.4026P PS=1.435U PD=2.71U
* device instance $1204 r0 *1 24.99,18.9825 pfet
M$1204 \$101 A2|ZN$1 VDD \$117 pfet L=0.5U W=0.915U AS=0.4026P AD=0.2379P
+ PS=2.71U PD=1.435U
* device instance $1205 r0 *1 26.01,18.9825 pfet
M$1205 \$101 A1|Z$1 VDD \$117 pfet L=0.5U W=0.915U AS=0.526125P AD=0.2379P
+ PS=2.58U PD=1.435U
* device instance $1206 r0 *1 27.26,18.9 pfet
M$1206 A2|ZN$4 \$101 VDD \$117 pfet L=0.5U W=1.83U AS=0.526125P AD=0.5673P
+ PS=2.58U PD=2.45U
* device instance $1207 r0 *1 28.38,18.9 pfet
M$1207 \$154 A1|Z$1 A2|ZN$4 \$117 pfet L=0.5U W=1.83U AS=0.5673P AD=0.52155P
+ PS=2.45U PD=2.4U
* device instance $1208 r0 *1 29.45,18.9 pfet
M$1208 VDD A2|ZN$1 \$154 \$117 pfet L=0.5U W=1.83U AS=0.52155P AD=0.8052P
+ PS=2.4U PD=4.54U
* device instance $1209 r0 *1 35.03,18.9 pfet
M$1209 D|ZN$1 A2|ZN$5 \$143 \$117 pfet L=0.5U W=1.83U AS=0.8052P AD=0.4758P
+ PS=4.54U PD=2.35U
* device instance $1210 r0 *1 36.05,18.9 pfet
M$1210 \$143 A1|A2|C|I|de D|ZN$1 \$117 pfet L=0.5U W=1.83U AS=0.4758P
+ AD=0.6405P PS=2.35U PD=2.53U
* device instance $1211 r0 *1 37.25,18.9 pfet
M$1211 VDD B|ZN$1 \$143 \$117 pfet L=0.5U W=1.83U AS=0.6405P AD=0.8052P
+ PS=2.53U PD=4.54U
* device instance $1212 r0 *1 42.97,18.675 pfet
M$1212 VDD CLK|clk \$120 \$117 pfet L=0.5U W=1.38U AS=0.6072P AD=0.3588P
+ PS=3.64U PD=1.9U
* device instance $1213 r0 *1 43.99,18.675 pfet
M$1213 \$104 \$120 VDD \$117 pfet L=0.5U W=1.38U AS=0.3588P AD=0.6072P PS=1.9U
+ PD=3.64U
* device instance $1214 r0 *1 46.03,18.485 pfet
M$1214 \$147 \$104 VDD \$117 pfet L=0.5U W=1U AS=0.9696P AD=0.12P PS=5.04U
+ PD=1.24U
* device instance $1215 r0 *1 46.77,18.485 pfet
M$1215 \$122 D|ZN$4 \$147 \$117 pfet L=0.5U W=1U AS=0.12P AD=0.4P PS=1.24U
+ PD=1.8U
* device instance $1216 r0 *1 48.07,18.485 pfet
M$1216 \$149 \$120 \$122 \$117 pfet L=0.5U W=1U AS=0.4P AD=0.12P PS=1.8U
+ PD=1.24U
* device instance $1217 r0 *1 48.81,18.485 pfet
M$1217 VDD \$105 \$149 \$117 pfet L=0.5U W=1U AS=0.12P AD=0.26P PS=1.24U
+ PD=1.52U
* device instance $1218 r0 *1 49.83,18.485 pfet
M$1218 \$105 \$122 VDD \$117 pfet L=0.5U W=1U AS=0.26P AD=0.26P PS=1.52U
+ PD=1.52U
* device instance $1219 r0 *1 50.85,18.485 pfet
M$1219 \$123 \$120 \$105 \$117 pfet L=0.5U W=1U AS=0.26P AD=0.6P PS=1.52U
+ PD=2.2U
* device instance $1220 r0 *1 52.55,18.485 pfet
M$1220 \$150 \$104 \$123 \$117 pfet L=0.5U W=1U AS=0.6P AD=0.13P PS=2.2U
+ PD=1.26U
* device instance $1221 r0 *1 53.31,18.485 pfet
M$1221 VDD \$106 \$150 \$117 pfet L=0.5U W=1U AS=0.13P AD=0.442P PS=1.26U
+ PD=1.94U
* device instance $1222 r0 *1 54.65,18.535 pfet
M$1222 \$106 \$123 VDD \$117 pfet L=0.5U W=1.1U AS=0.442P AD=0.484P PS=1.94U
+ PD=3.08U
* device instance $1223 r0 *1 56.39,18.9 pfet
M$1223 Q|tmds[1] \$106 VDD \$117 pfet L=0.5U W=1.83U AS=0.8052P AD=0.8052P
+ PS=4.54U PD=4.54U
* device instance $1224 r0 *1 62.52,18.9 pfet
M$1224 \$155 A2|ZN$4 VDD \$117 pfet L=0.5U W=1.83U AS=0.8052P AD=0.52155P
+ PS=4.54U PD=2.4U
* device instance $1225 r0 *1 63.59,18.9 pfet
M$1225 D|ZN$3 A1|B|ZN \$155 \$117 pfet L=0.5U W=1.83U AS=0.52155P AD=0.61275P
+ PS=2.4U PD=2.53U
* device instance $1226 r0 *1 64.79,18.9925 pfet
M$1226 VDD A1|B|ZN$1 D|ZN$3 \$117 pfet L=0.5U W=1.645U AS=0.61275P AD=0.7238P
+ PS=2.53U PD=4.17U
* device instance $1227 r0 *1 88.28,18.9 pfet
M$1227 \$156 A1|A2|C|I|de VDD \$117 pfet L=0.5U W=1.83U AS=0.8052P AD=0.52155P
+ PS=4.54U PD=2.4U
* device instance $1228 r0 *1 89.35,18.9 pfet
M$1228 B|ZN$1 A1|ctrl[0] \$156 \$117 pfet L=0.5U W=1.83U AS=0.52155P
+ AD=0.61275P PS=2.4U PD=2.53U
* device instance $1229 r0 *1 90.55,18.9925 pfet
M$1229 VDD A2|B|ZN B|ZN$1 \$117 pfet L=0.5U W=1.645U AS=0.61275P AD=0.7238P
+ PS=2.53U PD=4.17U
* device instance $1230 r0 *1 93.275,18.8075 pfet
M$1230 A2|ZN$2 A2|B|ZN VDD \$117 pfet L=0.5U W=1.645U AS=0.7238P AD=0.4277P
+ PS=4.17U PD=2.165U
* device instance $1231 r0 *1 94.295,18.8075 pfet
M$1231 VDD A1|ctrl[0] A2|ZN$2 \$117 pfet L=0.5U W=1.645U AS=0.4277P AD=0.7238P
+ PS=2.165U PD=4.17U
* device instance $1232 r0 *1 107.13,18.9 pfet
M$1232 VDD \$110 Q|tmds[6] \$117 pfet L=0.5U W=1.83U AS=0.8052P AD=0.8052P
+ PS=4.54U PD=4.54U
* device instance $1233 r0 *1 110.21,18.485 pfet
M$1233 \$148 \$110 VDD \$117 pfet L=0.5U W=1U AS=0.442P AD=0.13P PS=1.94U
+ PD=1.26U
* device instance $1234 r0 *1 110.97,18.485 pfet
M$1234 \$111 \$112 \$148 \$117 pfet L=0.5U W=1U AS=0.13P AD=0.6P PS=1.26U
+ PD=2.2U
* device instance $1235 r0 *1 112.67,18.485 pfet
M$1235 \$125 \$114 \$111 \$117 pfet L=0.5U W=1U AS=0.6P AD=0.26P PS=2.2U
+ PD=1.52U
* device instance $1236 r0 *1 113.69,18.485 pfet
M$1236 VDD \$113 \$125 \$117 pfet L=0.5U W=1U AS=0.26P AD=0.26P PS=1.52U
+ PD=1.52U
* device instance $1237 r0 *1 114.71,18.485 pfet
M$1237 \$146 \$125 VDD \$117 pfet L=0.5U W=1U AS=0.26P AD=0.12P PS=1.52U
+ PD=1.24U
* device instance $1238 r0 *1 115.45,18.485 pfet
M$1238 \$113 \$114 \$146 \$117 pfet L=0.5U W=1U AS=0.12P AD=0.4P PS=1.24U
+ PD=1.8U
* device instance $1239 r0 *1 116.75,18.485 pfet
M$1239 \$145 D|ZN$5 \$113 \$117 pfet L=0.5U W=1U AS=0.4P AD=0.12P PS=1.8U
+ PD=1.24U
* device instance $1240 r0 *1 117.49,18.485 pfet
M$1240 VDD \$112 \$145 \$117 pfet L=0.5U W=1U AS=0.12P AD=0.9696P PS=1.24U
+ PD=5.04U
* device instance $1241 r0 *1 108.87,18.535 pfet
M$1241 VDD \$111 \$110 \$117 pfet L=0.5U W=1.1U AS=0.484P AD=0.442P PS=3.08U
+ PD=1.94U
* device instance $1242 r0 *1 119.53,18.675 pfet
M$1242 VDD \$114 \$112 \$117 pfet L=0.5U W=1.38U AS=0.6072P AD=0.3588P PS=3.64U
+ PD=1.9U
* device instance $1243 r0 *1 120.55,18.675 pfet
M$1243 \$114 CLK|clk VDD \$117 pfet L=0.5U W=1.38U AS=0.3588P AD=0.6072P
+ PS=1.9U PD=3.64U
* device instance $1244 r0 *1 125.19,18.9 pfet
M$1244 A2|ZN$3 A1|A2|Z \$144 \$117 pfet L=0.5U W=1.83U AS=0.8052P AD=0.4758P
+ PS=4.54U PD=2.35U
* device instance $1245 r0 *1 126.21,18.9 pfet
M$1245 \$144 A1|A2|A3|data[2] A2|ZN$3 \$117 pfet L=0.5U W=1.83U AS=0.4758P
+ AD=0.6405P PS=2.35U PD=2.53U
* device instance $1246 r0 *1 127.41,18.9 pfet
M$1246 VDD A3|B|Z \$144 \$117 pfet L=0.5U W=1.83U AS=0.6405P AD=0.8052P
+ PS=2.53U PD=4.54U
* device instance $1247 r0 *1 140.315,18.8075 pfet
M$1247 A1|ZN$1 A2|ZN$3 VDD \$117 pfet L=0.5U W=1.645U AS=0.7238P AD=0.4277P
+ PS=4.17U PD=2.165U
* device instance $1248 r0 *1 141.335,18.8075 pfet
M$1248 VDD A1|ZN$2 A1|ZN$1 \$117 pfet L=0.5U W=1.645U AS=0.4277P AD=0.7238P
+ PS=2.165U PD=4.17U
* device instance $1249 r0 *1 12.07,19.405 pfet
M$1249 \$118 A1|A2|A3|data[2] VDD \$117 pfet L=0.5U W=0.82U AS=0.3608P
+ AD=0.2132P PS=2.52U PD=1.34U
* device instance $1250 r0 *1 13.09,19.405 pfet
M$1250 \$118 A1|A2|Z VDD \$117 pfet L=0.5U W=0.82U AS=0.5054P AD=0.2132P
+ PS=2.57U PD=1.34U
* device instance $1251 r0 *1 14.33,18.9 pfet
M$1251 A1|Z \$118 VDD \$117 pfet L=0.5U W=1.83U AS=0.5054P AD=0.8052P PS=2.57U
+ PD=4.54U
* device instance $1252 r0 *1 13.29,21.8775 pfet
M$1252 \$176 A1|A2|A3|ZN \$157 \$117 pfet L=0.5U W=0.915U AS=0.4026P
+ AD=0.260775P PS=2.71U PD=1.485U
* device instance $1253 r0 *1 14.36,21.8775 pfet
M$1253 \$176 A1|A2|Z VDD \$117 pfet L=0.5U W=0.915U AS=0.549P AD=0.260775P
+ PS=2.63U PD=1.485U
* device instance $1254 r0 *1 15.66,21.42 pfet
M$1254 \$158 \$157 VDD \$117 pfet L=0.5U W=1.83U AS=0.549P AD=0.52155P PS=2.63U
+ PD=2.4U
* device instance $1255 r0 *1 16.73,21.42 pfet
M$1255 A1|B1|Z A1|A2|Z \$158 \$117 pfet L=0.5U W=1.83U AS=0.52155P AD=0.4758P
+ PS=2.4U PD=2.35U
* device instance $1256 r0 *1 17.75,21.42 pfet
M$1256 \$158 A1|A2|A3|ZN A1|B1|Z \$117 pfet L=0.5U W=1.83U AS=0.4758P
+ AD=0.8052P PS=2.35U PD=4.54U
* device instance $1257 r0 *1 16.705,19.3575 pfet
M$1257 \$153 A1|Z \$99 \$117 pfet L=0.5U W=0.915U AS=0.4026P AD=0.2379P
+ PS=2.71U PD=1.435U
* device instance $1258 r0 *1 17.725,19.3575 pfet
M$1258 \$153 A2|ZN VDD \$117 pfet L=0.5U W=0.915U AS=0.57645P AD=0.2379P
+ PS=2.69U PD=1.435U
* device instance $1259 r0 *1 19.085,18.9 pfet
M$1259 A1|Z$1 \$99 VDD \$117 pfet L=0.5U W=1.83U AS=0.57645P AD=0.8052P
+ PS=2.69U PD=4.54U
* device instance $1260 r0 *1 26.67,21.3375 pfet
M$1260 \$159 A2|ZN$1 VDD \$117 pfet L=0.5U W=0.915U AS=0.4026P AD=0.2379P
+ PS=2.71U PD=1.435U
* device instance $1261 r0 *1 27.69,21.3375 pfet
M$1261 \$159 A1|B2|ZN VDD \$117 pfet L=0.5U W=0.915U AS=0.526125P AD=0.2379P
+ PS=2.58U PD=1.435U
* device instance $1262 r0 *1 28.94,21.42 pfet
M$1262 A2|ZN$5 \$159 VDD \$117 pfet L=0.5U W=1.83U AS=0.526125P AD=0.5673P
+ PS=2.58U PD=2.45U
* device instance $1263 r0 *1 30.06,21.42 pfet
M$1263 \$177 A1|B2|ZN A2|ZN$5 \$117 pfet L=0.5U W=1.83U AS=0.5673P AD=0.52155P
+ PS=2.45U PD=2.4U
* device instance $1264 r0 *1 31.13,21.42 pfet
M$1264 VDD A2|ZN$1 \$177 \$117 pfet L=0.5U W=1.83U AS=0.52155P AD=0.8052P
+ PS=2.4U PD=4.54U
* device instance $1265 r0 *1 41.19,21.42 pfet
M$1265 D|ZN$4 A2|ZN$8 \$161 \$117 pfet L=0.5U W=1.83U AS=0.8052P AD=0.4758P
+ PS=4.54U PD=2.35U
* device instance $1266 r0 *1 42.21,21.42 pfet
M$1266 \$161 A1|A2|C|I|de D|ZN$4 \$117 pfet L=0.5U W=1.83U AS=0.4758P
+ AD=0.6405P PS=2.35U PD=2.53U
* device instance $1267 r0 *1 43.41,21.42 pfet
M$1267 VDD B|ZN$1 \$161 \$117 pfet L=0.5U W=1.83U AS=0.6405P AD=0.8052P
+ PS=2.53U PD=4.54U
* device instance $1268 r0 *1 62.55,21.3275 pfet
M$1268 VDD A1|B|ZN$1 D|ZN \$117 pfet L=0.5U W=1.645U AS=0.61275P AD=0.7238P
+ PS=2.53U PD=4.17U
* device instance $1269 r0 *1 60.28,21.42 pfet
M$1269 \$178 A1|A2|B|ZN VDD \$117 pfet L=0.5U W=1.83U AS=0.8052P AD=0.52155P
+ PS=4.54U PD=2.4U
* device instance $1270 r0 *1 61.35,21.42 pfet
M$1270 D|ZN A1|B|ZN \$178 \$117 pfet L=0.5U W=1.83U AS=0.52155P AD=0.61275P
+ PS=2.4U PD=2.53U
* device instance $1271 r0 *1 72.55,21.42 pfet
M$1271 B2|ZN A1|B|C|I|ZN VDD \$117 pfet L=0.5U W=1.83U AS=0.8052P AD=0.8052P
+ PS=4.54U PD=4.54U
* device instance $1272 r0 *1 74.89,21.645 pfet
M$1272 VDD CLK|clk \$163 \$117 pfet L=0.5U W=1.38U AS=0.6072P AD=0.3588P
+ PS=3.64U PD=1.9U
* device instance $1273 r0 *1 75.91,21.645 pfet
M$1273 \$174 \$163 VDD \$117 pfet L=0.5U W=1.38U AS=0.3588P AD=0.6072P PS=1.9U
+ PD=3.64U
* device instance $1274 r0 *1 77.95,21.835 pfet
M$1274 \$179 \$174 VDD \$117 pfet L=0.5U W=1U AS=0.9696P AD=0.12P PS=5.04U
+ PD=1.24U
* device instance $1275 r0 *1 78.69,21.835 pfet
M$1275 \$175 D|ZN$6 \$179 \$117 pfet L=0.5U W=1U AS=0.12P AD=0.4P PS=1.24U
+ PD=1.8U
* device instance $1276 r0 *1 79.99,21.835 pfet
M$1276 \$180 \$163 \$175 \$117 pfet L=0.5U W=1U AS=0.4P AD=0.12P PS=1.8U
+ PD=1.24U
* device instance $1277 r0 *1 80.73,21.835 pfet
M$1277 VDD \$164 \$180 \$117 pfet L=0.5U W=1U AS=0.12P AD=0.26P PS=1.24U
+ PD=1.52U
* device instance $1278 r0 *1 81.75,21.835 pfet
M$1278 \$164 \$175 VDD \$117 pfet L=0.5U W=1U AS=0.26P AD=0.26P PS=1.52U
+ PD=1.52U
* device instance $1279 r0 *1 82.77,21.835 pfet
M$1279 \$165 \$163 \$164 \$117 pfet L=0.5U W=1U AS=0.26P AD=0.6P PS=1.52U
+ PD=2.2U
* device instance $1280 r0 *1 84.47,21.835 pfet
M$1280 \$181 \$174 \$165 \$117 pfet L=0.5U W=1U AS=0.6P AD=0.13P PS=2.2U
+ PD=1.26U
* device instance $1281 r0 *1 85.23,21.835 pfet
M$1281 \$181 \$166 VDD \$117 pfet L=0.5U W=1U AS=0.442P AD=0.13P PS=1.94U
+ PD=1.26U
* device instance $1282 r0 *1 86.57,21.785 pfet
M$1282 \$166 \$165 VDD \$117 pfet L=0.5U W=1.1U AS=0.442P AD=0.484P PS=1.94U
+ PD=3.08U
* device instance $1283 r0 *1 88.31,21.42 pfet
M$1283 Q|tmds[9] \$166 VDD \$117 pfet L=0.5U W=1.83U AS=0.8052P AD=0.8052P
+ PS=4.54U PD=4.54U
* device instance $1284 r0 *1 96.075,21.5125 pfet
M$1284 A1|B|ZN$1 A2|ZN$2 VDD \$117 pfet L=0.5U W=1.645U AS=0.7238P AD=0.4277P
+ PS=4.17U PD=2.165U
* device instance $1285 r0 *1 97.095,21.5125 pfet
M$1285 VDD A1|B|C|I|ZN A1|B|ZN$1 \$117 pfet L=0.5U W=1.645U AS=0.4277P
+ AD=0.7238P PS=2.165U PD=4.17U
* device instance $1286 r0 *1 105.595,21.5125 pfet
M$1286 D|ZN$2 A2|ZN$6 VDD \$117 pfet L=0.5U W=1.645U AS=0.7238P AD=0.4277P
+ PS=4.17U PD=2.165U
* device instance $1287 r0 *1 106.615,21.5125 pfet
M$1287 VDD A1|B|ZN$1 D|ZN$2 \$117 pfet L=0.5U W=1.645U AS=0.4277P AD=0.7238P
+ PS=2.165U PD=4.17U
* device instance $1288 r0 *1 108.395,21.5125 pfet
M$1288 D|ZN$5 A2|ZN$7 VDD \$117 pfet L=0.5U W=1.645U AS=0.7238P AD=0.4277P
+ PS=4.17U PD=2.165U
* device instance $1289 r0 *1 109.415,21.5125 pfet
M$1289 VDD A1|B|ZN$1 D|ZN$5 \$117 pfet L=0.5U W=1.645U AS=0.4277P AD=0.7238P
+ PS=2.165U PD=4.17U
* device instance $1290 r0 *1 122.39,20.915 pfet
M$1290 \$152 A1|data[1] VDD \$117 pfet L=0.5U W=0.82U AS=0.3608P AD=0.2132P
+ PS=2.52U PD=1.34U
* device instance $1291 r0 *1 123.41,20.915 pfet
M$1291 VDD A1|A2|I|data[0] \$152 \$117 pfet L=0.5U W=0.82U AS=0.2132P
+ AD=0.5054P PS=1.34U PD=2.57U
* device instance $1292 r0 *1 124.65,21.42 pfet
M$1292 A3|B|Z \$152 VDD \$117 pfet L=0.5U W=1.83U AS=0.5054P AD=0.8052P
+ PS=2.57U PD=4.54U
* device instance $1293 r0 *1 130.795,21.5125 pfet
M$1293 A1|ZN$2 A2|A3|Z VDD \$117 pfet L=0.5U W=1.645U AS=0.7238P AD=0.4277P
+ PS=4.17U PD=2.165U
* device instance $1294 r0 *1 131.815,21.5125 pfet
M$1294 VDD A1|A2|data[3] A1|ZN$2 \$117 pfet L=0.5U W=1.645U AS=0.4277P
+ AD=0.7238P PS=2.165U PD=4.17U
* device instance $1295 r0 *1 139.75,21.42 pfet
M$1295 A2|A3|B|ZN A2|ZN$3 \$170 \$117 pfet L=0.5U W=1.83U AS=0.8052P AD=0.4758P
+ PS=4.54U PD=2.35U
* device instance $1296 r0 *1 140.77,21.42 pfet
M$1296 \$170 A1|ZN$2 A2|A3|B|ZN \$117 pfet L=0.5U W=1.83U AS=0.4758P AD=0.6405P
+ PS=2.35U PD=2.53U
* device instance $1297 r0 *1 141.97,21.42 pfet
M$1297 VDD B|Z \$170 \$117 pfet L=0.5U W=1.83U AS=0.6405P AD=0.8052P PS=2.53U
+ PD=4.54U
* device instance $1298 r0 *1 12.17,28.98 pfet
M$1298 \$239 A3|Z VDD \$231 pfet L=0.5U W=1.83U AS=0.8052P AD=0.52155P PS=4.54U
+ PD=2.4U
* device instance $1299 r0 *1 13.24,28.98 pfet
M$1299 \$240 A2|ZN \$239 \$231 pfet L=0.5U W=1.83U AS=0.52155P AD=0.5673P
+ PS=2.4U PD=2.45U
* device instance $1300 r0 *1 14.36,28.98 pfet
M$1300 A1|ZN$3 A1|Z \$240 \$231 pfet L=0.5U W=1.83U AS=0.5673P AD=0.5673P
+ PS=2.45U PD=2.45U
* device instance $1301 r0 *1 15.48,28.98 pfet
M$1301 \$241 A1|B1|Z A1|ZN$3 \$231 pfet L=0.5U W=1.83U AS=0.5673P AD=0.52155P
+ PS=2.45U PD=2.4U
* device instance $1302 r0 *1 16.55,28.98 pfet
M$1302 VDD A1|B2|ZN \$241 \$231 pfet L=0.5U W=1.83U AS=0.52155P AD=0.8052P
+ PS=2.4U PD=4.54U
* device instance $1303 r0 *1 36.01,29.0725 pfet
M$1303 VDD B|ZN$2 A2|ZN$8 \$231 pfet L=0.5U W=1.645U AS=0.61275P AD=0.7238P
+ PS=2.53U PD=4.17U
* device instance $1304 r0 *1 37.21,28.98 pfet
M$1304 \$244 A1|A2|Z A2|ZN$8 \$231 pfet L=0.5U W=1.83U AS=0.61275P AD=0.52155P
+ PS=2.53U PD=2.4U
* device instance $1305 r0 *1 38.28,28.98 pfet
M$1305 VDD A1|A2|C|S|ZN \$244 \$231 pfet L=0.5U W=1.83U AS=0.52155P AD=0.8052P
+ PS=2.4U PD=4.54U
* device instance $1306 r0 *1 57.53,28.755 pfet
M$1306 VDD CLK|clk \$204 \$231 pfet L=0.5U W=1.38U AS=0.6072P AD=0.3588P
+ PS=3.64U PD=1.9U
* device instance $1307 r0 *1 58.55,28.755 pfet
M$1307 \$205 \$204 VDD \$231 pfet L=0.5U W=1.38U AS=0.3588P AD=0.6072P PS=1.9U
+ PD=3.64U
* device instance $1308 r0 *1 60.59,28.565 pfet
M$1308 \$236 \$205 VDD \$231 pfet L=0.5U W=1U AS=0.9696P AD=0.12P PS=5.04U
+ PD=1.24U
* device instance $1309 r0 *1 61.33,28.565 pfet
M$1309 \$206 D|ZN$7 \$236 \$231 pfet L=0.5U W=1U AS=0.12P AD=0.4P PS=1.24U
+ PD=1.8U
* device instance $1310 r0 *1 62.63,28.565 pfet
M$1310 \$237 \$204 \$206 \$231 pfet L=0.5U W=1U AS=0.4P AD=0.12P PS=1.8U
+ PD=1.24U
* device instance $1311 r0 *1 63.37,28.565 pfet
M$1311 VDD \$207 \$237 \$231 pfet L=0.5U W=1U AS=0.12P AD=0.26P PS=1.24U
+ PD=1.52U
* device instance $1312 r0 *1 64.39,28.565 pfet
M$1312 \$207 \$206 VDD \$231 pfet L=0.5U W=1U AS=0.26P AD=0.26P PS=1.52U
+ PD=1.52U
* device instance $1313 r0 *1 65.41,28.565 pfet
M$1313 \$208 \$204 \$207 \$231 pfet L=0.5U W=1U AS=0.26P AD=0.6P PS=1.52U
+ PD=2.2U
* device instance $1314 r0 *1 67.11,28.565 pfet
M$1314 \$238 \$205 \$208 \$231 pfet L=0.5U W=1U AS=0.6P AD=0.13P PS=2.2U
+ PD=1.26U
* device instance $1315 r0 *1 67.87,28.565 pfet
M$1315 VDD \$209 \$238 \$231 pfet L=0.5U W=1U AS=0.13P AD=0.442P PS=1.26U
+ PD=1.94U
* device instance $1316 r0 *1 69.21,28.615 pfet
M$1316 \$209 \$208 VDD \$231 pfet L=0.5U W=1.1U AS=0.442P AD=0.484P PS=1.94U
+ PD=3.08U
* device instance $1317 r0 *1 70.95,28.98 pfet
M$1317 Q|tmds[5] \$209 VDD \$231 pfet L=0.5U W=1.83U AS=0.8052P AD=0.8052P
+ PS=4.54U PD=4.54U
* device instance $1318 r0 *1 73.21,28.98 pfet
M$1318 \$246 B2|ZN VDD \$231 pfet L=0.5U W=1.83U AS=0.8052P AD=0.52155P
+ PS=4.54U PD=2.4U
* device instance $1319 r0 *1 74.28,28.98 pfet
M$1319 D|ZN$6 B1|ZN \$246 \$231 pfet L=0.5U W=1.83U AS=0.52155P AD=0.5673P
+ PS=2.4U PD=2.45U
* device instance $1320 r0 *1 75.4,28.98 pfet
M$1320 \$245 A1|B|ZN D|ZN$6 \$231 pfet L=0.5U W=1.83U AS=0.5673P AD=0.52155P
+ PS=2.45U PD=2.4U
* device instance $1321 r0 *1 76.47,28.98 pfet
M$1321 VDD A2|ZN$1 \$245 \$231 pfet L=0.5U W=1.83U AS=0.52155P AD=0.8052P
+ PS=2.4U PD=4.54U
* device instance $1322 r0 *1 91.03,29.0625 pfet
M$1322 \$215 A1|A2|ZN VDD \$231 pfet L=0.5U W=0.915U AS=0.526125P AD=0.2379P
+ PS=2.58U PD=1.435U
* device instance $1323 r0 *1 92.05,29.0625 pfet
M$1323 VDD A2|A3|Z$1 \$215 \$231 pfet L=0.5U W=0.915U AS=0.2379P AD=0.4026P
+ PS=1.435U PD=2.71U
* device instance $1324 r0 *1 87.59,28.98 pfet
M$1324 \$243 A2|A3|Z$1 VDD \$231 pfet L=0.5U W=1.83U AS=0.8052P AD=0.52155P
+ PS=4.54U PD=2.4U
* device instance $1325 r0 *1 88.66,28.98 pfet
M$1325 A3|B2|ZN A1|A2|ZN \$243 \$231 pfet L=0.5U W=1.83U AS=0.52155P AD=0.5673P
+ PS=2.4U PD=2.45U
* device instance $1326 r0 *1 89.78,28.98 pfet
M$1326 VDD \$215 A3|B2|ZN \$231 pfet L=0.5U W=1.83U AS=0.5673P AD=0.526125P
+ PS=2.45U PD=2.58U
* device instance $1327 r0 *1 94.395,28.8875 pfet
M$1327 A1|B|C|I|ZN A2|B|ZN VDD \$231 pfet L=0.5U W=1.645U AS=0.7238P AD=0.4277P
+ PS=4.17U PD=2.165U
* device instance $1328 r0 *1 95.415,28.8875 pfet
M$1328 VDD A1|A2|C|I|de A1|B|C|I|ZN \$231 pfet L=0.5U W=1.645U AS=0.4277P
+ AD=0.7238P PS=2.165U PD=4.17U
* device instance $1329 r0 *1 106.25,28.98 pfet
M$1329 \$242 A2|ZN$9 VDD \$231 pfet L=0.5U W=1.83U AS=0.8052P AD=0.4758P
+ PS=4.54U PD=2.35U
* device instance $1330 r0 *1 107.27,28.98 pfet
M$1330 A2|ZN$6 A1|A2|C|S|ZN \$242 \$231 pfet L=0.5U W=1.83U AS=0.4758P
+ AD=0.585P PS=2.35U PD=2.53U
* device instance $1331 r0 *1 108.47,29.165 pfet
M$1331 VDD B|ZN$3 A2|ZN$6 \$231 pfet L=0.5U W=1.46U AS=0.585P AD=0.3796P
+ PS=2.53U PD=1.98U
* device instance $1332 r0 *1 109.49,29.165 pfet
M$1332 A2|ZN$6 A1|A2|C|I|de VDD \$231 pfet L=0.5U W=1.46U AS=0.3796P AD=0.6424P
+ PS=1.98U PD=3.8U
* device instance $1333 r0 *1 142.55,28.98 pfet
M$1333 A2|ZN$10 A2|A3|ZN \$235 \$231 pfet L=0.5U W=1.83U AS=0.8052P AD=0.4758P
+ PS=4.54U PD=2.35U
* device instance $1334 r0 *1 143.57,28.98 pfet
M$1334 \$235 A1|ZN$1 A2|ZN$10 \$231 pfet L=0.5U W=1.83U AS=0.4758P AD=0.6405P
+ PS=2.35U PD=2.53U
* device instance $1335 r0 *1 144.77,28.98 pfet
M$1335 VDD B|Z \$235 \$231 pfet L=0.5U W=1.83U AS=0.6405P AD=0.8052P PS=2.53U
+ PD=4.54U
* device instance $1336 r0 *1 11.37,31.5 pfet
M$1336 A3|Z A1|A2|A3|ZN \$247 \$231 pfet L=0.5U W=1.83U AS=0.8052P AD=0.4758P
+ PS=4.54U PD=2.35U
* device instance $1337 r0 *1 12.39,31.5 pfet
M$1337 \$247 A1|data[1] A3|Z \$231 pfet L=0.5U W=1.83U AS=0.4758P AD=0.52155P
+ PS=2.35U PD=2.4U
* device instance $1338 r0 *1 13.46,31.5 pfet
M$1338 VDD \$248 \$247 \$231 pfet L=0.5U W=1.83U AS=0.52155P AD=0.549P PS=2.4U
+ PD=2.63U
* device instance $1339 r0 *1 14.76,31.9575 pfet
M$1339 \$274 A1|data[1] VDD \$231 pfet L=0.5U W=0.915U AS=0.549P AD=0.260775P
+ PS=2.63U PD=1.485U
* device instance $1340 r0 *1 15.83,31.9575 pfet
M$1340 \$248 A1|A2|A3|ZN \$274 \$231 pfet L=0.5U W=0.915U AS=0.260775P
+ AD=0.4026P PS=1.485U PD=2.71U
* device instance $1341 r0 *1 26.01,31.5 pfet
M$1341 VDD A1|A2|I|data[0] A1|B2|ZN \$231 pfet L=0.5U W=1.83U AS=0.8052P
+ AD=0.8052P PS=4.54U PD=4.54U
* device instance $1342 r0 *1 27.85,31.9575 pfet
M$1342 \$275 A1|A2|B2|Z \$262 \$231 pfet L=0.5U W=0.915U AS=0.4026P
+ AD=0.260775P PS=2.71U PD=1.485U
* device instance $1343 r0 *1 28.92,31.9575 pfet
M$1343 \$275 A1|B1|Z VDD \$231 pfet L=0.5U W=0.915U AS=0.549P AD=0.260775P
+ PS=2.63U PD=1.485U
* device instance $1344 r0 *1 30.22,31.5 pfet
M$1344 \$250 \$262 VDD \$231 pfet L=0.5U W=1.83U AS=0.549P AD=0.52155P PS=2.63U
+ PD=2.4U
* device instance $1345 r0 *1 31.29,31.5 pfet
M$1345 A2|Z A1|B1|Z \$250 \$231 pfet L=0.5U W=1.83U AS=0.52155P AD=0.4758P
+ PS=2.4U PD=2.35U
* device instance $1346 r0 *1 32.31,31.5 pfet
M$1346 \$250 A1|A2|B2|Z A2|Z \$231 pfet L=0.5U W=1.83U AS=0.4758P AD=0.8052P
+ PS=2.35U PD=4.54U
* device instance $1347 r0 *1 34.475,31.5925 pfet
M$1347 B|ZN$2 A2|Z VDD \$231 pfet L=0.5U W=1.645U AS=0.7238P AD=0.4277P
+ PS=4.17U PD=2.165U
* device instance $1348 r0 *1 35.495,31.5925 pfet
M$1348 VDD A1|A2|C|S|ZN B|ZN$2 \$231 pfet L=0.5U W=1.645U AS=0.4277P AD=0.7238P
+ PS=2.165U PD=4.17U
* device instance $1349 r0 *1 44.65,31.725 pfet
M$1349 VDD CLK|clk \$252 \$231 pfet L=0.5U W=1.38U AS=0.6072P AD=0.3588P
+ PS=3.64U PD=1.9U
* device instance $1350 r0 *1 45.67,31.725 pfet
M$1350 \$264 \$252 VDD \$231 pfet L=0.5U W=1.38U AS=0.3588P AD=0.6072P PS=1.9U
+ PD=3.64U
* device instance $1351 r0 *1 58.07,31.5 pfet
M$1351 Q|tmds[3] \$268 VDD \$231 pfet L=0.5U W=1.83U AS=0.8052P AD=0.8052P
+ PS=4.54U PD=4.54U
* device instance $1352 r0 *1 67.51,31.5 pfet
M$1352 A1|B|ZN A1|A2|C|I|de VDD \$231 pfet L=0.5U W=1.83U AS=0.8052P AD=0.8052P
+ PS=4.54U PD=4.54U
* device instance $1353 r0 *1 86.97,31.5 pfet
M$1353 A2|A3|Z$1 A1|A2|data[3] \$253 \$231 pfet L=0.5U W=1.83U AS=0.8052P
+ AD=0.4758P PS=4.54U PD=2.35U
* device instance $1354 r0 *1 87.99,31.5 pfet
M$1354 \$253 A1|data[1] A2|A3|Z$1 \$231 pfet L=0.5U W=1.83U AS=0.4758P
+ AD=0.52155P PS=2.35U PD=2.4U
* device instance $1355 r0 *1 89.06,31.5 pfet
M$1355 VDD \$254 \$253 \$231 pfet L=0.5U W=1.83U AS=0.52155P AD=0.549P PS=2.4U
+ PD=2.63U
* device instance $1356 r0 *1 90.36,31.9575 pfet
M$1356 \$281 A1|data[1] VDD \$231 pfet L=0.5U W=0.915U AS=0.549P AD=0.260775P
+ PS=2.63U PD=1.485U
* device instance $1357 r0 *1 91.43,31.9575 pfet
M$1357 \$254 A1|A2|data[3] \$281 \$231 pfet L=0.5U W=0.915U AS=0.260775P
+ AD=0.4026P PS=1.485U PD=2.71U
* device instance $1358 r0 *1 102.83,31.4175 pfet
M$1358 \$255 A1|A2|A3|ZN VDD \$231 pfet L=0.5U W=0.915U AS=0.4026P AD=0.2379P
+ PS=2.71U PD=1.435U
* device instance $1359 r0 *1 103.85,31.4175 pfet
M$1359 \$255 A1|A2|ZN VDD \$231 pfet L=0.5U W=0.915U AS=0.526125P AD=0.2379P
+ PS=2.58U PD=1.435U
* device instance $1360 r0 *1 105.1,31.5 pfet
M$1360 A2|ZN$9 \$255 VDD \$231 pfet L=0.5U W=1.83U AS=0.526125P AD=0.5673P
+ PS=2.58U PD=2.45U
* device instance $1361 r0 *1 106.22,31.5 pfet
M$1361 \$282 A1|A2|ZN A2|ZN$9 \$231 pfet L=0.5U W=1.83U AS=0.5673P AD=0.52155P
+ PS=2.45U PD=2.4U
* device instance $1362 r0 *1 107.29,31.5 pfet
M$1362 VDD A1|A2|A3|ZN \$282 \$231 pfet L=0.5U W=1.83U AS=0.52155P AD=0.8052P
+ PS=2.4U PD=4.54U
* device instance $1363 r0 *1 111.785,31.5925 pfet
M$1363 B|ZN$3 A1|A2|C|S|ZN VDD \$231 pfet L=0.5U W=1.645U AS=0.7238P AD=0.4277P
+ PS=4.17U PD=2.165U
* device instance $1364 r0 *1 112.805,31.5925 pfet
M$1364 VDD A2|ZN$11 B|ZN$3 \$231 pfet L=0.5U W=1.645U AS=0.4277P AD=0.7238P
+ PS=2.165U PD=4.17U
* device instance $1365 r0 *1 120.25,31.5775 pfet
M$1365 \$280 A1|A2|data[3] \$257 \$231 pfet L=0.5U W=0.495U AS=0.2178P
+ AD=0.141075P PS=1.87U PD=1.065U
* device instance $1366 r0 *1 121.32,31.5775 pfet
M$1366 \$280 A1|ZN VDD \$231 pfet L=0.5U W=0.495U AS=0.282P AD=0.141075P
+ PS=1.715U PD=1.065U
* device instance $1367 r0 *1 122.62,31.3675 pfet
M$1367 \$258 \$257 VDD \$231 pfet L=0.5U W=0.915U AS=0.282P AD=0.260775P
+ PS=1.715U PD=1.485U
* device instance $1368 r0 *1 123.69,31.3675 pfet
M$1368 \$259 A1|ZN \$258 \$231 pfet L=0.5U W=0.915U AS=0.260775P AD=0.2379P
+ PS=1.485U PD=1.435U
* device instance $1369 r0 *1 124.71,31.3675 pfet
M$1369 \$258 A1|A2|data[3] \$259 \$231 pfet L=0.5U W=0.915U AS=0.2379P
+ AD=0.4026P PS=1.435U PD=2.71U
* device instance $1370 r0 *1 127.99,29.53 pfet
M$1370 VDD A1|A2|A3|data[2] \$219 \$231 pfet L=0.5U W=0.73U AS=0.3212P
+ AD=0.1898P PS=2.34U PD=1.25U
* device instance $1371 r0 *1 129.01,29.53 pfet
M$1371 \$219 A1|A2|data[3] VDD \$231 pfet L=0.5U W=0.73U AS=0.1898P AD=0.1898P
+ PS=1.25U PD=1.25U
* device instance $1372 r0 *1 130.03,29.53 pfet
M$1372 \$219 A3|B|Z VDD \$231 pfet L=0.5U W=0.73U AS=0.5339P AD=0.1898P
+ PS=2.69U PD=1.25U
* device instance $1373 r0 *1 131.39,28.98 pfet
M$1373 B|Z \$219 VDD \$231 pfet L=0.5U W=1.83U AS=0.5339P AD=0.8052P PS=2.69U
+ PD=4.54U
* device instance $1374 r0 *1 126.45,31.5325 pfet
M$1374 \$271 \$259 VDD \$231 pfet L=0.5U W=0.915U AS=0.4026P AD=0.2379P
+ PS=2.71U PD=1.435U
* device instance $1375 r0 *1 127.47,31.5325 pfet
M$1375 \$271 A2|A3|Z VDD \$231 pfet L=0.5U W=0.915U AS=0.535925P AD=0.2379P
+ PS=2.58U PD=1.435U
* device instance $1376 r0 *1 128.72,31.5 pfet
M$1376 A1|A2|ZN \$271 VDD \$231 pfet L=0.5U W=1.83U AS=0.535925P AD=0.61305P
+ PS=2.58U PD=2.5U
* device instance $1377 r0 *1 129.89,31.5 pfet
M$1377 \$276 A2|A3|Z A1|A2|ZN \$231 pfet L=0.5U W=1.83U AS=0.61305P AD=0.4758P
+ PS=2.5U PD=2.35U
* device instance $1378 r0 *1 130.91,31.5 pfet
M$1378 VDD \$259 \$276 \$231 pfet L=0.5U W=1.83U AS=0.4758P AD=0.8052P PS=2.35U
+ PD=4.54U
* device instance $1379 r0 *1 140.87,31.5 pfet
M$1379 A2|ZN$12 A2|ZN$14 \$260 \$231 pfet L=0.5U W=1.83U AS=0.8052P AD=0.4758P
+ PS=4.54U PD=2.35U
* device instance $1380 r0 *1 141.89,31.5 pfet
M$1380 \$260 A1|Z$2 A2|ZN$12 \$231 pfet L=0.5U W=1.83U AS=0.4758P AD=0.6405P
+ PS=2.35U PD=2.53U
* device instance $1381 r0 *1 143.09,31.5 pfet
M$1381 VDD A2|A3|B|ZN \$260 \$231 pfet L=0.5U W=1.83U AS=0.6405P AD=0.8052P
+ PS=2.53U PD=4.54U
* device instance $1382 r0 *1 14.45,39.0275 pfet
M$1382 \$300 \$299 VDD \$310 pfet L=0.5U W=0.915U AS=0.4026P AD=0.2379P
+ PS=2.71U PD=1.435U
* device instance $1383 r0 *1 15.47,39.0275 pfet
M$1383 \$300 A1|A2|A3|ZN VDD \$310 pfet L=0.5U W=0.915U AS=0.535925P AD=0.2379P
+ PS=2.58U PD=1.435U
* device instance $1384 r0 *1 16.72,39.06 pfet
M$1384 A1|ZN$4 \$300 VDD \$310 pfet L=0.5U W=1.83U AS=0.535925P AD=0.61305P
+ PS=2.58U PD=2.5U
* device instance $1385 r0 *1 17.89,39.06 pfet
M$1385 \$333 A1|A2|A3|ZN A1|ZN$4 \$310 pfet L=0.5U W=1.83U AS=0.61305P
+ AD=0.4758P PS=2.5U PD=2.35U
* device instance $1386 r0 *1 18.91,39.06 pfet
M$1386 VDD \$299 \$333 \$310 pfet L=0.5U W=1.83U AS=0.4758P AD=0.8052P PS=2.35U
+ PD=4.54U
* device instance $1387 r0 *1 28.97,38.6025 pfet
M$1387 \$327 A1|A2|B2|Z \$303 \$310 pfet L=0.5U W=0.915U AS=0.4026P
+ AD=0.260775P PS=2.71U PD=1.485U
* device instance $1388 r0 *1 30.04,38.6025 pfet
M$1388 VDD A1|A2|ZN$1 \$327 \$310 pfet L=0.5U W=0.915U AS=0.260775P AD=0.549P
+ PS=1.485U PD=2.63U
* device instance $1389 r0 *1 31.34,39.06 pfet
M$1389 \$323 \$303 VDD \$310 pfet L=0.5U W=1.83U AS=0.549P AD=0.52155P PS=2.63U
+ PD=2.4U
* device instance $1390 r0 *1 32.41,39.06 pfet
M$1390 I1|Z A1|A2|ZN$1 \$323 \$310 pfet L=0.5U W=1.83U AS=0.52155P AD=0.4758P
+ PS=2.4U PD=2.35U
* device instance $1391 r0 *1 33.43,39.06 pfet
M$1391 \$323 A1|A2|B2|Z I1|Z \$310 pfet L=0.5U W=1.83U AS=0.4758P AD=0.8052P
+ PS=2.35U PD=4.54U
* device instance $1392 r0 *1 40.63,39.06 pfet
M$1392 D|ZN$8 A2|Z$1 \$324 \$310 pfet L=0.5U W=1.83U AS=0.8052P AD=0.4758P
+ PS=4.54U PD=2.35U
* device instance $1393 r0 *1 41.65,39.06 pfet
M$1393 \$324 A1|A2|C|I|de D|ZN$8 \$310 pfet L=0.5U W=1.83U AS=0.4758P
+ AD=0.6405P PS=2.35U PD=2.53U
* device instance $1394 r0 *1 42.85,39.06 pfet
M$1394 VDD B|ZN$1 \$324 \$310 pfet L=0.5U W=1.83U AS=0.6405P AD=0.8052P
+ PS=2.53U PD=4.54U
* device instance $1395 r0 *1 47.71,31.915 pfet
M$1395 \$277 \$264 VDD \$231 pfet L=0.5U W=1U AS=0.9696P AD=0.12P PS=5.04U
+ PD=1.24U
* device instance $1396 r0 *1 48.45,31.915 pfet
M$1396 \$265 D|ZN$8 \$277 \$231 pfet L=0.5U W=1U AS=0.12P AD=0.4P PS=1.24U
+ PD=1.8U
* device instance $1397 r0 *1 49.75,31.915 pfet
M$1397 \$278 \$252 \$265 \$231 pfet L=0.5U W=1U AS=0.4P AD=0.12P PS=1.8U
+ PD=1.24U
* device instance $1398 r0 *1 50.49,31.915 pfet
M$1398 VDD \$266 \$278 \$231 pfet L=0.5U W=1U AS=0.12P AD=0.26P PS=1.24U
+ PD=1.52U
* device instance $1399 r0 *1 51.51,31.915 pfet
M$1399 \$266 \$265 VDD \$231 pfet L=0.5U W=1U AS=0.26P AD=0.26P PS=1.52U
+ PD=1.52U
* device instance $1400 r0 *1 52.53,31.915 pfet
M$1400 \$267 \$252 \$266 \$231 pfet L=0.5U W=1U AS=0.26P AD=0.6P PS=1.52U
+ PD=2.2U
* device instance $1401 r0 *1 54.23,31.915 pfet
M$1401 \$279 \$264 \$267 \$231 pfet L=0.5U W=1U AS=0.6P AD=0.13P PS=2.2U
+ PD=1.26U
* device instance $1402 r0 *1 54.99,31.915 pfet
M$1402 \$279 \$268 VDD \$231 pfet L=0.5U W=1U AS=0.442P AD=0.13P PS=1.94U
+ PD=1.26U
* device instance $1403 r0 *1 56.33,31.865 pfet
M$1403 \$268 \$267 VDD \$231 pfet L=0.5U W=1.1U AS=0.442P AD=0.484P PS=1.94U
+ PD=3.08U
* device instance $1404 r0 *1 66.95,39.06 pfet
M$1404 A2|ZN$13 A2|ZN$15 \$325 \$310 pfet L=0.5U W=1.83U AS=0.8052P AD=0.4758P
+ PS=4.54U PD=2.35U
* device instance $1405 r0 *1 67.97,39.06 pfet
M$1405 \$325 A1|A2|C|S|ZN A2|ZN$13 \$310 pfet L=0.5U W=1.83U AS=0.4758P
+ AD=0.6405P PS=2.35U PD=2.53U
* device instance $1406 r0 *1 69.17,39.06 pfet
M$1406 VDD A1|B|ZN \$325 \$310 pfet L=0.5U W=1.83U AS=0.6405P AD=0.8052P
+ PS=2.53U PD=4.54U
* device instance $1407 r0 *1 86.585,38.9675 pfet
M$1407 B|ZN$4 A1|A2|ZN VDD \$310 pfet L=0.5U W=1.645U AS=0.7238P AD=0.4277P
+ PS=4.17U PD=2.165U
* device instance $1408 r0 *1 87.605,38.9675 pfet
M$1408 VDD A2|A3|Z$1 B|ZN$4 \$310 pfet L=0.5U W=1.645U AS=0.4277P AD=0.7238P
+ PS=2.165U PD=4.17U
* device instance $1409 r0 *1 110.11,39.1425 pfet
M$1409 \$307 A1|A2|B2|Z VDD \$310 pfet L=0.5U W=0.915U AS=0.4026P AD=0.2379P
+ PS=2.71U PD=1.435U
* device instance $1410 r0 *1 111.13,39.1425 pfet
M$1410 \$307 A1|A2|ZN VDD \$310 pfet L=0.5U W=0.915U AS=0.526125P AD=0.2379P
+ PS=2.58U PD=1.435U
* device instance $1411 r0 *1 112.38,39.06 pfet
M$1411 A2|ZN$11 \$307 VDD \$310 pfet L=0.5U W=1.83U AS=0.526125P AD=0.5673P
+ PS=2.58U PD=2.45U
* device instance $1412 r0 *1 113.5,39.06 pfet
M$1412 \$334 A1|A2|ZN A2|ZN$11 \$310 pfet L=0.5U W=1.83U AS=0.5673P AD=0.52155P
+ PS=2.45U PD=2.4U
* device instance $1413 r0 *1 114.57,39.06 pfet
M$1413 VDD A1|A2|B2|Z \$334 \$310 pfet L=0.5U W=1.83U AS=0.52155P AD=0.8052P
+ PS=2.4U PD=4.54U
* device instance $1414 r0 *1 126.315,38.9675 pfet
M$1414 A2|ZN$14 A1|A2|ZN VDD \$310 pfet L=0.5U W=1.645U AS=0.7238P AD=0.4277P
+ PS=4.17U PD=2.165U
* device instance $1415 r0 *1 127.335,38.9675 pfet
M$1415 VDD A1|data[5] A2|ZN$14 \$310 pfet L=0.5U W=1.645U AS=0.4277P AD=0.7238P
+ PS=2.165U PD=4.17U
* device instance $1416 r0 *1 142.025,38.9675 pfet
M$1416 A2|A3|ZN A1|Z$2 VDD \$310 pfet L=0.5U W=1.645U AS=0.7238P AD=0.4277P
+ PS=4.17U PD=2.165U
* device instance $1417 r0 *1 143.045,38.9675 pfet
M$1417 VDD A2|ZN$14 A2|A3|ZN \$310 pfet L=0.5U W=1.645U AS=0.4277P AD=0.7238P
+ PS=2.165U PD=4.17U
* device instance $1418 r0 *1 8.25,38.9825 pfet
M$1418 \$326 A1|A2|A3|data[2] \$298 \$310 pfet L=0.5U W=0.495U AS=0.2178P
+ AD=0.141075P PS=1.87U PD=1.065U
* device instance $1419 r0 *1 9.32,38.9825 pfet
M$1419 VDD A1|B2|ZN \$326 \$310 pfet L=0.5U W=0.495U AS=0.141075P AD=0.282P
+ PS=1.065U PD=1.715U
* device instance $1420 r0 *1 10.62,39.1925 pfet
M$1420 \$322 \$298 VDD \$310 pfet L=0.5U W=0.915U AS=0.282P AD=0.260775P
+ PS=1.715U PD=1.485U
* device instance $1421 r0 *1 11.69,39.1925 pfet
M$1421 \$299 A1|B2|ZN \$322 \$310 pfet L=0.5U W=0.915U AS=0.260775P AD=0.2379P
+ PS=1.485U PD=1.435U
* device instance $1422 r0 *1 12.71,39.1925 pfet
M$1422 \$322 A1|A2|A3|data[2] \$299 \$310 pfet L=0.5U W=0.915U AS=0.2379P
+ AD=0.4026P PS=1.435U PD=2.71U
* device instance $1423 r0 *1 20.55,41.4875 pfet
M$1423 VDD B|ZN$4 A2|ZN$19 \$310 pfet L=0.5U W=1.645U AS=0.61275P AD=0.7238P
+ PS=2.53U PD=4.17U
* device instance $1424 r0 *1 18.28,41.58 pfet
M$1424 \$358 A1|A2|ZN$1 VDD \$310 pfet L=0.5U W=1.83U AS=0.8052P AD=0.52155P
+ PS=4.54U PD=2.4U
* device instance $1425 r0 *1 19.35,41.58 pfet
M$1425 A2|ZN$19 A1|ZN$4 \$358 \$310 pfet L=0.5U W=1.83U AS=0.52155P AD=0.61275P
+ PS=2.4U PD=2.53U
* device instance $1426 r0 *1 47.35,41.58 pfet
M$1426 D|ZN$9 A2|ZN$16 \$337 \$310 pfet L=0.5U W=1.83U AS=0.8052P AD=0.4758P
+ PS=4.54U PD=2.35U
* device instance $1427 r0 *1 48.37,41.58 pfet
M$1427 \$337 A1|A2|C|I|de D|ZN$9 \$310 pfet L=0.5U W=1.83U AS=0.4758P
+ AD=0.6405P PS=2.35U PD=2.53U
* device instance $1428 r0 *1 49.57,41.58 pfet
M$1428 VDD B|ZN$1 \$337 \$310 pfet L=0.5U W=1.83U AS=0.6405P AD=0.8052P
+ PS=2.53U PD=4.54U
* device instance $1429 r0 *1 66.35,41.58 pfet
M$1429 \$339 B|ZN$1 VDD \$310 pfet L=0.5U W=1.83U AS=0.8052P AD=0.6405P
+ PS=4.54U PD=2.53U
* device instance $1430 r0 *1 67.55,41.58 pfet
M$1430 D|ZN$7 A1|ZN$5 \$339 \$310 pfet L=0.5U W=1.83U AS=0.6405P AD=0.4758P
+ PS=2.53U PD=2.35U
* device instance $1431 r0 *1 68.57,41.58 pfet
M$1431 \$339 A2|ZN$13 D|ZN$7 \$310 pfet L=0.5U W=1.83U AS=0.4758P AD=0.8052P
+ PS=2.35U PD=4.54U
* device instance $1432 r0 *1 83.415,42.0325 pfet
M$1432 \$364 \$341 \$342 \$310 pfet L=0.5U W=0.915U AS=0.4026P AD=0.2447625P
+ PS=2.71U PD=1.45U
* device instance $1433 r0 *1 84.45,42.0325 pfet
M$1433 \$364 A2|A3|Z$1 VDD \$310 pfet L=0.5U W=0.915U AS=0.571875P
+ AD=0.2447625P PS=2.68U PD=1.45U
* device instance $1434 r0 *1 85.8,41.575 pfet
M$1434 \$343 \$342 VDD \$310 pfet L=0.5U W=1.83U AS=0.571875P AD=0.52155P
+ PS=2.68U PD=2.4U
* device instance $1435 r0 *1 86.87,41.575 pfet
M$1435 A3|Z$1 A2|A3|Z$1 \$343 \$310 pfet L=0.5U W=1.83U AS=0.52155P AD=0.4758P
+ PS=2.4U PD=2.35U
* device instance $1436 r0 *1 87.89,41.575 pfet
M$1436 \$343 \$341 A3|Z$1 \$310 pfet L=0.5U W=1.83U AS=0.4758P AD=1.3176P
+ PS=2.35U PD=5.1U
* device instance $1437 r0 *1 94.25,41.58 pfet
M$1437 A1|A2|Z$1 A1|A2|ZN \$345 \$310 pfet L=0.5U W=1.83U AS=0.8052P AD=0.4758P
+ PS=4.54U PD=2.35U
* device instance $1438 r0 *1 95.27,41.58 pfet
M$1438 \$345 A1|data[5] A1|A2|Z$1 \$310 pfet L=0.5U W=1.83U AS=0.4758P
+ AD=0.52155P PS=2.35U PD=2.4U
* device instance $1439 r0 *1 96.34,41.58 pfet
M$1439 VDD \$329 \$345 \$310 pfet L=0.5U W=1.83U AS=0.52155P AD=0.549P PS=2.4U
+ PD=2.63U
* device instance $1440 r0 *1 97.64,42.0375 pfet
M$1440 \$365 A1|data[5] VDD \$310 pfet L=0.5U W=0.915U AS=0.549P AD=0.260775P
+ PS=2.63U PD=1.485U
* device instance $1441 r0 *1 98.71,42.0375 pfet
M$1441 \$329 A1|A2|ZN \$365 \$310 pfet L=0.5U W=0.915U AS=0.260775P AD=0.4026P
+ PS=1.485U PD=2.71U
* device instance $1442 r0 *1 107.91,41.395 pfet
M$1442 VDD B|ZN$5 A2|ZN$7 \$310 pfet L=0.5U W=1.46U AS=0.585P AD=0.3796P
+ PS=2.53U PD=1.98U
* device instance $1443 r0 *1 108.93,41.395 pfet
M$1443 A2|ZN$7 A1|A2|C|I|de VDD \$310 pfet L=0.5U W=1.46U AS=0.3796P AD=0.6424P
+ PS=1.98U PD=3.8U
* device instance $1444 r0 *1 105.69,41.58 pfet
M$1444 \$366 A2|ZN$17 VDD \$310 pfet L=0.5U W=1.83U AS=0.8052P AD=0.4758P
+ PS=4.54U PD=2.35U
* device instance $1445 r0 *1 106.71,41.58 pfet
M$1445 A2|ZN$7 A1|A2|C|S|ZN \$366 \$310 pfet L=0.5U W=1.83U AS=0.4758P
+ AD=0.585P PS=2.35U PD=2.53U
* device instance $1446 r0 *1 127.99,41.4975 pfet
M$1446 \$346 A1|A2|data[3] VDD \$310 pfet L=0.5U W=0.915U AS=0.526125P
+ AD=0.2379P PS=2.58U PD=1.435U
* device instance $1447 r0 *1 129.01,41.4975 pfet
M$1447 VDD A2|A3|Z \$346 \$310 pfet L=0.5U W=0.915U AS=0.2379P AD=0.4026P
+ PS=1.435U PD=2.71U
* device instance $1448 r0 *1 124.55,41.58 pfet
M$1448 \$362 A2|A3|Z VDD \$310 pfet L=0.5U W=1.83U AS=0.8052P AD=0.52155P
+ PS=4.54U PD=2.4U
* device instance $1449 r0 *1 125.62,41.58 pfet
M$1449 A1|A2|I0|ZN A1|A2|data[3] \$362 \$310 pfet L=0.5U W=1.83U AS=0.52155P
+ AD=0.5673P PS=2.4U PD=2.45U
* device instance $1450 r0 *1 126.74,41.58 pfet
M$1450 VDD \$346 A1|A2|I0|ZN \$310 pfet L=0.5U W=1.83U AS=0.5673P AD=0.526125P
+ PS=2.45U PD=2.58U
* device instance $1451 r0 *1 142.45,41.6125 pfet
M$1451 \$330 A2|A3|ZN VDD \$310 pfet L=0.5U W=0.915U AS=0.535925P AD=0.2379P
+ PS=2.58U PD=1.435U
* device instance $1452 r0 *1 143.47,41.6125 pfet
M$1452 VDD \$348 \$330 \$310 pfet L=0.5U W=0.915U AS=0.2379P AD=0.4026P
+ PS=1.435U PD=2.71U
* device instance $1453 r0 *1 139.01,41.58 pfet
M$1453 \$361 \$348 VDD \$310 pfet L=0.5U W=1.83U AS=0.8052P AD=0.4758P PS=4.54U
+ PD=2.35U
* device instance $1454 r0 *1 140.03,41.58 pfet
M$1454 B1|ZN$1 A2|A3|ZN \$361 \$310 pfet L=0.5U W=1.83U AS=0.4758P AD=0.61305P
+ PS=2.35U PD=2.5U
* device instance $1455 r0 *1 141.2,41.58 pfet
M$1455 VDD \$330 B1|ZN$1 \$310 pfet L=0.5U W=1.83U AS=0.61305P AD=0.535925P
+ PS=2.5U PD=2.58U
* device instance $1456 r0 *1 32.79,49.2225 pfet
M$1456 \$383 A1|A2|I0|ZN VDD \$396 pfet L=0.5U W=0.915U AS=0.526125P AD=0.2379P
+ PS=2.58U PD=1.435U
* device instance $1457 r0 *1 33.81,49.2225 pfet
M$1457 VDD A1|A2|A3|ZN \$383 \$396 pfet L=0.5U W=0.915U AS=0.2379P AD=0.4026P
+ PS=1.435U PD=2.71U
* device instance $1458 r0 *1 29.35,49.14 pfet
M$1458 \$413 A1|A2|A3|ZN VDD \$396 pfet L=0.5U W=1.83U AS=0.8052P AD=0.52155P
+ PS=4.54U PD=2.4U
* device instance $1459 r0 *1 30.42,49.14 pfet
M$1459 A1|A2|ZN$1 A1|A2|I0|ZN \$413 \$396 pfet L=0.5U W=1.83U AS=0.52155P
+ AD=0.5673P PS=2.4U PD=2.45U
* device instance $1460 r0 *1 31.54,49.14 pfet
M$1460 VDD \$383 A1|A2|ZN$1 \$396 pfet L=0.5U W=1.83U AS=0.5673P AD=0.526125P
+ PS=2.45U PD=2.58U
* device instance $1461 r0 *1 33.77,42.0325 pfet
M$1461 VDD A1|A2|C|S|ZN \$335 \$310 pfet L=0.5U W=0.915U AS=0.4026P AD=0.2379P
+ PS=2.71U PD=1.435U
* device instance $1462 r0 *1 34.79,42.0325 pfet
M$1462 \$359 A1|A2|I0|ZN VDD \$310 pfet L=0.5U W=0.915U AS=0.2379P AD=0.1098P
+ PS=1.435U PD=1.155U
* device instance $1463 r0 *1 35.53,42.0325 pfet
M$1463 \$336 A1|A2|C|S|ZN \$359 \$310 pfet L=0.5U W=0.915U AS=0.1098P
+ AD=0.2379P PS=1.155U PD=1.435U
* device instance $1464 r0 *1 36.55,42.0325 pfet
M$1464 \$360 \$335 \$336 \$310 pfet L=0.5U W=0.915U AS=0.2379P AD=0.1258125P
+ PS=1.435U PD=1.19U
* device instance $1465 r0 *1 37.325,42.0325 pfet
M$1465 \$360 I1|Z VDD \$310 pfet L=0.5U W=0.915U AS=0.6244875P AD=0.1258125P
+ PS=2.795U PD=1.19U
* device instance $1466 r0 *1 38.79,41.575 pfet
M$1466 A2|Z$1 \$336 VDD \$310 pfet L=0.5U W=1.83U AS=0.6244875P AD=0.8052P
+ PS=2.795U PD=4.54U
* device instance $1467 r0 *1 46.89,48.915 pfet
M$1467 VDD CLK|clk \$397 \$396 pfet L=0.5U W=1.38U AS=0.6072P AD=0.3588P
+ PS=3.64U PD=1.9U
* device instance $1468 r0 *1 47.91,48.915 pfet
M$1468 \$384 \$397 VDD \$396 pfet L=0.5U W=1.38U AS=0.3588P AD=0.6072P PS=1.9U
+ PD=3.64U
* device instance $1469 r0 *1 49.95,48.725 pfet
M$1469 \$409 \$384 VDD \$396 pfet L=0.5U W=1U AS=0.9696P AD=0.12P PS=5.04U
+ PD=1.24U
* device instance $1470 r0 *1 50.69,48.725 pfet
M$1470 \$398 D|ZN$9 \$409 \$396 pfet L=0.5U W=1U AS=0.12P AD=0.4P PS=1.24U
+ PD=1.8U
* device instance $1471 r0 *1 51.99,48.725 pfet
M$1471 \$410 \$397 \$398 \$396 pfet L=0.5U W=1U AS=0.4P AD=0.12P PS=1.8U
+ PD=1.24U
* device instance $1472 r0 *1 52.73,48.725 pfet
M$1472 VDD \$385 \$410 \$396 pfet L=0.5U W=1U AS=0.12P AD=0.26P PS=1.24U
+ PD=1.52U
* device instance $1473 r0 *1 53.75,48.725 pfet
M$1473 \$385 \$398 VDD \$396 pfet L=0.5U W=1U AS=0.26P AD=0.26P PS=1.52U
+ PD=1.52U
* device instance $1474 r0 *1 54.77,48.725 pfet
M$1474 \$399 \$397 \$385 \$396 pfet L=0.5U W=1U AS=0.26P AD=0.6P PS=1.52U
+ PD=2.2U
* device instance $1475 r0 *1 56.47,48.725 pfet
M$1475 \$411 \$384 \$399 \$396 pfet L=0.5U W=1U AS=0.6P AD=0.13P PS=2.2U
+ PD=1.26U
* device instance $1476 r0 *1 57.23,48.725 pfet
M$1476 VDD \$386 \$411 \$396 pfet L=0.5U W=1U AS=0.13P AD=0.442P PS=1.26U
+ PD=1.94U
* device instance $1477 r0 *1 58.57,48.775 pfet
M$1477 \$386 \$399 VDD \$396 pfet L=0.5U W=1.1U AS=0.442P AD=0.484P PS=1.94U
+ PD=3.08U
* device instance $1478 r0 *1 60.31,49.14 pfet
M$1478 Q|tmds[7] \$386 VDD \$396 pfet L=0.5U W=1.83U AS=0.8052P AD=0.8052P
+ PS=4.54U PD=4.54U
* device instance $1479 r0 *1 70.31,49.2225 pfet
M$1479 \$389 A1|A2|B1|Z VDD \$396 pfet L=0.5U W=0.915U AS=0.526125P AD=0.2379P
+ PS=2.58U PD=1.435U
* device instance $1480 r0 *1 71.33,49.2225 pfet
M$1480 VDD A1|A2|B2|Z \$389 \$396 pfet L=0.5U W=0.915U AS=0.2379P AD=0.4026P
+ PS=1.435U PD=2.71U
* device instance $1481 r0 *1 66.87,49.14 pfet
M$1481 \$416 A1|A2|B2|Z VDD \$396 pfet L=0.5U W=1.83U AS=0.8052P AD=0.52155P
+ PS=4.54U PD=2.4U
* device instance $1482 r0 *1 67.94,49.14 pfet
M$1482 A2|ZN$15 A1|A2|B1|Z \$416 \$396 pfet L=0.5U W=1.83U AS=0.52155P
+ AD=0.5673P PS=2.4U PD=2.45U
* device instance $1483 r0 *1 69.06,49.14 pfet
M$1483 VDD \$389 A2|ZN$15 \$396 pfet L=0.5U W=1.83U AS=0.5673P AD=0.526125P
+ PS=2.45U PD=2.58U
* device instance $1484 r0 *1 77.13,41.9025 pfet
M$1484 \$363 A1|A2|A3|ZN \$355 \$310 pfet L=0.5U W=0.495U AS=0.2178P AD=0.1287P
+ PS=1.87U PD=1.015U
* device instance $1485 r0 *1 78.15,41.9025 pfet
M$1485 \$363 A1|data[5] VDD \$310 pfet L=0.5U W=0.495U AS=0.294375P AD=0.1287P
+ PS=1.765U PD=1.015U
* device instance $1486 r0 *1 79.5,41.6925 pfet
M$1486 \$340 \$355 VDD \$310 pfet L=0.5U W=0.915U AS=0.294375P AD=0.260775P
+ PS=1.765U PD=1.485U
* device instance $1487 r0 *1 80.57,41.6925 pfet
M$1487 \$341 A1|data[5] \$340 \$310 pfet L=0.5U W=0.915U AS=0.260775P
+ AD=0.2379P PS=1.485U PD=1.435U
* device instance $1488 r0 *1 81.59,41.6925 pfet
M$1488 \$340 A1|A2|A3|ZN \$341 \$310 pfet L=0.5U W=0.915U AS=0.2379P AD=0.4026P
+ PS=1.435U PD=2.71U
* device instance $1489 r0 *1 86.44,49.14 pfet
M$1489 \$415 A1|data[6] A2|ZN$18 \$396 pfet L=0.5U W=1.83U AS=0.8052P
+ AD=0.5673P PS=4.54U PD=2.45U
* device instance $1490 r0 *1 87.56,49.14 pfet
M$1490 VDD A1|A2|Z$1 \$415 \$396 pfet L=0.5U W=1.83U AS=0.5673P AD=0.8052P
+ PS=2.45U PD=4.54U
* device instance $1491 r0 *1 97.79,49.2225 pfet
M$1491 \$391 A1|A2|B1|Z VDD \$396 pfet L=0.5U W=0.915U AS=0.4026P AD=0.2379P
+ PS=2.71U PD=1.435U
* device instance $1492 r0 *1 98.81,49.2225 pfet
M$1492 \$391 A1|data[6] VDD \$396 pfet L=0.5U W=0.915U AS=0.526125P AD=0.2379P
+ PS=2.58U PD=1.435U
* device instance $1493 r0 *1 100.06,49.14 pfet
M$1493 A2|ZN$17 \$391 VDD \$396 pfet L=0.5U W=1.83U AS=0.526125P AD=0.5673P
+ PS=2.58U PD=2.45U
* device instance $1494 r0 *1 101.18,49.14 pfet
M$1494 \$414 A1|data[6] A2|ZN$17 \$396 pfet L=0.5U W=1.83U AS=0.5673P
+ AD=0.52155P PS=2.45U PD=2.4U
* device instance $1495 r0 *1 102.25,49.14 pfet
M$1495 VDD A1|A2|B1|Z \$414 \$396 pfet L=0.5U W=1.83U AS=0.52155P AD=0.8052P
+ PS=2.4U PD=4.54U
* device instance $1496 r0 *1 145.21,41.4475 pfet
M$1496 \$348 A2|A3|B|ZN \$349 \$310 pfet L=0.5U W=0.915U AS=0.4026P AD=0.2379P
+ PS=2.71U PD=1.435U
* device instance $1497 r0 *1 146.23,41.4475 pfet
M$1497 \$349 A1|B|Z \$348 \$310 pfet L=0.5U W=0.915U AS=0.2379P AD=0.260775P
+ PS=1.435U PD=1.485U
* device instance $1498 r0 *1 147.3,41.4475 pfet
M$1498 VDD \$332 \$349 \$310 pfet L=0.5U W=0.915U AS=0.260775P AD=0.282P
+ PS=1.485U PD=1.715U
* device instance $1499 r0 *1 148.6,41.6575 pfet
M$1499 \$350 A1|B|Z VDD \$310 pfet L=0.5U W=0.495U AS=0.282P AD=0.141075P
+ PS=1.715U PD=1.065U
* device instance $1500 r0 *1 149.67,41.6575 pfet
M$1500 \$332 A2|A3|B|ZN \$350 \$310 pfet L=0.5U W=0.495U AS=0.141075P
+ AD=0.2178P PS=1.065U PD=1.87U
* device instance $1501 r0 *1 15.095,52.1125 pfet
M$1501 \$432 \$422 \$423 \$396 pfet L=0.5U W=0.915U AS=0.4026P AD=0.2447625P
+ PS=2.71U PD=1.45U
* device instance $1502 r0 *1 16.13,52.1125 pfet
M$1502 \$432 A3|B|ZN VDD \$396 pfet L=0.5U W=0.915U AS=0.571875P AD=0.2447625P
+ PS=2.68U PD=1.45U
* device instance $1503 r0 *1 17.48,51.655 pfet
M$1503 \$424 \$423 VDD \$396 pfet L=0.5U W=1.83U AS=0.571875P AD=0.52155P
+ PS=2.68U PD=2.4U
* device instance $1504 r0 *1 18.55,51.655 pfet
M$1504 A2|A3|Z$3 A3|B|ZN \$424 \$396 pfet L=0.5U W=1.83U AS=0.52155P AD=0.4758P
+ PS=2.4U PD=2.35U
* device instance $1505 r0 *1 19.57,51.655 pfet
M$1505 \$424 \$422 A2|A3|Z$3 \$396 pfet L=0.5U W=1.83U AS=0.4758P AD=1.3176P
+ PS=2.35U PD=5.1U
* device instance $1506 r0 *1 36.15,51.5775 pfet
M$1506 \$426 A1|A2|ZN$2 VDD \$396 pfet L=0.5U W=0.915U AS=0.526125P AD=0.2379P
+ PS=2.58U PD=1.435U
* device instance $1507 r0 *1 37.17,51.5775 pfet
M$1507 VDD A1|A2|A3|ZN \$426 \$396 pfet L=0.5U W=0.915U AS=0.2379P AD=0.4026P
+ PS=1.435U PD=2.71U
* device instance $1508 r0 *1 32.71,51.66 pfet
M$1508 \$434 A1|A2|A3|ZN VDD \$396 pfet L=0.5U W=1.83U AS=0.8052P AD=0.52155P
+ PS=4.54U PD=2.4U
* device instance $1509 r0 *1 33.78,51.66 pfet
M$1509 A1|A2|ZN$3 A1|A2|ZN$2 \$434 \$396 pfet L=0.5U W=1.83U AS=0.52155P
+ AD=0.5673P PS=2.4U PD=2.45U
* device instance $1510 r0 *1 34.9,51.66 pfet
M$1510 VDD \$426 A1|A2|ZN$3 \$396 pfet L=0.5U W=1.83U AS=0.5673P AD=0.526125P
+ PS=2.45U PD=2.58U
* device instance $1511 r0 *1 47.99,51.5675 pfet
M$1511 VDD B|ZN$6 A2|ZN$16 \$396 pfet L=0.5U W=1.645U AS=0.61275P AD=0.7238P
+ PS=2.53U PD=4.17U
* device instance $1512 r0 *1 45.72,51.66 pfet
M$1512 \$436 A2|ZN$20 VDD \$396 pfet L=0.5U W=1.83U AS=0.8052P AD=0.52155P
+ PS=4.54U PD=2.4U
* device instance $1513 r0 *1 46.79,51.66 pfet
M$1513 A2|ZN$16 A1|A2|B|B2|C|Z \$436 \$396 pfet L=0.5U W=1.83U AS=0.52155P
+ AD=0.61275P PS=2.4U PD=2.53U
* device instance $1514 r0 *1 69.85,52.1175 pfet
M$1514 \$437 A1|A2|A3|ZN \$427 \$396 pfet L=0.5U W=0.915U AS=0.4026P
+ AD=0.260775P PS=2.71U PD=1.485U
* device instance $1515 r0 *1 70.92,52.1175 pfet
M$1515 \$437 A1|A2|Z$1 VDD \$396 pfet L=0.5U W=0.915U AS=0.549P AD=0.260775P
+ PS=2.63U PD=1.485U
* device instance $1516 r0 *1 72.22,51.66 pfet
M$1516 \$428 \$427 VDD \$396 pfet L=0.5U W=1.83U AS=0.549P AD=0.52155P PS=2.63U
+ PD=2.4U
* device instance $1517 r0 *1 73.29,51.66 pfet
M$1517 A1|A2|B1|Z A1|A2|Z$1 \$428 \$396 pfet L=0.5U W=1.83U AS=0.52155P
+ AD=0.4758P PS=2.4U PD=2.35U
* device instance $1518 r0 *1 74.31,51.66 pfet
M$1518 \$428 A1|A2|A3|ZN A1|A2|B1|Z \$396 pfet L=0.5U W=1.83U AS=0.4758P
+ AD=0.8052P PS=2.35U PD=4.54U
* device instance $1519 r0 *1 85.53,51.66 pfet
M$1519 \$439 A3|Z$1 VDD \$396 pfet L=0.5U W=1.83U AS=0.8052P AD=0.52155P
+ PS=4.54U PD=2.4U
* device instance $1520 r0 *1 86.6,51.66 pfet
M$1520 \$440 A2|ZN$18 \$439 \$396 pfet L=0.5U W=1.83U AS=0.52155P AD=0.5673P
+ PS=2.4U PD=2.45U
* device instance $1521 r0 *1 87.72,51.66 pfet
M$1521 A3|B|ZN A1|B|Z \$440 \$396 pfet L=0.5U W=1.83U AS=0.5673P AD=0.5673P
+ PS=2.45U PD=2.45U
* device instance $1522 r0 *1 88.84,51.66 pfet
M$1522 \$438 A1|A2|B1|Z A3|B|ZN \$396 pfet L=0.5U W=1.83U AS=0.5673P
+ AD=0.52155P PS=2.45U PD=2.4U
* device instance $1523 r0 *1 89.91,51.66 pfet
M$1523 VDD A3|B2|ZN \$438 \$396 pfet L=0.5U W=1.83U AS=0.52155P AD=0.8052P
+ PS=2.4U PD=4.54U
* device instance $1524 r0 *1 123.56,51.66 pfet
M$1524 \$435 A2|ZN$22 VDD \$396 pfet L=0.5U W=1.83U AS=0.8052P AD=0.5673P
+ PS=4.54U PD=2.45U
* device instance $1525 r0 *1 124.68,51.66 pfet
M$1525 A1|A2|B|ZN A1|ZN$7 \$435 \$396 pfet L=0.5U W=1.83U AS=0.5673P AD=0.8052P
+ PS=2.45U PD=4.54U
* device instance $1526 r0 *1 125.905,49.5975 pfet
M$1526 \$412 A1|ZN \$393 \$396 pfet L=0.5U W=0.915U AS=0.4026P AD=0.2379P
+ PS=2.71U PD=1.435U
* device instance $1527 r0 *1 126.925,49.5975 pfet
M$1527 \$412 A1|A2|I0|ZN VDD \$396 pfet L=0.5U W=0.915U AS=0.57645P AD=0.2379P
+ PS=2.69U PD=1.435U
* device instance $1528 r0 *1 128.285,49.14 pfet
M$1528 A1|Z$2 \$393 VDD \$396 pfet L=0.5U W=1.83U AS=0.57645P AD=0.8052P
+ PS=2.69U PD=4.54U
* device instance $1529 r0 *1 141.43,49.69 pfet
M$1529 VDD A1|Z$2 \$394 \$396 pfet L=0.5U W=0.73U AS=0.3212P AD=0.1898P
+ PS=2.34U PD=1.25U
* device instance $1530 r0 *1 142.45,49.69 pfet
M$1530 \$394 A2|ZN$14 VDD \$396 pfet L=0.5U W=0.73U AS=0.1898P AD=0.1898P
+ PS=1.25U PD=1.25U
* device instance $1531 r0 *1 143.47,49.69 pfet
M$1531 \$394 A2|A3|B|ZN VDD \$396 pfet L=0.5U W=0.73U AS=0.5339P AD=0.1898P
+ PS=2.69U PD=1.25U
* device instance $1532 r0 *1 144.83,49.14 pfet
M$1532 A1|Z$3 \$394 VDD \$396 pfet L=0.5U W=1.83U AS=0.5339P AD=0.8052P
+ PS=2.69U PD=4.54U
* device instance $1533 r0 *1 144.87,51.5675 pfet
M$1533 VDD A1|B|Z A1|ZN$6 \$396 pfet L=0.5U W=1.645U AS=0.61275P AD=0.7238P
+ PS=2.53U PD=4.17U
* device instance $1534 r0 *1 142.6,51.66 pfet
M$1534 \$433 A2|ZN$12 VDD \$396 pfet L=0.5U W=1.83U AS=0.8052P AD=0.52155P
+ PS=4.54U PD=2.4U
* device instance $1535 r0 *1 143.67,51.66 pfet
M$1535 A1|ZN$6 A1|Z$3 \$433 \$396 pfet L=0.5U W=1.83U AS=0.52155P AD=0.61275P
+ PS=2.4U PD=2.53U
* device instance $1536 r0 *1 8.81,51.9825 pfet
M$1536 \$431 A2|ZN$19 \$419 \$396 pfet L=0.5U W=0.495U AS=0.2178P AD=0.1287P
+ PS=1.87U PD=1.015U
* device instance $1537 r0 *1 9.83,51.9825 pfet
M$1537 \$431 A1|ZN$3 VDD \$396 pfet L=0.5U W=0.495U AS=0.294375P AD=0.1287P
+ PS=1.765U PD=1.015U
* device instance $1538 r0 *1 11.18,51.7725 pfet
M$1538 \$421 \$419 VDD \$396 pfet L=0.5U W=0.915U AS=0.294375P AD=0.260775P
+ PS=1.765U PD=1.485U
* device instance $1539 r0 *1 12.25,51.7725 pfet
M$1539 \$422 A1|ZN$3 \$421 \$396 pfet L=0.5U W=0.915U AS=0.260775P AD=0.2379P
+ PS=1.485U PD=1.435U
* device instance $1540 r0 *1 13.27,51.7725 pfet
M$1540 \$421 A2|ZN$19 \$422 \$396 pfet L=0.5U W=0.915U AS=0.2379P AD=0.4026P
+ PS=1.435U PD=2.71U
* device instance $1541 r0 *1 10.44,59.22 pfet
M$1541 \$498 A2|ZN$19 VDD \$472 pfet L=0.5U W=1.83U AS=0.8052P AD=0.5673P
+ PS=4.54U PD=2.45U
* device instance $1542 r0 *1 11.56,59.22 pfet
M$1542 A1|A2|B2|ZN A1|ZN$3 \$498 \$472 pfet L=0.5U W=1.83U AS=0.5673P
+ AD=0.8052P PS=2.45U PD=4.54U
* device instance $1543 r0 *1 13.75,59.22 pfet
M$1543 A2|A4|B1|ZN A2|ZN$19 \$482 \$472 pfet L=0.5U W=1.83U AS=0.8052P
+ AD=0.4758P PS=4.54U PD=2.35U
* device instance $1544 r0 *1 14.77,59.22 pfet
M$1544 \$482 A1|ZN$3 A2|A4|B1|ZN \$472 pfet L=0.5U W=1.83U AS=0.4758P
+ AD=0.6405P PS=2.35U PD=2.53U
* device instance $1545 r0 *1 15.97,59.22 pfet
M$1545 VDD A3|B|ZN \$482 \$472 pfet L=0.5U W=1.83U AS=0.6405P AD=0.8052P
+ PS=2.53U PD=4.54U
* device instance $1546 r0 *1 33.39,59.3025 pfet
M$1546 \$460 A1|A2|B2|Z VDD \$472 pfet L=0.5U W=0.915U AS=0.4026P AD=0.2379P
+ PS=2.71U PD=1.435U
* device instance $1547 r0 *1 34.41,59.3025 pfet
M$1547 \$460 A1|A2|ZN$3 VDD \$472 pfet L=0.5U W=0.915U AS=0.526125P AD=0.2379P
+ PS=2.58U PD=1.435U
* device instance $1548 r0 *1 35.66,59.22 pfet
M$1548 A2|ZN$20 \$460 VDD \$472 pfet L=0.5U W=1.83U AS=0.526125P AD=0.5673P
+ PS=2.58U PD=2.45U
* device instance $1549 r0 *1 36.78,59.22 pfet
M$1549 \$502 A1|A2|ZN$3 A2|ZN$20 \$472 pfet L=0.5U W=1.83U AS=0.5673P
+ AD=0.52155P PS=2.45U PD=2.4U
* device instance $1550 r0 *1 37.85,59.22 pfet
M$1550 VDD A1|A2|B2|Z \$502 \$472 pfet L=0.5U W=1.83U AS=0.52155P AD=0.8052P
+ PS=2.4U PD=4.54U
* device instance $1551 r0 *1 48.505,59.1275 pfet
M$1551 B|ZN$6 A1|A2|ZN$2 VDD \$472 pfet L=0.5U W=1.645U AS=0.7238P AD=0.4277P
+ PS=4.17U PD=2.165U
* device instance $1552 r0 *1 49.525,59.1275 pfet
M$1552 VDD A1|A2|B|B2|C|Z B|ZN$6 \$472 pfet L=0.5U W=1.645U AS=0.4277P
+ AD=0.7238P PS=2.165U PD=4.17U
* device instance $1553 r0 *1 68.665,59.1275 pfet
M$1553 A1|ZN$5 A1|A2|Z$1 VDD \$472 pfet L=0.5U W=1.645U AS=0.7238P AD=0.4277P
+ PS=4.17U PD=2.165U
* device instance $1554 r0 *1 69.685,59.1275 pfet
M$1554 VDD A1|A2|B|B2|C|Z A1|ZN$5 \$472 pfet L=0.5U W=1.645U AS=0.4277P
+ AD=0.7238P PS=2.165U PD=4.17U
* device instance $1555 r0 *1 83.09,59.1875 pfet
M$1555 \$453 A3|B2|ZN VDD \$472 pfet L=0.5U W=0.915U AS=0.535925P AD=0.2379P
+ PS=2.58U PD=1.435U
* device instance $1556 r0 *1 84.11,59.1875 pfet
M$1556 VDD \$463 \$453 \$472 pfet L=0.5U W=0.915U AS=0.2379P AD=0.4026P
+ PS=1.435U PD=2.71U
* device instance $1557 r0 *1 79.65,59.22 pfet
M$1557 \$503 \$463 VDD \$472 pfet L=0.5U W=1.83U AS=0.8052P AD=0.4758P PS=4.54U
+ PD=2.35U
* device instance $1558 r0 *1 80.67,59.22 pfet
M$1558 A1|ZN$10 A3|B2|ZN \$503 \$472 pfet L=0.5U W=1.83U AS=0.4758P AD=0.61305P
+ PS=2.35U PD=2.5U
* device instance $1559 r0 *1 81.84,59.22 pfet
M$1559 VDD \$453 A1|ZN$10 \$472 pfet L=0.5U W=1.83U AS=0.61305P AD=0.535925P
+ PS=2.5U PD=2.58U
* device instance $1560 r0 *1 98.41,58.7625 pfet
M$1560 \$486 A1|A2|Z$1 \$465 \$472 pfet L=0.5U W=0.915U AS=0.4026P AD=0.260775P
+ PS=2.71U PD=1.485U
* device instance $1561 r0 *1 99.48,58.7625 pfet
M$1561 VDD A1|data[6] \$486 \$472 pfet L=0.5U W=0.915U AS=0.260775P AD=0.549P
+ PS=1.485U PD=2.63U
* device instance $1562 r0 *1 100.78,59.22 pfet
M$1562 \$484 \$465 VDD \$472 pfet L=0.5U W=1.83U AS=0.549P AD=0.52155P PS=2.63U
+ PD=2.4U
* device instance $1563 r0 *1 101.85,59.22 pfet
M$1563 A1|A2|Z$2 A1|data[6] \$484 \$472 pfet L=0.5U W=1.83U AS=0.52155P
+ AD=0.4758P PS=2.4U PD=2.35U
* device instance $1564 r0 *1 102.87,59.22 pfet
M$1564 \$484 A1|A2|Z$1 A1|A2|Z$2 \$472 pfet L=0.5U W=1.83U AS=0.4758P
+ AD=0.8052P PS=2.35U PD=4.54U
* device instance $1565 r0 *1 108.395,59.1275 pfet
M$1565 A1|B2|ZN$1 A1|A2|Z$2 VDD \$472 pfet L=0.5U W=1.645U AS=0.7238P
+ AD=0.4277P PS=4.17U PD=2.165U
* device instance $1566 r0 *1 109.415,59.1275 pfet
M$1566 VDD A1|data[7] A1|B2|ZN$1 \$472 pfet L=0.5U W=1.645U AS=0.4277P
+ AD=0.7238P PS=2.165U PD=4.17U
* device instance $1567 r0 *1 109.545,51.7525 pfet
M$1567 B|ZN$5 A1|A2|C|S|ZN VDD \$396 pfet L=0.5U W=1.645U AS=0.7238P AD=0.4277P
+ PS=4.17U PD=2.165U
* device instance $1568 r0 *1 110.565,51.7525 pfet
M$1568 VDD A2|ZN$21 B|ZN$5 \$396 pfet L=0.5U W=1.645U AS=0.4277P AD=0.7238P
+ PS=2.165U PD=4.17U
* device instance $1569 r0 *1 119.035,51.7525 pfet
M$1569 A1|B1|ZN A1|A2|ZN$2 VDD \$396 pfet L=0.5U W=1.645U AS=0.7238P AD=0.4277P
+ PS=4.17U PD=2.165U
* device instance $1570 r0 *1 120.055,51.7525 pfet
M$1570 VDD A1|A2|I|data[0] A1|B1|ZN \$396 pfet L=0.5U W=1.645U AS=0.4277P
+ AD=0.7238P PS=2.165U PD=4.17U
* device instance $1571 r0 *1 123.4,59.22 pfet
M$1571 \$501 A1|B1|ZN A2|ZN$22 \$472 pfet L=0.5U W=1.83U AS=0.8052P AD=0.5673P
+ PS=4.54U PD=2.45U
* device instance $1572 r0 *1 124.52,59.22 pfet
M$1572 VDD A2|B2|ZN \$501 \$472 pfet L=0.5U W=1.83U AS=0.5673P AD=0.8052P
+ PS=2.45U PD=4.54U
* device instance $1573 r0 *1 127.32,59.22 pfet
M$1573 \$500 A1|ZN$8 A1|ZN$7 \$472 pfet L=0.5U W=1.83U AS=0.8052P AD=0.5673P
+ PS=4.54U PD=2.45U
* device instance $1574 r0 *1 128.44,59.22 pfet
M$1574 VDD A2|ZN$25 \$500 \$472 pfet L=0.5U W=1.83U AS=0.5673P AD=0.8052P
+ PS=2.45U PD=4.54U
* device instance $1575 r0 *1 137.4,59.22 pfet
M$1575 \$499 A1|B2|ZN$1 A1|ZN$8 \$472 pfet L=0.5U W=1.83U AS=0.8052P AD=0.5673P
+ PS=4.54U PD=2.45U
* device instance $1576 r0 *1 138.52,59.22 pfet
M$1576 VDD A2|ZN$23 \$499 \$472 pfet L=0.5U W=1.83U AS=0.5673P AD=0.8052P
+ PS=2.45U PD=4.54U
* device instance $1577 r0 *1 140.935,59.22 pfet
M$1577 VDD A1|B2|ZN$1 \$485 \$472 pfet L=0.5U W=1.83U AS=0.8052P AD=0.4758P
+ PS=4.54U PD=2.35U
* device instance $1578 r0 *1 141.955,59.22 pfet
M$1578 \$485 B1|ZN$1 VDD \$472 pfet L=0.5U W=1.83U AS=0.4758P AD=0.4758P
+ PS=2.35U PD=2.35U
* device instance $1579 r0 *1 142.975,59.22 pfet
M$1579 A2|B2|ZN A1|ZN$6 \$485 \$472 pfet L=0.5U W=1.83U AS=0.4758P AD=0.4758P
+ PS=2.35U PD=2.35U
* device instance $1580 r0 *1 143.995,59.22 pfet
M$1580 \$485 A2|ZN$10 A2|B2|ZN \$472 pfet L=0.5U W=1.83U AS=0.4758P AD=0.8052P
+ PS=2.35U PD=4.54U
* device instance $1581 r0 *1 17.81,61.7725 pfet
M$1581 \$506 \$505 VDD \$472 pfet L=0.5U W=0.915U AS=0.4026P AD=0.2379P
+ PS=2.71U PD=1.435U
* device instance $1582 r0 *1 18.83,61.7725 pfet
M$1582 \$506 A3|B|ZN VDD \$472 pfet L=0.5U W=0.915U AS=0.535925P AD=0.2379P
+ PS=2.58U PD=1.435U
* device instance $1583 r0 *1 20.08,61.74 pfet
M$1583 A2|A3|I1|ZN \$506 VDD \$472 pfet L=0.5U W=1.83U AS=0.535925P AD=0.61305P
+ PS=2.58U PD=2.5U
* device instance $1584 r0 *1 21.25,61.74 pfet
M$1584 \$516 A3|B|ZN A2|A3|I1|ZN \$472 pfet L=0.5U W=1.83U AS=0.61305P
+ AD=0.4758P PS=2.5U PD=2.35U
* device instance $1585 r0 *1 22.27,61.74 pfet
M$1585 VDD \$505 \$516 \$472 pfet L=0.5U W=1.83U AS=0.4758P AD=0.8052P PS=2.35U
+ PD=4.54U
* device instance $1586 r0 *1 35.03,61.6575 pfet
M$1586 \$490 A1|ZN$10 VDD \$472 pfet L=0.5U W=0.915U AS=0.526125P AD=0.2379P
+ PS=2.58U PD=1.435U
* device instance $1587 r0 *1 36.05,61.6575 pfet
M$1587 VDD A1|A2|ZN$3 \$490 \$472 pfet L=0.5U W=0.915U AS=0.2379P AD=0.4026P
+ PS=1.435U PD=2.71U
* device instance $1588 r0 *1 31.59,61.74 pfet
M$1588 \$518 A1|A2|ZN$3 VDD \$472 pfet L=0.5U W=1.83U AS=0.8052P AD=0.52155P
+ PS=4.54U PD=2.4U
* device instance $1589 r0 *1 32.66,61.74 pfet
M$1589 A2|B1|I|ZN A1|ZN$10 \$518 \$472 pfet L=0.5U W=1.83U AS=0.52155P
+ AD=0.5673P PS=2.4U PD=2.45U
* device instance $1590 r0 *1 33.78,61.74 pfet
M$1590 VDD \$490 A2|B1|I|ZN \$472 pfet L=0.5U W=1.83U AS=0.5673P AD=0.526125P
+ PS=2.45U PD=2.58U
* device instance $1591 r0 *1 50.85,61.7725 pfet
M$1591 \$510 \$509 VDD \$472 pfet L=0.5U W=0.915U AS=0.4026P AD=0.2379P
+ PS=2.71U PD=1.435U
* device instance $1592 r0 *1 51.87,61.7725 pfet
M$1592 \$510 A2|A3|ZN$1 VDD \$472 pfet L=0.5U W=0.915U AS=0.535925P AD=0.2379P
+ PS=2.58U PD=1.435U
* device instance $1593 r0 *1 53.12,61.74 pfet
M$1593 A2|ZN$24 \$510 VDD \$472 pfet L=0.5U W=1.83U AS=0.535925P AD=0.61305P
+ PS=2.58U PD=2.5U
* device instance $1594 r0 *1 54.29,61.74 pfet
M$1594 \$521 A2|A3|ZN$1 A2|ZN$24 \$472 pfet L=0.5U W=1.83U AS=0.61305P
+ AD=0.4758P PS=2.5U PD=2.35U
* device instance $1595 r0 *1 55.31,61.74 pfet
M$1595 VDD \$509 \$521 \$472 pfet L=0.5U W=1.83U AS=0.4758P AD=0.8052P PS=2.35U
+ PD=4.54U
* device instance $1596 r0 *1 57.435,61.74 pfet
M$1596 D|ZN$10 A2|A3|ZN$1 \$493 \$472 pfet L=0.5U W=1.83U AS=0.8052P AD=0.4758P
+ PS=4.54U PD=2.35U
* device instance $1597 r0 *1 58.455,61.74 pfet
M$1597 \$493 A1|A2|B|B2|C|Z D|ZN$10 \$472 pfet L=0.5U W=1.83U AS=0.4758P
+ AD=0.5673P PS=2.35U PD=2.45U
* device instance $1598 r0 *1 59.575,61.74 pfet
M$1598 \$522 B|ZN$7 \$493 \$472 pfet L=0.5U W=1.83U AS=0.5673P AD=0.5673P
+ PS=2.45U PD=2.45U
* device instance $1599 r0 *1 60.695,61.74 pfet
M$1599 VDD A1|B|C|I|ZN \$522 \$472 pfet L=0.5U W=1.83U AS=0.5673P AD=0.8052P
+ PS=2.45U PD=4.54U
* device instance $1600 r0 *1 73.07,61.74 pfet
M$1600 \$495 A1|B|Z$1 VDD \$472 pfet L=0.5U W=1.83U AS=0.8052P AD=0.6405P
+ PS=4.54U PD=2.53U
* device instance $1601 r0 *1 74.27,61.74 pfet
M$1601 A2|ZN$1 A1|A2|B|ZN \$495 \$472 pfet L=0.5U W=1.83U AS=0.6405P AD=0.4758P
+ PS=2.53U PD=2.35U
* device instance $1602 r0 *1 75.29,61.74 pfet
M$1602 \$495 A1|A2|B|B2|C|Z A2|ZN$1 \$472 pfet L=0.5U W=1.83U AS=0.4758P
+ AD=0.8052P PS=2.35U PD=4.54U
* device instance $1603 r0 *1 89.24,59.1425 pfet
M$1603 \$487 A1|data[6] VDD \$472 pfet L=0.5U W=0.495U AS=0.282P AD=0.141075P
+ PS=1.715U PD=1.065U
* device instance $1604 r0 *1 90.31,59.1425 pfet
M$1604 \$464 A1|A2|A3|ZN \$487 \$472 pfet L=0.5U W=0.495U AS=0.141075P
+ AD=0.2178P PS=1.065U PD=1.87U
* device instance $1605 r0 *1 85.85,59.3525 pfet
M$1605 \$463 A1|A2|A3|ZN \$483 \$472 pfet L=0.5U W=0.915U AS=0.4026P AD=0.2379P
+ PS=2.71U PD=1.435U
* device instance $1606 r0 *1 86.87,59.3525 pfet
M$1606 \$483 A1|data[6] \$463 \$472 pfet L=0.5U W=0.915U AS=0.2379P
+ AD=0.260775P PS=1.435U PD=1.485U
* device instance $1607 r0 *1 87.94,59.3525 pfet
M$1607 VDD \$464 \$483 \$472 pfet L=0.5U W=0.915U AS=0.260775P AD=0.282P
+ PS=1.485U PD=1.715U
* device instance $1608 r0 *1 97.23,61.235 pfet
M$1608 \$496 A1|A2|Z$1 VDD \$472 pfet L=0.5U W=0.82U AS=0.5054P AD=0.2132P
+ PS=2.57U PD=1.34U
* device instance $1609 r0 *1 98.25,61.235 pfet
M$1609 VDD A1|data[6] \$496 \$472 pfet L=0.5U W=0.82U AS=0.2132P AD=0.3608P
+ PS=1.34U PD=2.52U
* device instance $1610 r0 *1 95.99,61.74 pfet
M$1610 VDD \$496 A1|B|Z \$472 pfet L=0.5U W=1.83U AS=0.8052P AD=0.5054P
+ PS=4.54U PD=2.57U
* device instance $1611 r0 *1 108.95,61.6575 pfet
M$1611 \$497 A1|data[7] VDD \$472 pfet L=0.5U W=0.915U AS=0.526125P AD=0.2379P
+ PS=2.58U PD=1.435U
* device instance $1612 r0 *1 109.97,61.6575 pfet
M$1612 VDD A1|A2|Z$2 \$497 \$472 pfet L=0.5U W=0.915U AS=0.2379P AD=0.4026P
+ PS=1.435U PD=2.71U
* device instance $1613 r0 *1 105.51,61.74 pfet
M$1613 \$524 A1|A2|Z$2 VDD \$472 pfet L=0.5U W=1.83U AS=0.8052P AD=0.52155P
+ PS=4.54U PD=2.4U
* device instance $1614 r0 *1 106.58,61.74 pfet
M$1614 A1|A2|ZN$2 A1|data[7] \$524 \$472 pfet L=0.5U W=1.83U AS=0.52155P
+ AD=0.5673P PS=2.4U PD=2.45U
* device instance $1615 r0 *1 107.7,61.74 pfet
M$1615 VDD \$497 A1|A2|ZN$2 \$472 pfet L=0.5U W=1.83U AS=0.5673P AD=0.526125P
+ PS=2.45U PD=2.58U
* device instance $1616 r0 *1 123.61,61.74 pfet
M$1616 \$523 A2|B2|ZN VDD \$472 pfet L=0.5U W=1.83U AS=0.8052P AD=0.52155P
+ PS=4.54U PD=2.4U
* device instance $1617 r0 *1 124.68,61.74 pfet
M$1617 A1|A2|A3|ZN A1|B1|ZN \$523 \$472 pfet L=0.5U W=1.83U AS=0.52155P
+ AD=0.5673P PS=2.4U PD=2.45U
* device instance $1618 r0 *1 125.8,61.74 pfet
M$1618 \$520 A1|ZN$8 A1|A2|A3|ZN \$472 pfet L=0.5U W=1.83U AS=0.5673P
+ AD=0.52155P PS=2.45U PD=2.4U
* device instance $1619 r0 *1 126.87,61.74 pfet
M$1619 VDD A2|ZN$25 \$520 \$472 pfet L=0.5U W=1.83U AS=0.52155P AD=0.8052P
+ PS=2.4U PD=4.54U
* device instance $1620 r0 *1 142.6,61.74 pfet
M$1620 \$517 A2|ZN$12 VDD \$472 pfet L=0.5U W=1.83U AS=0.8052P AD=0.5673P
+ PS=4.54U PD=2.45U
* device instance $1621 r0 *1 143.72,61.74 pfet
M$1621 A2|ZN$23 A1|Z$3 \$517 \$472 pfet L=0.5U W=1.83U AS=0.5673P AD=0.8052P
+ PS=2.45U PD=4.54U
* device instance $1622 r0 *1 11.61,61.8175 pfet
M$1622 \$515 A2|ZN$19 \$504 \$472 pfet L=0.5U W=0.495U AS=0.2178P AD=0.141075P
+ PS=1.87U PD=1.065U
* device instance $1623 r0 *1 12.68,61.8175 pfet
M$1623 \$515 A1|ZN$3 VDD \$472 pfet L=0.5U W=0.495U AS=0.282P AD=0.141075P
+ PS=1.715U PD=1.065U
* device instance $1624 r0 *1 13.98,61.6075 pfet
M$1624 \$488 \$504 VDD \$472 pfet L=0.5U W=0.915U AS=0.282P AD=0.260775P
+ PS=1.715U PD=1.485U
* device instance $1625 r0 *1 15.05,61.6075 pfet
M$1625 \$505 A1|ZN$3 \$488 \$472 pfet L=0.5U W=0.915U AS=0.260775P AD=0.2379P
+ PS=1.485U PD=1.435U
* device instance $1626 r0 *1 16.07,61.6075 pfet
M$1626 \$488 A2|ZN$19 \$505 \$472 pfet L=0.5U W=0.915U AS=0.2379P AD=0.4026P
+ PS=1.435U PD=2.71U
* device instance $1627 r0 *1 12.73,69.3 pfet
M$1627 \$571 A1|A2|B2|ZN VDD \$565 pfet L=0.5U W=1.83U AS=0.8052P AD=0.52155P
+ PS=4.54U PD=2.4U
* device instance $1628 r0 *1 13.8,69.3 pfet
M$1628 A1|A2|ZN$4 A2|A4|B1|ZN \$571 \$565 pfet L=0.5U W=1.83U AS=0.52155P
+ AD=0.5673P PS=2.4U PD=2.45U
* device instance $1629 r0 *1 14.92,69.3 pfet
M$1629 \$572 A1|ZN$9 A1|A2|ZN$4 \$565 pfet L=0.5U W=1.83U AS=0.5673P
+ AD=0.52155P PS=2.45U PD=2.4U
* device instance $1630 r0 *1 15.99,69.3 pfet
M$1630 VDD A2|A3|I1|ZN \$572 \$565 pfet L=0.5U W=1.83U AS=0.52155P AD=0.8052P
+ PS=2.4U PD=4.54U
* device instance $1631 r0 *1 31,69.3 pfet
M$1631 \$573 A1|ZN$10 A1|A2|I|ZN \$565 pfet L=0.5U W=1.83U AS=0.8052P
+ AD=0.5673P PS=4.54U PD=2.45U
* device instance $1632 r0 *1 32.12,69.3 pfet
M$1632 VDD A1|A2|ZN$3 \$573 \$565 pfet L=0.5U W=1.83U AS=0.5673P AD=0.8052P
+ PS=2.45U PD=4.54U
* device instance $1633 r0 *1 36.75,69.3825 pfet
M$1633 \$543 A2|B1|I|ZN VDD \$565 pfet L=0.5U W=0.915U AS=0.4026P AD=0.2379P
+ PS=2.71U PD=1.435U
* device instance $1634 r0 *1 37.77,69.3825 pfet
M$1634 \$543 A1|B3|ZN VDD \$565 pfet L=0.5U W=0.915U AS=0.526125P AD=0.2379P
+ PS=2.58U PD=1.435U
* device instance $1635 r0 *1 39.02,69.3 pfet
M$1635 A2|A3|ZN$1 \$543 VDD \$565 pfet L=0.5U W=1.83U AS=0.526125P AD=0.5673P
+ PS=2.58U PD=2.45U
* device instance $1636 r0 *1 40.14,69.3 pfet
M$1636 \$574 A1|B3|ZN A2|A3|ZN$1 \$565 pfet L=0.5U W=1.83U AS=0.5673P
+ AD=0.52155P PS=2.45U PD=2.4U
* device instance $1637 r0 *1 41.21,69.3 pfet
M$1637 VDD A2|B1|I|ZN \$574 \$565 pfet L=0.5U W=1.83U AS=0.52155P AD=0.8052P
+ PS=2.4U PD=4.54U
* device instance $1638 r0 *1 44.65,61.8175 pfet
M$1638 \$519 A1|A2|B2|Z \$507 \$472 pfet L=0.5U W=0.495U AS=0.2178P
+ AD=0.141075P PS=1.87U PD=1.065U
* device instance $1639 r0 *1 45.72,61.8175 pfet
M$1639 \$519 A1|A2|B|ZN VDD \$472 pfet L=0.5U W=0.495U AS=0.282P AD=0.141075P
+ PS=1.715U PD=1.065U
* device instance $1640 r0 *1 47.02,61.6075 pfet
M$1640 \$491 \$507 VDD \$472 pfet L=0.5U W=0.915U AS=0.282P AD=0.260775P
+ PS=1.715U PD=1.485U
* device instance $1641 r0 *1 48.09,61.6075 pfet
M$1641 \$509 A1|A2|B|ZN \$491 \$472 pfet L=0.5U W=0.915U AS=0.260775P
+ AD=0.2379P PS=1.485U PD=1.435U
* device instance $1642 r0 *1 49.11,61.6075 pfet
M$1642 \$491 A1|A2|B2|Z \$509 \$472 pfet L=0.5U W=0.915U AS=0.2379P AD=0.4026P
+ PS=1.435U PD=2.71U
* device instance $1643 r0 *1 56.36,69.3 pfet
M$1643 \$575 A2|ZN$24 VDD \$565 pfet L=0.5U W=1.83U AS=0.8052P AD=0.5673P
+ PS=4.54U PD=2.45U
* device instance $1644 r0 *1 57.48,69.3 pfet
M$1644 B|ZN$7 A1|A2|B|B2|C|Z \$575 \$565 pfet L=0.5U W=1.83U AS=0.5673P
+ AD=0.8052P PS=2.45U PD=4.54U
* device instance $1645 r0 *1 62.01,69.075 pfet
M$1645 VDD CLK|clk \$546 \$565 pfet L=0.5U W=1.38U AS=0.6072P AD=0.3588P
+ PS=3.64U PD=1.9U
* device instance $1646 r0 *1 63.03,69.075 pfet
M$1646 \$547 \$546 VDD \$565 pfet L=0.5U W=1.38U AS=0.3588P AD=0.6072P PS=1.9U
+ PD=3.64U
* device instance $1647 r0 *1 65.07,68.885 pfet
M$1647 \$570 \$547 VDD \$565 pfet L=0.5U W=1U AS=0.9696P AD=0.12P PS=5.04U
+ PD=1.24U
* device instance $1648 r0 *1 65.81,68.885 pfet
M$1648 \$548 D|ZN$10 \$570 \$565 pfet L=0.5U W=1U AS=0.12P AD=0.4P PS=1.24U
+ PD=1.8U
* device instance $1649 r0 *1 67.11,68.885 pfet
M$1649 \$569 \$546 \$548 \$565 pfet L=0.5U W=1U AS=0.4P AD=0.12P PS=1.8U
+ PD=1.24U
* device instance $1650 r0 *1 67.85,68.885 pfet
M$1650 VDD \$549 \$569 \$565 pfet L=0.5U W=1U AS=0.12P AD=0.26P PS=1.24U
+ PD=1.52U
* device instance $1651 r0 *1 68.87,68.885 pfet
M$1651 \$549 \$548 VDD \$565 pfet L=0.5U W=1U AS=0.26P AD=0.26P PS=1.52U
+ PD=1.52U
* device instance $1652 r0 *1 69.89,68.885 pfet
M$1652 \$550 \$546 \$549 \$565 pfet L=0.5U W=1U AS=0.26P AD=0.6P PS=1.52U
+ PD=2.2U
* device instance $1653 r0 *1 71.59,68.885 pfet
M$1653 \$568 \$547 \$550 \$565 pfet L=0.5U W=1U AS=0.6P AD=0.13P PS=2.2U
+ PD=1.26U
* device instance $1654 r0 *1 72.35,68.885 pfet
M$1654 VDD \$551 \$568 \$565 pfet L=0.5U W=1U AS=0.13P AD=0.442P PS=1.26U
+ PD=1.94U
* device instance $1655 r0 *1 73.69,68.935 pfet
M$1655 \$551 \$550 VDD \$565 pfet L=0.5U W=1.1U AS=0.442P AD=0.484P PS=1.94U
+ PD=3.08U
* device instance $1656 r0 *1 75.43,69.3 pfet
M$1656 A1|I|Q \$551 VDD \$565 pfet L=0.5U W=1.83U AS=0.8052P AD=0.8052P
+ PS=4.54U PD=4.54U
* device instance $1657 r0 *1 106.19,69.3825 pfet
M$1657 \$555 A1|A2|B2|Z VDD \$565 pfet L=0.5U W=0.915U AS=0.4026P AD=0.2379P
+ PS=2.71U PD=1.435U
* device instance $1658 r0 *1 107.21,69.3825 pfet
M$1658 \$555 A1|A2|Z$2 VDD \$565 pfet L=0.5U W=0.915U AS=0.526125P AD=0.2379P
+ PS=2.58U PD=1.435U
* device instance $1659 r0 *1 108.46,69.3 pfet
M$1659 A2|ZN$21 \$555 VDD \$565 pfet L=0.5U W=1.83U AS=0.526125P AD=0.5673P
+ PS=2.58U PD=2.45U
* device instance $1660 r0 *1 109.58,69.3 pfet
M$1660 \$577 A1|A2|Z$2 A2|ZN$21 \$565 pfet L=0.5U W=1.83U AS=0.5673P
+ AD=0.52155P PS=2.45U PD=2.4U
* device instance $1661 r0 *1 110.65,69.3 pfet
M$1661 VDD A1|A2|B2|Z \$577 \$565 pfet L=0.5U W=1.83U AS=0.52155P AD=0.8052P
+ PS=2.4U PD=4.54U
* device instance $1662 r0 *1 142.025,69.2075 pfet
M$1662 A2|ZN$25 A1|ZN$6 VDD \$565 pfet L=0.5U W=1.645U AS=0.7238P AD=0.4277P
+ PS=4.17U PD=2.165U
* device instance $1663 r0 *1 143.045,69.2075 pfet
M$1663 VDD A2|ZN$10 A2|ZN$25 \$565 pfet L=0.5U W=1.645U AS=0.4277P AD=0.7238P
+ PS=2.165U PD=4.17U
* device instance $1664 r0 *1 10.95,71.82 pfet
M$1664 A1|ZN$9 A1|A2|I|ZN VDD \$565 pfet L=0.5U W=1.83U AS=0.8052P AD=0.8052P
+ PS=4.54U PD=4.54U
* device instance $1665 r0 *1 13.8,71.82 pfet
M$1665 \$593 A2|A4|B1|ZN VDD \$565 pfet L=0.5U W=1.83U AS=0.8052P AD=0.5673P
+ PS=4.54U PD=2.45U
* device instance $1666 r0 *1 14.92,71.82 pfet
M$1666 A2|ZN$27 A1|A2|B2|ZN \$593 \$565 pfet L=0.5U W=1.83U AS=0.5673P
+ AD=0.8052P PS=2.45U PD=4.54U
* device instance $1667 r0 *1 27.64,71.82 pfet
M$1667 \$595 A1|A2|A3|ZN S|ZN \$565 pfet L=0.5U W=1.83U AS=0.8052P AD=0.5673P
+ PS=4.54U PD=2.45U
* device instance $1668 r0 *1 28.76,71.82 pfet
M$1668 VDD A2|B1|I|ZN \$595 \$565 pfet L=0.5U W=1.83U AS=0.5673P AD=0.8052P
+ PS=2.45U PD=4.54U
* device instance $1669 r0 *1 32.12,71.82 pfet
M$1669 \$596 A1|I|Q A2|ZN$28 \$565 pfet L=0.5U W=1.83U AS=0.8052P AD=0.5673P
+ PS=4.54U PD=2.45U
* device instance $1670 r0 *1 33.24,71.82 pfet
M$1670 VDD A1|A2|A3|ZN \$596 \$565 pfet L=0.5U W=1.83U AS=0.5673P AD=0.8052P
+ PS=2.45U PD=4.54U
* device instance $1671 r0 *1 36.09,71.82 pfet
M$1671 VDD A1|I|Q A1|B3|ZN \$565 pfet L=0.5U W=1.83U AS=0.8052P AD=0.8052P
+ PS=4.54U PD=4.54U
* device instance $1672 r0 *1 49.035,71.9125 pfet
M$1672 A1|ZN$11 A2|A3|ZN$1 VDD \$565 pfet L=0.5U W=1.645U AS=0.7238P AD=0.4277P
+ PS=4.17U PD=2.165U
* device instance $1673 r0 *1 50.055,71.9125 pfet
M$1673 VDD A1|A2|B|ZN A1|ZN$11 \$565 pfet L=0.5U W=1.645U AS=0.4277P AD=0.7238P
+ PS=2.165U PD=4.17U
* device instance $1674 r0 *1 80.99,71.7375 pfet
M$1674 \$581 A1|A2|ZN$4 VDD \$565 pfet L=0.5U W=0.915U AS=0.4026P AD=0.2379P
+ PS=2.71U PD=1.435U
* device instance $1675 r0 *1 82.01,71.7375 pfet
M$1675 \$581 A1|A2|A3|ZN VDD \$565 pfet L=0.5U W=0.915U AS=0.526125P AD=0.2379P
+ PS=2.58U PD=1.435U
* device instance $1676 r0 *1 83.26,71.82 pfet
M$1676 B|ZN$8 \$581 VDD \$565 pfet L=0.5U W=1.83U AS=0.526125P AD=0.5673P
+ PS=2.58U PD=2.45U
* device instance $1677 r0 *1 84.38,71.82 pfet
M$1677 \$600 A1|A2|A3|ZN B|ZN$8 \$565 pfet L=0.5U W=1.83U AS=0.5673P
+ AD=0.52155P PS=2.45U PD=2.4U
* device instance $1678 r0 *1 85.45,71.82 pfet
M$1678 VDD A1|A2|ZN$4 \$600 \$565 pfet L=0.5U W=1.83U AS=0.52155P AD=0.8052P
+ PS=2.4U PD=4.54U
* device instance $1679 r0 *1 91.69,71.82 pfet
M$1679 \$601 A4|Z VDD \$565 pfet L=0.5U W=1.83U AS=0.8052P AD=0.52155P PS=4.54U
+ PD=2.4U
* device instance $1680 r0 *1 92.76,71.82 pfet
M$1680 \$602 A1|A3|I|Q \$601 \$565 pfet L=0.5U W=1.83U AS=0.52155P AD=0.5673P
+ PS=2.4U PD=2.45U
* device instance $1681 r0 *1 93.88,71.82 pfet
M$1681 \$603 A1|A2|Q \$602 \$565 pfet L=0.5U W=1.83U AS=0.5673P AD=0.52155P
+ PS=2.45U PD=2.4U
* device instance $1682 r0 *1 94.95,71.82 pfet
M$1682 A2|ZN$26 A1|I|Q \$603 \$565 pfet L=0.5U W=1.83U AS=0.52155P AD=0.8052P
+ PS=2.4U PD=4.54U
* device instance $1683 r0 *1 93.985,69.7575 pfet
M$1683 \$576 A1|Z$4 \$553 \$565 pfet L=0.5U W=0.915U AS=0.4026P AD=0.2379P
+ PS=2.71U PD=1.435U
* device instance $1684 r0 *1 95.005,69.7575 pfet
M$1684 \$576 A2|ZN$26 VDD \$565 pfet L=0.5U W=0.915U AS=0.57645P AD=0.2379P
+ PS=2.69U PD=1.435U
* device instance $1685 r0 *1 96.365,69.3 pfet
M$1685 A1|A2|B|B2|C|Z \$553 VDD \$565 pfet L=0.5U W=1.83U AS=0.57645P
+ AD=0.8052P PS=2.69U PD=4.54U
* device instance $1686 r0 *1 106.25,72.2775 pfet
M$1686 \$604 A1|A2|ZN$4 \$583 \$565 pfet L=0.5U W=0.915U AS=0.4026P
+ AD=0.260775P PS=2.71U PD=1.485U
* device instance $1687 r0 *1 107.32,72.2775 pfet
M$1687 \$604 A1|Q VDD \$565 pfet L=0.5U W=0.915U AS=0.549P AD=0.260775P
+ PS=2.63U PD=1.485U
* device instance $1688 r0 *1 108.62,71.82 pfet
M$1688 \$585 \$583 VDD \$565 pfet L=0.5U W=1.83U AS=0.549P AD=0.52155P PS=2.63U
+ PD=2.4U
* device instance $1689 r0 *1 109.69,71.82 pfet
M$1689 A1|A2|B2|Z A1|Q \$585 \$565 pfet L=0.5U W=1.83U AS=0.52155P AD=0.4758P
+ PS=2.4U PD=2.35U
* device instance $1690 r0 *1 110.71,71.82 pfet
M$1690 \$585 A1|A2|ZN$4 A1|A2|B2|Z \$565 pfet L=0.5U W=1.83U AS=0.4758P
+ AD=0.8052P PS=2.35U PD=4.54U
* device instance $1691 r0 *1 114.04,71.82 pfet
M$1691 \$599 A2|ZN$29 VDD \$565 pfet L=0.5U W=1.83U AS=0.8052P AD=0.5673P
+ PS=4.54U PD=2.45U
* device instance $1692 r0 *1 115.16,71.82 pfet
M$1692 D|ZN$11 A1|B|C|I|ZN \$599 \$565 pfet L=0.5U W=1.83U AS=0.5673P
+ AD=0.8052P PS=2.45U PD=4.54U
* device instance $1693 r0 *1 124.07,69.805 pfet
M$1693 \$557 A1|A2|C|S|ZN VDD \$565 pfet L=0.5U W=0.82U AS=0.3608P AD=0.2132P
+ PS=2.52U PD=1.34U
* device instance $1694 r0 *1 125.09,69.805 pfet
M$1694 \$557 A1|A2|B2|Z VDD \$565 pfet L=0.5U W=0.82U AS=0.5054P AD=0.2132P
+ PS=2.57U PD=1.34U
* device instance $1695 r0 *1 126.33,69.3 pfet
M$1695 A1|B|Z$1 \$557 VDD \$565 pfet L=0.5U W=1.83U AS=0.5054P AD=0.8052P
+ PS=2.57U PD=4.54U
* device instance $1696 r0 *1 144.31,71.82 pfet
M$1696 A1|Q \$592 VDD \$565 pfet L=0.5U W=1.83U AS=0.8052P AD=0.8052P PS=4.54U
+ PD=4.54U
* device instance $1697 r0 *1 54.21,79.3475 pfet
M$1697 \$633 \$625 VDD \$657 pfet L=0.5U W=0.915U AS=0.4026P AD=0.2379P
+ PS=2.71U PD=1.435U
* device instance $1698 r0 *1 55.23,79.3475 pfet
M$1698 \$633 A1|A3|B1|ZN VDD \$657 pfet L=0.5U W=0.915U AS=0.535925P AD=0.2379P
+ PS=2.58U PD=1.435U
* device instance $1699 r0 *1 56.48,79.38 pfet
M$1699 A2|ZN$32 \$633 VDD \$657 pfet L=0.5U W=1.83U AS=0.535925P AD=0.61305P
+ PS=2.58U PD=2.5U
* device instance $1700 r0 *1 57.65,79.38 pfet
M$1700 \$677 A1|A3|B1|ZN A2|ZN$32 \$657 pfet L=0.5U W=1.83U AS=0.61305P
+ AD=0.4758P PS=2.5U PD=2.35U
* device instance $1701 r0 *1 58.67,79.38 pfet
M$1701 VDD \$625 \$677 \$657 pfet L=0.5U W=1.83U AS=0.4758P AD=0.8052P PS=2.35U
+ PD=4.54U
* device instance $1702 r0 *1 65.93,79.155 pfet
M$1702 VDD CLK|clk \$634 \$657 pfet L=0.5U W=1.38U AS=0.6072P AD=0.3588P
+ PS=3.64U PD=1.9U
* device instance $1703 r0 *1 66.95,79.155 pfet
M$1703 \$627 \$634 VDD \$657 pfet L=0.5U W=1.38U AS=0.3588P AD=0.6072P PS=1.9U
+ PD=3.64U
* device instance $1704 r0 *1 68.99,78.965 pfet
M$1704 \$672 \$627 VDD \$657 pfet L=0.5U W=1U AS=0.9696P AD=0.12P PS=5.04U
+ PD=1.24U
* device instance $1705 r0 *1 69.73,78.965 pfet
M$1705 \$635 D|ZN$13 \$672 \$657 pfet L=0.5U W=1U AS=0.12P AD=0.4P PS=1.24U
+ PD=1.8U
* device instance $1706 r0 *1 71.03,78.965 pfet
M$1706 \$671 \$634 \$635 \$657 pfet L=0.5U W=1U AS=0.4P AD=0.12P PS=1.8U
+ PD=1.24U
* device instance $1707 r0 *1 71.77,78.965 pfet
M$1707 VDD \$636 \$671 \$657 pfet L=0.5U W=1U AS=0.12P AD=0.26P PS=1.24U
+ PD=1.52U
* device instance $1708 r0 *1 72.79,78.965 pfet
M$1708 \$636 \$635 VDD \$657 pfet L=0.5U W=1U AS=0.26P AD=0.26P PS=1.52U
+ PD=1.52U
* device instance $1709 r0 *1 73.81,78.965 pfet
M$1709 \$637 \$634 \$636 \$657 pfet L=0.5U W=1U AS=0.26P AD=0.6P PS=1.52U
+ PD=2.2U
* device instance $1710 r0 *1 75.51,78.965 pfet
M$1710 \$670 \$627 \$637 \$657 pfet L=0.5U W=1U AS=0.6P AD=0.13P PS=2.2U
+ PD=1.26U
* device instance $1711 r0 *1 76.27,78.965 pfet
M$1711 VDD \$638 \$670 \$657 pfet L=0.5U W=1U AS=0.13P AD=0.442P PS=1.26U
+ PD=1.94U
* device instance $1712 r0 *1 77.61,79.015 pfet
M$1712 \$638 \$637 VDD \$657 pfet L=0.5U W=1.1U AS=0.442P AD=0.484P PS=1.94U
+ PD=3.08U
* device instance $1713 r0 *1 79.35,79.38 pfet
M$1713 A1|A2|I|Q \$638 VDD \$657 pfet L=0.5U W=1.83U AS=0.8052P AD=0.8052P
+ PS=4.54U PD=4.54U
* device instance $1714 r0 *1 81.51,79.38 pfet
M$1714 A2|ZN$30 A2|Z$3 \$663 \$657 pfet L=0.5U W=1.83U AS=0.8052P AD=0.4758P
+ PS=4.54U PD=2.35U
* device instance $1715 r0 *1 82.53,79.38 pfet
M$1715 \$663 A1|ZN$12 A2|ZN$30 \$657 pfet L=0.5U W=1.83U AS=0.4758P AD=0.6405P
+ PS=2.35U PD=2.53U
* device instance $1716 r0 *1 83.73,79.38 pfet
M$1716 VDD B|ZN$8 \$663 \$657 pfet L=0.5U W=1.83U AS=0.6405P AD=0.8052P
+ PS=2.53U PD=4.54U
* device instance $1717 r0 *1 94.28,79.38 pfet
M$1717 \$678 A1|Z$4 A1|A2|C|S|ZN \$657 pfet L=0.5U W=1.83U AS=0.8052P
+ AD=0.5673P PS=4.54U PD=2.45U
* device instance $1718 r0 *1 95.4,79.38 pfet
M$1718 VDD A2|ZN$26 \$678 \$657 pfet L=0.5U W=1.83U AS=0.5673P AD=0.8052P
+ PS=2.45U PD=4.54U
* device instance $1719 r0 *1 112.41,79.155 pfet
M$1719 VDD CLK|clk \$639 \$657 pfet L=0.5U W=1.38U AS=0.6072P AD=0.3588P
+ PS=3.64U PD=1.9U
* device instance $1720 r0 *1 113.43,79.155 pfet
M$1720 \$629 \$639 VDD \$657 pfet L=0.5U W=1.38U AS=0.3588P AD=0.6072P PS=1.9U
+ PD=3.64U
* device instance $1721 r0 *1 115.47,78.965 pfet
M$1721 \$669 \$629 VDD \$657 pfet L=0.5U W=1U AS=0.9696P AD=0.12P PS=5.04U
+ PD=1.24U
* device instance $1722 r0 *1 116.21,78.965 pfet
M$1722 \$640 D|ZN$11 \$669 \$657 pfet L=0.5U W=1U AS=0.12P AD=0.4P PS=1.24U
+ PD=1.8U
* device instance $1723 r0 *1 117.51,78.965 pfet
M$1723 \$668 \$639 \$640 \$657 pfet L=0.5U W=1U AS=0.4P AD=0.12P PS=1.8U
+ PD=1.24U
* device instance $1724 r0 *1 118.25,78.965 pfet
M$1724 VDD \$641 \$668 \$657 pfet L=0.5U W=1U AS=0.12P AD=0.26P PS=1.24U
+ PD=1.52U
* device instance $1725 r0 *1 119.27,78.965 pfet
M$1725 \$641 \$640 VDD \$657 pfet L=0.5U W=1U AS=0.26P AD=0.26P PS=1.52U
+ PD=1.52U
* device instance $1726 r0 *1 120.29,78.965 pfet
M$1726 \$642 \$639 \$641 \$657 pfet L=0.5U W=1U AS=0.26P AD=0.6P PS=1.52U
+ PD=2.2U
* device instance $1727 r0 *1 121.99,78.965 pfet
M$1727 \$665 \$629 \$642 \$657 pfet L=0.5U W=1U AS=0.6P AD=0.13P PS=2.2U
+ PD=1.26U
* device instance $1728 r0 *1 122.75,78.965 pfet
M$1728 VDD \$643 \$665 \$657 pfet L=0.5U W=1U AS=0.13P AD=0.442P PS=1.26U
+ PD=1.94U
* device instance $1729 r0 *1 124.09,79.015 pfet
M$1729 \$643 \$642 VDD \$657 pfet L=0.5U W=1.1U AS=0.442P AD=0.484P PS=1.94U
+ PD=3.08U
* device instance $1730 r0 *1 125.83,79.38 pfet
M$1730 A1|A2|Q \$643 VDD \$657 pfet L=0.5U W=1.83U AS=0.8052P AD=0.8052P
+ PS=4.54U PD=4.54U
* device instance $1731 r0 *1 130.89,72.045 pfet
M$1731 VDD CLK|clk \$587 \$565 pfet L=0.5U W=1.38U AS=0.6072P AD=0.3588P
+ PS=3.64U PD=1.9U
* device instance $1732 r0 *1 131.91,72.045 pfet
M$1732 \$588 \$587 VDD \$565 pfet L=0.5U W=1.38U AS=0.3588P AD=0.6072P PS=1.9U
+ PD=3.64U
* device instance $1733 r0 *1 133.55,79.38 pfet
M$1733 \$664 A1|B|C|I|ZN VDD \$657 pfet L=0.5U W=1.83U AS=0.8052P AD=0.6405P
+ PS=4.54U PD=2.53U
* device instance $1734 r0 *1 134.75,79.38 pfet
M$1734 D|ZN$12 A1|ZN$19 \$664 \$657 pfet L=0.5U W=1.83U AS=0.6405P AD=0.4758P
+ PS=2.53U PD=2.35U
* device instance $1735 r0 *1 135.77,79.38 pfet
M$1735 \$664 A2|ZN$31 D|ZN$12 \$657 pfet L=0.5U W=1.83U AS=0.4758P AD=0.8052P
+ PS=2.35U PD=4.54U
* device instance $1736 r0 *1 133.95,72.235 pfet
M$1736 \$598 \$588 VDD \$565 pfet L=0.5U W=1U AS=0.9696P AD=0.12P PS=5.04U
+ PD=1.24U
* device instance $1737 r0 *1 134.69,72.235 pfet
M$1737 \$589 D|ZN$12 \$598 \$565 pfet L=0.5U W=1U AS=0.12P AD=0.4P PS=1.24U
+ PD=1.8U
* device instance $1738 r0 *1 135.99,72.235 pfet
M$1738 \$597 \$587 \$589 \$565 pfet L=0.5U W=1U AS=0.4P AD=0.12P PS=1.8U
+ PD=1.24U
* device instance $1739 r0 *1 136.73,72.235 pfet
M$1739 VDD \$590 \$597 \$565 pfet L=0.5U W=1U AS=0.12P AD=0.26P PS=1.24U
+ PD=1.52U
* device instance $1740 r0 *1 137.75,72.235 pfet
M$1740 \$590 \$589 VDD \$565 pfet L=0.5U W=1U AS=0.26P AD=0.26P PS=1.52U
+ PD=1.52U
* device instance $1741 r0 *1 138.77,72.235 pfet
M$1741 \$591 \$587 \$590 \$565 pfet L=0.5U W=1U AS=0.26P AD=0.6P PS=1.52U
+ PD=2.2U
* device instance $1742 r0 *1 140.47,72.235 pfet
M$1742 \$594 \$588 \$591 \$565 pfet L=0.5U W=1U AS=0.6P AD=0.13P PS=2.2U
+ PD=1.26U
* device instance $1743 r0 *1 141.23,72.235 pfet
M$1743 \$594 \$592 VDD \$565 pfet L=0.5U W=1U AS=0.442P AD=0.13P PS=1.94U
+ PD=1.26U
* device instance $1744 r0 *1 142.57,72.185 pfet
M$1744 \$592 \$591 VDD \$565 pfet L=0.5U W=1.1U AS=0.442P AD=0.484P PS=1.94U
+ PD=3.08U
* device instance $1745 r0 *1 12.17,79.8375 pfet
M$1745 \$675 A1|ZN$9 \$619 \$657 pfet L=0.5U W=0.915U AS=0.4026P AD=0.32025P
+ PS=2.71U PD=1.615U
* device instance $1746 r0 *1 13.37,79.8375 pfet
M$1746 \$676 A1|A2|B2|ZN \$675 \$657 pfet L=0.5U W=0.915U AS=0.32025P
+ AD=0.306525P PS=1.615U PD=1.585U
* device instance $1747 r0 *1 14.54,79.8375 pfet
M$1747 \$674 A2|A3|I1|ZN \$676 \$657 pfet L=0.5U W=0.915U AS=0.306525P
+ AD=0.343125P PS=1.585U PD=1.665U
* device instance $1748 r0 *1 15.79,79.8375 pfet
M$1748 \$674 A2|A4|B1|ZN VDD \$657 pfet L=0.5U W=0.915U AS=0.549P AD=0.343125P
+ PS=2.63U PD=1.665U
* device instance $1749 r0 *1 17.09,79.38 pfet
M$1749 A2|A3|Z$2 \$619 VDD \$657 pfet L=0.5U W=1.83U AS=0.549P AD=0.8052P
+ PS=2.63U PD=4.54U
* device instance $1750 r0 *1 11.55,81.8175 pfet
M$1750 \$679 A2|A3|Z$3 VDD \$657 pfet L=0.5U W=0.915U AS=0.4026P AD=0.2379P
+ PS=2.71U PD=1.435U
* device instance $1751 r0 *1 12.57,81.8175 pfet
M$1751 \$679 A1|ZN$9 VDD \$657 pfet L=0.5U W=0.915U AS=0.526125P AD=0.2379P
+ PS=2.58U PD=1.435U
* device instance $1752 r0 *1 13.82,81.9 pfet
M$1752 A1|I0|ZN \$679 VDD \$657 pfet L=0.5U W=1.83U AS=0.526125P AD=0.5673P
+ PS=2.58U PD=2.45U
* device instance $1753 r0 *1 14.94,81.9 pfet
M$1753 \$696 A1|ZN$9 A1|I0|ZN \$657 pfet L=0.5U W=1.83U AS=0.5673P AD=0.52155P
+ PS=2.45U PD=2.4U
* device instance $1754 r0 *1 16.01,81.9 pfet
M$1754 VDD A2|A3|Z$3 \$696 \$657 pfet L=0.5U W=1.83U AS=0.52155P AD=0.8052P
+ PS=2.4U PD=4.54U
* device instance $1755 r0 *1 24.25,78.9275 pfet
M$1755 VDD S|ZN \$621 \$657 pfet L=0.5U W=0.915U AS=0.4026P AD=0.2379P PS=2.71U
+ PD=1.435U
* device instance $1756 r0 *1 25.27,78.9275 pfet
M$1756 \$666 A1|I0|ZN VDD \$657 pfet L=0.5U W=0.915U AS=0.2379P AD=0.1098P
+ PS=1.435U PD=1.155U
* device instance $1757 r0 *1 26.01,78.9275 pfet
M$1757 \$622 S|ZN \$666 \$657 pfet L=0.5U W=0.915U AS=0.1098P AD=0.2379P
+ PS=1.155U PD=1.435U
* device instance $1758 r0 *1 27.03,78.9275 pfet
M$1758 \$667 \$621 \$622 \$657 pfet L=0.5U W=0.915U AS=0.2379P AD=0.1258125P
+ PS=1.435U PD=1.19U
* device instance $1759 r0 *1 27.805,78.9275 pfet
M$1759 VDD A2|A3|I1|ZN \$667 \$657 pfet L=0.5U W=0.915U AS=0.1258125P
+ AD=0.6244875P PS=1.19U PD=2.795U
* device instance $1760 r0 *1 29.27,79.385 pfet
M$1760 A2|Z$2 \$622 VDD \$657 pfet L=0.5U W=1.83U AS=0.6244875P AD=0.8052P
+ PS=2.795U PD=4.54U
* device instance $1761 r0 *1 37.32,81.9 pfet
M$1761 \$698 A2|B1|I|ZN VDD \$657 pfet L=0.5U W=1.83U AS=0.8052P AD=0.5673P
+ PS=4.54U PD=2.45U
* device instance $1762 r0 *1 38.44,81.9 pfet
M$1762 A1|A3|B1|ZN A1|B3|ZN \$698 \$657 pfet L=0.5U W=1.83U AS=0.5673P
+ AD=0.8052P PS=2.45U PD=4.54U
* device instance $1763 r0 *1 39.51,79.885 pfet
M$1763 \$631 A1|A2|ZN$4 VDD \$657 pfet L=0.5U W=0.82U AS=0.3608P AD=0.2132P
+ PS=2.52U PD=1.34U
* device instance $1764 r0 *1 40.53,79.885 pfet
M$1764 \$631 A2|A3|Z$2 VDD \$657 pfet L=0.5U W=0.82U AS=0.5054P AD=0.2132P
+ PS=2.57U PD=1.34U
* device instance $1765 r0 *1 41.77,79.38 pfet
M$1765 A2|Z$3 \$631 VDD \$657 pfet L=0.5U W=1.83U AS=0.5054P AD=0.8052P
+ PS=2.57U PD=4.54U
* device instance $1766 r0 *1 48.01,79.3025 pfet
M$1766 \$673 A2|Z$2 \$624 \$657 pfet L=0.5U W=0.495U AS=0.2178P AD=0.141075P
+ PS=1.87U PD=1.065U
* device instance $1767 r0 *1 49.08,79.3025 pfet
M$1767 VDD A1|A2|I|Q \$673 \$657 pfet L=0.5U W=0.495U AS=0.141075P AD=0.282P
+ PS=1.065U PD=1.715U
* device instance $1768 r0 *1 50.38,79.5125 pfet
M$1768 \$662 \$624 VDD \$657 pfet L=0.5U W=0.915U AS=0.282P AD=0.260775P
+ PS=1.715U PD=1.485U
* device instance $1769 r0 *1 51.45,79.5125 pfet
M$1769 \$625 A1|A2|I|Q \$662 \$657 pfet L=0.5U W=0.915U AS=0.260775P AD=0.2379P
+ PS=1.485U PD=1.435U
* device instance $1770 r0 *1 52.47,79.5125 pfet
M$1770 \$662 A2|Z$2 \$625 \$657 pfet L=0.5U W=0.915U AS=0.2379P AD=0.4026P
+ PS=1.435U PD=2.71U
* device instance $1771 r0 *1 62.475,81.9 pfet
M$1771 D|ZN$13 A2|ZN$32 \$682 \$657 pfet L=0.5U W=1.83U AS=0.8052P AD=0.4758P
+ PS=4.54U PD=2.35U
* device instance $1772 r0 *1 63.495,81.9 pfet
M$1772 \$682 A1|A2|B|B2|C|Z D|ZN$13 \$657 pfet L=0.5U W=1.83U AS=0.4758P
+ AD=0.5673P PS=2.35U PD=2.45U
* device instance $1773 r0 *1 64.615,81.9 pfet
M$1773 \$699 B|ZN$9 \$682 \$657 pfet L=0.5U W=1.83U AS=0.5673P AD=0.5673P
+ PS=2.45U PD=2.45U
* device instance $1774 r0 *1 65.735,81.9 pfet
M$1774 VDD A1|B|C|I|ZN \$699 \$657 pfet L=0.5U W=1.83U AS=0.5673P AD=0.8052P
+ PS=2.45U PD=4.54U
* device instance $1775 r0 *1 82.63,81.395 pfet
M$1775 \$685 A1|ZN$12 VDD \$657 pfet L=0.5U W=0.82U AS=0.3608P AD=0.2132P
+ PS=2.52U PD=1.34U
* device instance $1776 r0 *1 83.65,81.395 pfet
M$1776 VDD A2|Z$3 \$685 \$657 pfet L=0.5U W=0.82U AS=0.2132P AD=0.5054P
+ PS=1.34U PD=2.57U
* device instance $1777 r0 *1 84.89,81.9 pfet
M$1777 A1|Z$4 \$685 VDD \$657 pfet L=0.5U W=1.83U AS=0.5054P AD=0.8052P
+ PS=2.57U PD=4.54U
* device instance $1778 r0 *1 93.155,81.4425 pfet
M$1778 \$701 A2|A3|ZN$4 VDD \$657 pfet L=0.5U W=0.915U AS=0.57645P AD=0.2379P
+ PS=2.69U PD=1.435U
* device instance $1779 r0 *1 94.175,81.4425 pfet
M$1779 \$687 A1|A2|ZN$6 \$701 \$657 pfet L=0.5U W=0.915U AS=0.2379P AD=0.4026P
+ PS=1.435U PD=2.71U
* device instance $1780 r0 *1 91.795,81.9 pfet
M$1780 VDD \$687 A3|B2|Z \$657 pfet L=0.5U W=1.83U AS=0.8052P AD=0.57645P
+ PS=4.54U PD=2.69U
* device instance $1781 r0 *1 103.96,81.9 pfet
M$1781 \$702 A2|ZN$30 VDD \$657 pfet L=0.5U W=1.83U AS=0.8052P AD=0.5673P
+ PS=4.54U PD=2.45U
* device instance $1782 r0 *1 105.08,81.9 pfet
M$1782 A1|B1|ZN$1 A1|A3|I|Q \$702 \$657 pfet L=0.5U W=1.83U AS=0.5673P
+ AD=0.8052P PS=2.45U PD=4.54U
* device instance $1783 r0 *1 125.83,81.8075 pfet
M$1783 VDD B|Z$1 A2|A3|ZN$2 \$657 pfet L=0.5U W=1.645U AS=0.61275P AD=0.7238P
+ PS=2.53U PD=4.17U
* device instance $1784 r0 *1 123.56,81.9 pfet
M$1784 \$700 A2|ZN$33 VDD \$657 pfet L=0.5U W=1.83U AS=0.8052P AD=0.52155P
+ PS=4.54U PD=2.4U
* device instance $1785 r0 *1 124.63,81.9 pfet
M$1785 A2|A3|ZN$2 A1|Z$5 \$700 \$657 pfet L=0.5U W=1.83U AS=0.52155P
+ AD=0.61275P PS=2.4U PD=2.53U
* device instance $1786 r0 *1 143.15,81.8175 pfet
M$1786 \$694 A2|ZN$30 VDD \$657 pfet L=0.5U W=0.915U AS=0.4026P AD=0.2379P
+ PS=2.71U PD=1.435U
* device instance $1787 r0 *1 144.17,81.8175 pfet
M$1787 \$694 A1|Q VDD \$657 pfet L=0.5U W=0.915U AS=0.526125P AD=0.2379P
+ PS=2.58U PD=1.435U
* device instance $1788 r0 *1 145.42,81.9 pfet
M$1788 B|ZN$10 \$694 VDD \$657 pfet L=0.5U W=1.83U AS=0.526125P AD=0.5673P
+ PS=2.58U PD=2.45U
* device instance $1789 r0 *1 146.54,81.9 pfet
M$1789 \$697 A1|Q B|ZN$10 \$657 pfet L=0.5U W=1.83U AS=0.5673P AD=0.52155P
+ PS=2.45U PD=2.4U
* device instance $1790 r0 *1 147.61,81.9 pfet
M$1790 VDD A2|ZN$30 \$697 \$657 pfet L=0.5U W=1.83U AS=0.52155P AD=0.8052P
+ PS=2.4U PD=4.54U
* device instance $1791 r0 *1 13.33,89.4275 pfet
M$1791 \$714 \$713 VDD \$732 pfet L=0.5U W=0.915U AS=0.4026P AD=0.2379P
+ PS=2.71U PD=1.435U
* device instance $1792 r0 *1 14.35,89.4275 pfet
M$1792 \$714 A2|A3|Z$3 VDD \$732 pfet L=0.5U W=0.915U AS=0.535925P AD=0.2379P
+ PS=2.58U PD=1.435U
* device instance $1793 r0 *1 15.6,89.46 pfet
M$1793 A2|B2|ZN$1 \$714 VDD \$732 pfet L=0.5U W=1.83U AS=0.535925P AD=0.61305P
+ PS=2.58U PD=2.5U
* device instance $1794 r0 *1 16.77,89.46 pfet
M$1794 \$742 A2|A3|Z$3 A2|B2|ZN$1 \$732 pfet L=0.5U W=1.83U AS=0.61305P
+ AD=0.4758P PS=2.5U PD=2.35U
* device instance $1795 r0 *1 17.79,89.46 pfet
M$1795 VDD \$713 \$742 \$732 pfet L=0.5U W=1.83U AS=0.4758P AD=0.8052P PS=2.35U
+ PD=4.54U
* device instance $1796 r0 *1 20.52,89.46 pfet
M$1796 \$743 A2|A3|Z$3 VDD \$732 pfet L=0.5U W=1.83U AS=0.8052P AD=0.5673P
+ PS=4.54U PD=2.45U
* device instance $1797 r0 *1 21.64,89.46 pfet
M$1797 A3|ZN A1|A2|I|ZN \$743 \$732 pfet L=0.5U W=1.83U AS=0.5673P AD=0.8052P
+ PS=2.45U PD=4.54U
* device instance $1798 r0 *1 25.45,89.46 pfet
M$1798 VDD A1|A2|I|Q A1|ZN$13 \$732 pfet L=0.5U W=1.83U AS=0.8052P AD=0.8052P
+ PS=4.54U PD=4.54U
* device instance $1799 r0 *1 35.03,89.46 pfet
M$1799 A2|B|ZN$1 A2|B1|I|ZN VDD \$732 pfet L=0.5U W=1.83U AS=0.8052P AD=0.8052P
+ PS=4.54U PD=4.54U
* device instance $1800 r0 *1 37.32,89.46 pfet
M$1800 \$744 A2|B|ZN$1 VDD \$732 pfet L=0.5U W=1.83U AS=0.8052P AD=0.5673P
+ PS=4.54U PD=2.45U
* device instance $1801 r0 *1 38.44,89.46 pfet
M$1801 A1|ZN$12 A1|I0|ZN \$744 \$732 pfet L=0.5U W=1.83U AS=0.5673P AD=0.8052P
+ PS=2.45U PD=4.54U
* device instance $1802 r0 *1 55.19,89.46 pfet
M$1802 B|ZN$11 A2|B2|Z \$739 \$732 pfet L=0.5U W=1.83U AS=0.8052P AD=0.4758P
+ PS=4.54U PD=2.35U
* device instance $1803 r0 *1 56.21,89.46 pfet
M$1803 \$739 A1|A3|B1|ZN B|ZN$11 \$732 pfet L=0.5U W=1.83U AS=0.4758P
+ AD=0.6405P PS=2.35U PD=2.53U
* device instance $1804 r0 *1 57.41,89.46 pfet
M$1804 VDD B|C|Z \$739 \$732 pfet L=0.5U W=1.83U AS=0.6405P AD=0.8052P PS=2.53U
+ PD=4.54U
* device instance $1805 r0 *1 69.225,89.3675 pfet
M$1805 I|ZN A1|A2|A4|I|Q VDD \$732 pfet L=0.5U W=1.645U AS=0.7238P AD=0.4277P
+ PS=4.17U PD=2.165U
* device instance $1806 r0 *1 70.245,89.3675 pfet
M$1806 VDD A2|ZN$39 I|ZN \$732 pfet L=0.5U W=1.645U AS=0.4277P AD=0.7238P
+ PS=2.165U PD=4.17U
* device instance $1807 r0 *1 102.235,89.3675 pfet
M$1807 B|C|ZN A2|ZN$30 VDD \$732 pfet L=0.5U W=1.645U AS=0.7238P AD=0.4277P
+ PS=4.17U PD=2.165U
* device instance $1808 r0 *1 103.255,89.3675 pfet
M$1808 VDD A1|A3|I|Q B|C|ZN \$732 pfet L=0.5U W=1.645U AS=0.4277P AD=0.7238P
+ PS=2.165U PD=4.17U
* device instance $1809 r0 *1 106.25,89.46 pfet
M$1809 \$750 A3|B2|Z VDD \$732 pfet L=0.5U W=1.83U AS=0.8052P AD=0.4758P
+ PS=4.54U PD=2.35U
* device instance $1810 r0 *1 107.27,89.46 pfet
M$1810 B1|ZN$2 A1|B1|ZN$1 \$750 \$732 pfet L=0.5U W=1.83U AS=0.4758P AD=0.585P
+ PS=2.35U PD=2.53U
* device instance $1811 r0 *1 108.47,89.645 pfet
M$1811 VDD B|C|ZN B1|ZN$2 \$732 pfet L=0.5U W=1.46U AS=0.585P AD=0.585P
+ PS=2.53U PD=2.53U
* device instance $1812 r0 *1 109.67,89.46 pfet
M$1812 \$751 A2|ZN$35 VDD \$732 pfet L=0.5U W=1.83U AS=0.585P AD=0.4758P
+ PS=2.53U PD=2.35U
* device instance $1813 r0 *1 110.69,89.46 pfet
M$1813 B1|ZN$2 A1|Z$5 \$751 \$732 pfet L=0.5U W=1.83U AS=0.4758P AD=0.8052P
+ PS=2.35U PD=4.54U
* device instance $1814 r0 *1 113.32,89.46 pfet
M$1814 \$746 A1|A2|Q A2|ZN$35 \$732 pfet L=0.5U W=1.83U AS=0.8052P AD=0.5673P
+ PS=4.54U PD=2.45U
* device instance $1815 r0 *1 114.44,89.46 pfet
M$1815 VDD A2|ZN$30 \$746 \$732 pfet L=0.5U W=1.83U AS=0.5673P AD=0.8052P
+ PS=2.45U PD=4.54U
* device instance $1816 r0 *1 122.31,89.46 pfet
M$1816 VDD \$728 A1|Z$5 \$732 pfet L=0.5U W=1.83U AS=0.8052P AD=0.5054P
+ PS=4.54U PD=2.57U
* device instance $1817 r0 *1 123.55,89.965 pfet
M$1817 \$728 A2|ZN$30 VDD \$732 pfet L=0.5U W=0.82U AS=0.5054P AD=0.2132P
+ PS=2.57U PD=1.34U
* device instance $1818 r0 *1 124.57,89.965 pfet
M$1818 VDD A1|A2|Q \$728 \$732 pfet L=0.5U W=0.82U AS=0.2132P AD=0.3608P
+ PS=1.34U PD=2.52U
* device instance $1819 r0 *1 136.425,81.9925 pfet
M$1819 A2|ZN$31 A1|A2|B|B2|C|Z VDD \$657 pfet L=0.5U W=1.645U AS=0.7238P
+ AD=0.4277P PS=4.17U PD=2.165U
* device instance $1820 r0 *1 137.445,81.9925 pfet
M$1820 VDD A2|ZN$34 A2|ZN$31 \$657 pfet L=0.5U W=1.645U AS=0.4277P AD=0.7238P
+ PS=2.165U PD=4.17U
* device instance $1821 r0 *1 146.475,89.3675 pfet
M$1821 C|ZN A2|ZN$30 VDD \$732 pfet L=0.5U W=1.645U AS=0.7238P AD=0.4277P
+ PS=4.17U PD=2.165U
* device instance $1822 r0 *1 147.495,89.3675 pfet
M$1822 VDD A1|A3|B|Q C|ZN \$732 pfet L=0.5U W=1.645U AS=0.4277P AD=0.7238P
+ PS=2.165U PD=4.17U
* device instance $1823 r0 *1 7.13,89.3825 pfet
M$1823 \$741 A1|A2|I|ZN \$712 \$732 pfet L=0.5U W=0.495U AS=0.2178P
+ AD=0.141075P PS=1.87U PD=1.065U
* device instance $1824 r0 *1 8.2,89.3825 pfet
M$1824 VDD A1|A2|I|Q \$741 \$732 pfet L=0.5U W=0.495U AS=0.141075P AD=0.282P
+ PS=1.065U PD=1.715U
* device instance $1825 r0 *1 9.5,89.5925 pfet
M$1825 \$738 \$712 VDD \$732 pfet L=0.5U W=0.915U AS=0.282P AD=0.260775P
+ PS=1.715U PD=1.485U
* device instance $1826 r0 *1 10.57,89.5925 pfet
M$1826 \$713 A1|A2|I|Q \$738 \$732 pfet L=0.5U W=0.915U AS=0.260775P AD=0.2379P
+ PS=1.485U PD=1.435U
* device instance $1827 r0 *1 11.59,89.5925 pfet
M$1827 \$738 A1|A2|I|ZN \$713 \$732 pfet L=0.5U W=0.915U AS=0.2379P AD=0.4026P
+ PS=1.435U PD=2.71U
* device instance $1828 r0 *1 12.68,91.98 pfet
M$1828 \$776 A2|A3|I1|ZN VDD \$732 pfet L=0.5U W=1.83U AS=0.8052P AD=0.5673P
+ PS=4.54U PD=2.45U
* device instance $1829 r0 *1 13.8,91.98 pfet
M$1829 A1|A2|ZN$5 A1|ZN$9 \$776 \$732 pfet L=0.5U W=1.83U AS=0.5673P AD=0.8052P
+ PS=2.45U PD=4.54U
* device instance $1830 r0 *1 22.65,91.98 pfet
M$1830 \$777 A3|ZN VDD \$732 pfet L=0.5U W=1.83U AS=0.8052P AD=0.52155P
+ PS=4.54U PD=2.4U
* device instance $1831 r0 *1 23.72,91.98 pfet
M$1831 \$778 A1|A2|ZN$5 \$777 \$732 pfet L=0.5U W=1.83U AS=0.52155P AD=0.5673P
+ PS=2.4U PD=2.45U
* device instance $1832 r0 *1 24.84,91.98 pfet
M$1832 A2|A3|ZN$3 A1|ZN$13 \$778 \$732 pfet L=0.5U W=1.83U AS=0.5673P
+ AD=0.5673P PS=2.45U PD=2.45U
* device instance $1833 r0 *1 25.96,91.98 pfet
M$1833 \$779 A2|B1|I|ZN A2|A3|ZN$3 \$732 pfet L=0.5U W=1.83U AS=0.5673P
+ AD=0.5673P PS=2.45U PD=2.45U
* device instance $1834 r0 *1 27.08,91.98 pfet
M$1834 \$780 A2|B2|ZN$1 \$779 \$732 pfet L=0.5U W=1.83U AS=0.5673P AD=0.52155P
+ PS=2.45U PD=2.4U
* device instance $1835 r0 *1 28.15,91.98 pfet
M$1835 VDD A1|B3|ZN \$780 \$732 pfet L=0.5U W=1.83U AS=0.52155P AD=0.8052P
+ PS=2.4U PD=4.54U
* device instance $1836 r0 *1 38.99,91.8975 pfet
M$1836 \$755 A2|B2|ZN$1 VDD \$732 pfet L=0.5U W=0.915U AS=0.4026P AD=0.2379P
+ PS=2.71U PD=1.435U
* device instance $1837 r0 *1 40.01,91.8975 pfet
M$1837 \$755 A1|A3|B1|ZN VDD \$732 pfet L=0.5U W=0.915U AS=0.526125P AD=0.2379P
+ PS=2.58U PD=1.435U
* device instance $1838 r0 *1 41.26,91.98 pfet
M$1838 A2|ZN$36 \$755 VDD \$732 pfet L=0.5U W=1.83U AS=0.526125P AD=0.5673P
+ PS=2.58U PD=2.45U
* device instance $1839 r0 *1 42.38,91.98 pfet
M$1839 \$782 A1|A3|B1|ZN A2|ZN$36 \$732 pfet L=0.5U W=1.83U AS=0.5673P
+ AD=0.52155P PS=2.45U PD=2.4U
* device instance $1840 r0 *1 43.45,91.98 pfet
M$1840 VDD A2|B2|ZN$1 \$782 \$732 pfet L=0.5U W=1.83U AS=0.52155P AD=0.8052P
+ PS=2.4U PD=4.54U
* device instance $1841 r0 *1 48.625,89.9175 pfet
M$1841 \$745 A1|A2|I|Q \$719 \$732 pfet L=0.5U W=0.915U AS=0.4026P AD=0.2379P
+ PS=2.71U PD=1.435U
* device instance $1842 r0 *1 49.645,89.9175 pfet
M$1842 \$745 A2|Z$2 VDD \$732 pfet L=0.5U W=0.915U AS=0.57645P AD=0.2379P
+ PS=2.69U PD=1.435U
* device instance $1843 r0 *1 51.005,89.46 pfet
M$1843 A2|B2|Z \$719 VDD \$732 pfet L=0.5U W=1.83U AS=0.57645P AD=0.8052P
+ PS=2.69U PD=4.54U
* device instance $1844 r0 *1 50.15,91.475 pfet
M$1844 \$757 A1|A2|I|Q VDD \$732 pfet L=0.5U W=0.82U AS=0.3608P AD=0.2132P
+ PS=2.52U PD=1.34U
* device instance $1845 r0 *1 51.17,91.475 pfet
M$1845 VDD A2|Z$2 \$757 \$732 pfet L=0.5U W=0.82U AS=0.2132P AD=0.5054P
+ PS=1.34U PD=2.57U
* device instance $1846 r0 *1 52.41,91.98 pfet
M$1846 B|C|Z \$757 VDD \$732 pfet L=0.5U W=1.83U AS=0.5054P AD=0.8052P PS=2.57U
+ PD=4.54U
* device instance $1847 r0 *1 55.29,91.98 pfet
M$1847 VDD A2|B2|Z \$758 \$732 pfet L=0.5U W=1.83U AS=0.8052P AD=0.4758P
+ PS=4.54U PD=2.35U
* device instance $1848 r0 *1 56.31,91.98 pfet
M$1848 \$758 A1|A3|B1|ZN VDD \$732 pfet L=0.5U W=1.83U AS=0.4758P AD=0.5124P
+ PS=2.35U PD=2.39U
* device instance $1849 r0 *1 57.37,91.98 pfet
M$1849 \$759 B|C|Z \$758 \$732 pfet L=0.5U W=1.83U AS=0.5124P AD=0.5673P
+ PS=2.39U PD=2.45U
* device instance $1850 r0 *1 58.49,91.98 pfet
M$1850 A2|A3|ZN$4 A2|ZN$39 \$759 \$732 pfet L=0.5U W=1.83U AS=0.5673P
+ AD=0.4758P PS=2.45U PD=2.35U
* device instance $1851 r0 *1 59.51,91.98 pfet
M$1851 \$759 A1|A2|A4|I|Q A2|A3|ZN$4 \$732 pfet L=0.5U W=1.83U AS=0.4758P
+ AD=0.8052P PS=2.35U PD=4.54U
* device instance $1852 r0 *1 68.07,91.98 pfet
M$1852 A1|ZN$15 I|ZN VDD \$732 pfet L=0.5U W=1.83U AS=0.8052P AD=0.8052P
+ PS=4.54U PD=4.54U
* device instance $1853 r0 *1 70.73,91.8875 pfet
M$1853 A2|ZN$37 B|ZN$11 VDD \$732 pfet L=0.5U W=1.645U AS=0.7238P AD=0.61275P
+ PS=4.17U PD=2.53U
* device instance $1854 r0 *1 71.93,91.98 pfet
M$1854 \$785 A1|ZN$15 A2|ZN$37 \$732 pfet L=0.5U W=1.83U AS=0.61275P
+ AD=0.52155P PS=2.53U PD=2.4U
* device instance $1855 r0 *1 73,91.98 pfet
M$1855 VDD A1|A2|ZN$6 \$785 \$732 pfet L=0.5U W=1.83U AS=0.52155P AD=0.8052P
+ PS=2.4U PD=4.54U
* device instance $1856 r0 *1 86.09,89.9175 pfet
M$1856 \$747 A1|Q \$724 \$732 pfet L=0.5U W=0.915U AS=0.4026P AD=0.32025P
+ PS=2.71U PD=1.615U
* device instance $1857 r0 *1 87.29,89.9175 pfet
M$1857 \$748 A1|A2|I|Q \$747 \$732 pfet L=0.5U W=0.915U AS=0.32025P
+ AD=0.306525P PS=1.615U PD=1.585U
* device instance $1858 r0 *1 88.46,89.9175 pfet
M$1858 \$749 A1|A3|B|Q \$748 \$732 pfet L=0.5U W=0.915U AS=0.306525P
+ AD=0.343125P PS=1.585U PD=1.665U
* device instance $1859 r0 *1 89.71,89.9175 pfet
M$1859 \$749 A1|A2|A4|I|Q VDD \$732 pfet L=0.5U W=0.915U AS=0.549P AD=0.343125P
+ PS=2.63U PD=1.665U
* device instance $1860 r0 *1 91.01,89.46 pfet
M$1860 A4|Z \$724 VDD \$732 pfet L=0.5U W=1.83U AS=0.549P AD=0.8052P PS=2.63U
+ PD=4.54U
* device instance $1861 r0 *1 88.93,92.0125 pfet
M$1861 \$766 \$765 VDD \$732 pfet L=0.5U W=0.915U AS=0.4026P AD=0.2379P
+ PS=2.71U PD=1.435U
* device instance $1862 r0 *1 89.95,92.0125 pfet
M$1862 \$766 A3|B2|Z VDD \$732 pfet L=0.5U W=0.915U AS=0.535925P AD=0.2379P
+ PS=2.58U PD=1.435U
* device instance $1863 r0 *1 91.2,91.98 pfet
M$1863 A2|ZN$38 \$766 VDD \$732 pfet L=0.5U W=1.83U AS=0.535925P AD=0.61305P
+ PS=2.58U PD=2.5U
* device instance $1864 r0 *1 92.37,91.98 pfet
M$1864 \$789 A3|B2|Z A2|ZN$38 \$732 pfet L=0.5U W=1.83U AS=0.61305P AD=0.4758P
+ PS=2.5U PD=2.35U
* device instance $1865 r0 *1 93.39,91.98 pfet
M$1865 VDD \$765 \$789 \$732 pfet L=0.5U W=1.83U AS=0.4758P AD=0.8052P PS=2.35U
+ PD=4.54U
* device instance $1866 r0 *1 107.77,91.8875 pfet
M$1866 VDD B|C|ZN A2|ZN$33 \$732 pfet L=0.5U W=1.645U AS=0.6292P AD=0.7238P
+ PS=2.55U PD=4.17U
* device instance $1867 r0 *1 104.41,91.98 pfet
M$1867 \$788 A2|A3|ZN$4 VDD \$732 pfet L=0.5U W=1.83U AS=0.8052P AD=0.52155P
+ PS=4.54U PD=2.4U
* device instance $1868 r0 *1 105.48,91.98 pfet
M$1868 \$787 A1|A2|ZN$6 \$788 \$732 pfet L=0.5U W=1.83U AS=0.52155P AD=0.52155P
+ PS=2.4U PD=2.4U
* device instance $1869 r0 *1 106.55,91.98 pfet
M$1869 A2|ZN$33 A1|B1|ZN$1 \$787 \$732 pfet L=0.5U W=1.83U AS=0.52155P
+ AD=0.6292P PS=2.4U PD=2.55U
* device instance $1870 r0 *1 123.665,91.5225 pfet
M$1870 \$784 A1|A2|Q \$768 \$732 pfet L=0.5U W=0.915U AS=0.4026P AD=0.2379P
+ PS=2.71U PD=1.435U
* device instance $1871 r0 *1 124.685,91.5225 pfet
M$1871 VDD A2|ZN$30 \$784 \$732 pfet L=0.5U W=0.915U AS=0.2379P AD=0.57645P
+ PS=1.435U PD=2.69U
* device instance $1872 r0 *1 126.045,91.98 pfet
M$1872 B|Z$1 \$768 VDD \$732 pfet L=0.5U W=1.83U AS=0.57645P AD=0.8052P
+ PS=2.69U PD=4.54U
* device instance $1873 r0 *1 138.295,92.4325 pfet
M$1873 \$781 \$770 \$771 \$732 pfet L=0.5U W=0.915U AS=0.4026P AD=0.2447625P
+ PS=2.71U PD=1.45U
* device instance $1874 r0 *1 139.33,92.4325 pfet
M$1874 \$781 A2|A3|ZN$2 VDD \$732 pfet L=0.5U W=0.915U AS=0.571875P
+ AD=0.2447625P PS=2.68U PD=1.45U
* device instance $1875 r0 *1 140.68,91.975 pfet
M$1875 \$772 \$771 VDD \$732 pfet L=0.5U W=1.83U AS=0.571875P AD=0.52155P
+ PS=2.68U PD=2.4U
* device instance $1876 r0 *1 141.75,91.975 pfet
M$1876 A2|Z$4 A2|A3|ZN$2 \$772 \$732 pfet L=0.5U W=1.83U AS=0.52155P AD=0.4758P
+ PS=2.4U PD=2.35U
* device instance $1877 r0 *1 142.77,91.975 pfet
M$1877 \$772 \$770 A2|Z$4 \$732 pfet L=0.5U W=1.83U AS=0.4758P AD=1.3176P
+ PS=2.35U PD=5.1U
* device instance $1878 r0 *1 145.96,91.98 pfet
M$1878 \$775 A2|ZN$30 VDD \$732 pfet L=0.5U W=1.83U AS=0.8052P AD=0.5673P
+ PS=4.54U PD=2.45U
* device instance $1879 r0 *1 147.08,91.98 pfet
M$1879 A1|ZN$14 A1|A3|B|Q \$775 \$732 pfet L=0.5U W=1.83U AS=0.5673P AD=0.8052P
+ PS=2.45U PD=4.54U
* device instance $1880 r0 *1 12.67,99.6225 pfet
M$1880 \$809 A1|A2|A3|ZN$1 VDD \$808 pfet L=0.5U W=0.915U AS=0.4026P AD=0.2379P
+ PS=2.71U PD=1.435U
* device instance $1881 r0 *1 13.69,99.6225 pfet
M$1881 \$809 A1|A2|I|Q VDD \$808 pfet L=0.5U W=0.915U AS=0.526125P AD=0.2379P
+ PS=2.58U PD=1.435U
* device instance $1882 r0 *1 14.94,99.54 pfet
M$1882 A2|A3|ZN$5 \$809 VDD \$808 pfet L=0.5U W=1.83U AS=0.526125P AD=0.5673P
+ PS=2.58U PD=2.45U
* device instance $1883 r0 *1 16.06,99.54 pfet
M$1883 \$823 A1|A2|I|Q A2|A3|ZN$5 \$808 pfet L=0.5U W=1.83U AS=0.5673P
+ AD=0.52155P PS=2.45U PD=2.4U
* device instance $1884 r0 *1 17.13,99.54 pfet
M$1884 VDD A1|A2|A3|ZN$1 \$823 \$808 pfet L=0.5U W=1.83U AS=0.52155P AD=0.8052P
+ PS=2.4U PD=4.54U
* device instance $1885 r0 *1 17.825,101.6025 pfet
M$1885 \$848 A1|I0|ZN \$827 \$808 pfet L=0.5U W=0.915U AS=0.4026P AD=0.2379P
+ PS=2.71U PD=1.435U
* device instance $1886 r0 *1 18.845,101.6025 pfet
M$1886 VDD A2|A3|ZN$5 \$848 \$808 pfet L=0.5U W=0.915U AS=0.2379P AD=0.57645P
+ PS=1.435U PD=2.69U
* device instance $1887 r0 *1 20.205,102.06 pfet
M$1887 A1|Z$6 \$827 VDD \$808 pfet L=0.5U W=1.83U AS=0.57645P AD=0.8052P
+ PS=2.69U PD=4.54U
* device instance $1888 r0 *1 26.11,101.9775 pfet
M$1888 \$829 A2|ZN$48 VDD \$808 pfet L=0.5U W=0.915U AS=0.4026P AD=0.2379P
+ PS=2.71U PD=1.435U
* device instance $1889 r0 *1 27.13,101.9775 pfet
M$1889 \$829 A1|ZN$16 VDD \$808 pfet L=0.5U W=0.915U AS=0.526125P AD=0.2379P
+ PS=2.58U PD=1.435U
* device instance $1890 r0 *1 28.38,102.06 pfet
M$1890 B1|ZN$3 \$829 VDD \$808 pfet L=0.5U W=1.83U AS=0.526125P AD=0.5673P
+ PS=2.58U PD=2.45U
* device instance $1891 r0 *1 29.5,102.06 pfet
M$1891 \$849 A1|ZN$16 B1|ZN$3 \$808 pfet L=0.5U W=1.83U AS=0.5673P AD=0.52155P
+ PS=2.45U PD=2.4U
* device instance $1892 r0 *1 30.57,102.06 pfet
M$1892 VDD A2|ZN$48 \$849 \$808 pfet L=0.5U W=1.83U AS=0.52155P AD=0.8052P
+ PS=2.4U PD=4.54U
* device instance $1893 r0 *1 31.16,99.54 pfet
M$1893 \$824 A2|ZN$28 VDD \$808 pfet L=0.5U W=1.83U AS=0.8052P AD=0.52155P
+ PS=4.54U PD=2.4U
* device instance $1894 r0 *1 32.23,99.54 pfet
M$1894 A1|ZN$16 A1|A2|A3|ZN$1 \$824 \$808 pfet L=0.5U W=1.83U AS=0.52155P
+ AD=0.61275P PS=2.4U PD=2.53U
* device instance $1895 r0 *1 33.43,99.6325 pfet
M$1895 VDD A2|B|ZN$1 A1|ZN$16 \$808 pfet L=0.5U W=1.645U AS=0.61275P AD=0.7238P
+ PS=2.53U PD=4.17U
* device instance $1896 r0 *1 39.4,99.54 pfet
M$1896 \$825 A1|B3|ZN A1|A2|A3|ZN$1 \$808 pfet L=0.5U W=1.83U AS=0.8052P
+ AD=0.5673P PS=4.54U PD=2.45U
* device instance $1897 r0 *1 40.52,99.54 pfet
M$1897 VDD A1|A2|B|ZN \$825 \$808 pfet L=0.5U W=1.83U AS=0.5673P AD=0.8052P
+ PS=2.45U PD=4.54U
* device instance $1898 r0 *1 40.11,101.9775 pfet
M$1898 \$831 A2|ZN$40 VDD \$808 pfet L=0.5U W=0.915U AS=0.4026P AD=0.2379P
+ PS=2.71U PD=1.435U
* device instance $1899 r0 *1 41.13,101.9775 pfet
M$1899 \$831 A1|A2|ZN$7 VDD \$808 pfet L=0.5U W=0.915U AS=0.526125P AD=0.2379P
+ PS=2.58U PD=1.435U
* device instance $1900 r0 *1 42.38,102.06 pfet
M$1900 A2|ZN$39 \$831 VDD \$808 pfet L=0.5U W=1.83U AS=0.526125P AD=0.5673P
+ PS=2.58U PD=2.45U
* device instance $1901 r0 *1 43.5,102.06 pfet
M$1901 \$851 A1|A2|ZN$7 A2|ZN$39 \$808 pfet L=0.5U W=1.83U AS=0.5673P
+ AD=0.52155P PS=2.45U PD=2.4U
* device instance $1902 r0 *1 44.57,102.06 pfet
M$1902 VDD A2|ZN$40 \$851 \$808 pfet L=0.5U W=1.83U AS=0.52155P AD=0.8052P
+ PS=2.4U PD=4.54U
* device instance $1903 r0 *1 49.69,102.5175 pfet
M$1903 \$852 A2|ZN$36 \$834 \$808 pfet L=0.5U W=0.915U AS=0.4026P AD=0.260775P
+ PS=2.71U PD=1.485U
* device instance $1904 r0 *1 50.76,102.5175 pfet
M$1904 \$852 A1|ZN$11 VDD \$808 pfet L=0.5U W=0.915U AS=0.549P AD=0.260775P
+ PS=2.63U PD=1.485U
* device instance $1905 r0 *1 52.06,102.06 pfet
M$1905 \$835 \$834 VDD \$808 pfet L=0.5U W=1.83U AS=0.549P AD=0.52155P PS=2.63U
+ PD=2.4U
* device instance $1906 r0 *1 53.13,102.06 pfet
M$1906 A2|Z$5 A1|ZN$11 \$835 \$808 pfet L=0.5U W=1.83U AS=0.52155P AD=0.4758P
+ PS=2.4U PD=2.35U
* device instance $1907 r0 *1 54.15,102.06 pfet
M$1907 \$835 A2|ZN$36 A2|Z$5 \$808 pfet L=0.5U W=1.83U AS=0.4758P AD=0.8052P
+ PS=2.35U PD=4.54U
* device instance $1908 r0 *1 59.16,102.06 pfet
M$1908 \$854 A2|ZN$46 VDD \$808 pfet L=0.5U W=1.83U AS=0.8052P AD=0.5673P
+ PS=4.54U PD=2.45U
* device instance $1909 r0 *1 60.28,102.06 pfet
M$1909 B|ZN$9 A1|A2|B|B2|C|Z \$854 \$808 pfet L=0.5U W=1.83U AS=0.5673P
+ AD=0.8052P PS=2.45U PD=4.54U
* device instance $1910 r0 *1 69.8,99.54 pfet
M$1910 \$826 A2|ZN$39 VDD \$808 pfet L=0.5U W=1.83U AS=0.8052P AD=0.5673P
+ PS=4.54U PD=2.45U
* device instance $1911 r0 *1 70.92,99.54 pfet
M$1911 A1|A2|ZN$6 A1|A2|A4|I|Q \$826 \$808 pfet L=0.5U W=1.83U AS=0.5673P
+ AD=0.8052P PS=2.45U PD=4.54U
* device instance $1912 r0 *1 82.73,92.0575 pfet
M$1912 \$786 A2|ZN$30 \$792 \$732 pfet L=0.5U W=0.495U AS=0.2178P AD=0.141075P
+ PS=1.87U PD=1.065U
* device instance $1913 r0 *1 83.8,92.0575 pfet
M$1913 \$786 A1|ZN$23 VDD \$732 pfet L=0.5U W=0.495U AS=0.282P AD=0.141075P
+ PS=1.715U PD=1.065U
* device instance $1914 r0 *1 85.1,91.8475 pfet
M$1914 \$764 \$792 VDD \$732 pfet L=0.5U W=0.915U AS=0.282P AD=0.260775P
+ PS=1.715U PD=1.485U
* device instance $1915 r0 *1 86.17,91.8475 pfet
M$1915 \$765 A1|ZN$23 \$764 \$732 pfet L=0.5U W=0.915U AS=0.260775P AD=0.2379P
+ PS=1.485U PD=1.435U
* device instance $1916 r0 *1 87.19,91.8475 pfet
M$1916 \$764 A2|ZN$30 \$765 \$732 pfet L=0.5U W=0.915U AS=0.2379P AD=0.4026P
+ PS=1.435U PD=2.71U
* device instance $1917 r0 *1 89.385,102.06 pfet
M$1917 \$855 A1|B|C|I|ZN VDD \$808 pfet L=0.5U W=1.83U AS=0.8052P AD=0.5673P
+ PS=4.54U PD=2.45U
* device instance $1918 r0 *1 90.505,102.06 pfet
M$1918 \$838 B|ZN$13 \$855 \$808 pfet L=0.5U W=1.83U AS=0.5673P AD=0.5673P
+ PS=2.45U PD=2.45U
* device instance $1919 r0 *1 91.625,102.06 pfet
M$1919 D|ZN$14 A1|A2|B|B2|C|Z \$838 \$808 pfet L=0.5U W=1.83U AS=0.5673P
+ AD=0.4758P PS=2.45U PD=2.35U
* device instance $1920 r0 *1 92.645,102.06 pfet
M$1920 \$838 A2|ZN$38 D|ZN$14 \$808 pfet L=0.5U W=1.83U AS=0.4758P AD=0.8052P
+ PS=2.35U PD=4.54U
* device instance $1921 r0 *1 106.71,102.06 pfet
M$1921 A2|ZN$42 A2|ZN$63 \$839 \$808 pfet L=0.5U W=1.83U AS=0.8052P AD=0.4758P
+ PS=4.54U PD=2.35U
* device instance $1922 r0 *1 107.73,102.06 pfet
M$1922 \$839 A1|B|Z$1 A2|ZN$42 \$808 pfet L=0.5U W=1.83U AS=0.4758P AD=0.6405P
+ PS=2.35U PD=2.53U
* device instance $1923 r0 *1 108.93,102.06 pfet
M$1923 VDD A1|A2|B|B2|C|Z \$839 \$808 pfet L=0.5U W=1.83U AS=0.6405P AD=0.8052P
+ PS=2.53U PD=4.54U
* device instance $1924 r0 *1 110.695,99.54 pfet
M$1924 VDD A1|A2|B|B2|C|Z \$821 \$808 pfet L=0.5U W=1.83U AS=0.8052P AD=0.4758P
+ PS=4.54U PD=2.35U
* device instance $1925 r0 *1 111.715,99.54 pfet
M$1925 \$821 B1|ZN$2 VDD \$808 pfet L=0.5U W=1.83U AS=0.4758P AD=0.4758P
+ PS=2.35U PD=2.35U
* device instance $1926 r0 *1 112.735,99.54 pfet
M$1926 A2|ZN$29 A1|ZN$17 \$821 \$808 pfet L=0.5U W=1.83U AS=0.4758P AD=0.4758P
+ PS=2.35U PD=2.35U
* device instance $1927 r0 *1 113.755,99.54 pfet
M$1927 \$821 A2|ZN$42 A2|ZN$29 \$808 pfet L=0.5U W=1.83U AS=0.4758P AD=0.8052P
+ PS=2.35U PD=4.54U
* device instance $1928 r0 *1 120.15,102.06 pfet
M$1928 B|ZN$12 A2|ZN$43 \$843 \$808 pfet L=0.5U W=1.83U AS=0.8052P AD=0.4758P
+ PS=4.54U PD=2.35U
* device instance $1929 r0 *1 121.17,102.06 pfet
M$1929 \$843 A1|ZN$18 B|ZN$12 \$808 pfet L=0.5U W=1.83U AS=0.4758P AD=0.6405P
+ PS=2.35U PD=2.53U
* device instance $1930 r0 *1 122.37,102.06 pfet
M$1930 VDD B|ZN$16 \$843 \$808 pfet L=0.5U W=1.83U AS=0.6405P AD=0.8052P
+ PS=2.53U PD=4.54U
* device instance $1931 r0 *1 129.07,101.875 pfet
M$1931 VDD A1|A2|C|S|ZN A1|ZN$19 \$808 pfet L=0.5U W=1.46U AS=0.6424P
+ AD=0.3796P PS=3.8U PD=1.98U
* device instance $1932 r0 *1 130.09,101.875 pfet
M$1932 A1|ZN$19 B|Z$2 VDD \$808 pfet L=0.5U W=1.46U AS=0.3796P AD=0.585P
+ PS=1.98U PD=2.53U
* device instance $1933 r0 *1 131.29,102.06 pfet
M$1933 \$853 A1|B|Z$1 A1|ZN$19 \$808 pfet L=0.5U W=1.83U AS=0.585P AD=0.4758P
+ PS=2.53U PD=2.35U
* device instance $1934 r0 *1 132.31,102.06 pfet
M$1934 VDD A2|ZN$44 \$853 \$808 pfet L=0.5U W=1.83U AS=0.4758P AD=0.8052P
+ PS=2.35U PD=4.54U
* device instance $1935 r0 *1 132.01,92.3025 pfet
M$1935 \$783 A2|ZN$30 \$793 \$732 pfet L=0.5U W=0.495U AS=0.2178P AD=0.1287P
+ PS=1.87U PD=1.015U
* device instance $1936 r0 *1 133.03,92.3025 pfet
M$1936 \$783 A1|A3|B|Q VDD \$732 pfet L=0.5U W=0.495U AS=0.294375P AD=0.1287P
+ PS=1.765U PD=1.015U
* device instance $1937 r0 *1 134.38,92.0925 pfet
M$1937 \$769 \$793 VDD \$732 pfet L=0.5U W=0.915U AS=0.294375P AD=0.260775P
+ PS=1.765U PD=1.485U
* device instance $1938 r0 *1 135.45,92.0925 pfet
M$1938 \$770 A1|A3|B|Q \$769 \$732 pfet L=0.5U W=0.915U AS=0.260775P AD=0.2379P
+ PS=1.485U PD=1.435U
* device instance $1939 r0 *1 136.47,92.0925 pfet
M$1939 \$769 A2|ZN$30 \$770 \$732 pfet L=0.5U W=0.915U AS=0.2379P AD=0.4026P
+ PS=1.435U PD=2.71U
* device instance $1940 r0 *1 140.345,102.06 pfet
M$1940 \$850 A1|B|C|I|ZN VDD \$808 pfet L=0.5U W=1.83U AS=0.8052P AD=0.5673P
+ PS=4.54U PD=2.45U
* device instance $1941 r0 *1 141.465,102.06 pfet
M$1941 \$847 B|ZN$14 \$850 \$808 pfet L=0.5U W=1.83U AS=0.5673P AD=0.5673P
+ PS=2.45U PD=2.45U
* device instance $1942 r0 *1 142.585,102.06 pfet
M$1942 D|ZN$15 A1|A2|B|B2|C|Z \$847 \$808 pfet L=0.5U W=1.83U AS=0.5673P
+ AD=0.4758P PS=2.45U PD=2.35U
* device instance $1943 r0 *1 143.605,102.06 pfet
M$1943 \$847 A2|Z$4 D|ZN$15 \$808 pfet L=0.5U W=1.83U AS=0.4758P AD=0.8052P
+ PS=2.35U PD=4.54U
* device instance $1944 r0 *1 143.77,99.54 pfet
M$1944 \$822 A2|A3|ZN$2 VDD \$808 pfet L=0.5U W=1.83U AS=0.8052P AD=0.4758P
+ PS=4.54U PD=2.35U
* device instance $1945 r0 *1 144.79,99.54 pfet
M$1945 A2|ZN$34 A1|ZN$14 \$822 \$808 pfet L=0.5U W=1.83U AS=0.4758P AD=0.585P
+ PS=2.35U PD=2.53U
* device instance $1946 r0 *1 145.99,99.725 pfet
M$1946 VDD B|ZN$10 A2|ZN$34 \$808 pfet L=0.5U W=1.46U AS=0.585P AD=0.3796P
+ PS=2.53U PD=1.98U
* device instance $1947 r0 *1 147.01,99.725 pfet
M$1947 A2|ZN$34 C|ZN VDD \$808 pfet L=0.5U W=1.46U AS=0.3796P AD=0.6424P
+ PS=1.98U PD=3.8U
* device instance $1948 r0 *1 14.45,109.5875 pfet
M$1948 \$875 \$874 VDD \$888 pfet L=0.5U W=0.915U AS=0.4026P AD=0.2379P
+ PS=2.71U PD=1.435U
* device instance $1949 r0 *1 15.47,109.5875 pfet
M$1949 \$875 A2|A3|ZN$5 VDD \$888 pfet L=0.5U W=0.915U AS=0.535925P AD=0.2379P
+ PS=2.58U PD=1.435U
* device instance $1950 r0 *1 16.72,109.62 pfet
M$1950 A2|ZN$48 \$875 VDD \$888 pfet L=0.5U W=1.83U AS=0.535925P AD=0.61305P
+ PS=2.58U PD=2.5U
* device instance $1951 r0 *1 17.89,109.62 pfet
M$1951 \$925 A2|A3|ZN$5 A2|ZN$48 \$888 pfet L=0.5U W=1.83U AS=0.61305P
+ AD=0.4758P PS=2.5U PD=2.35U
* device instance $1952 r0 *1 18.91,109.62 pfet
M$1952 VDD \$874 \$925 \$888 pfet L=0.5U W=1.83U AS=0.4758P AD=0.8052P PS=2.35U
+ PD=4.54U
* device instance $1953 r0 *1 24.985,109.5275 pfet
M$1953 A2|ZN$45 A1|ZN$16 VDD \$888 pfet L=0.5U W=1.645U AS=0.7238P AD=0.4277P
+ PS=4.17U PD=2.165U
* device instance $1954 r0 *1 26.005,109.5275 pfet
M$1954 VDD A2|ZN$48 A2|ZN$45 \$888 pfet L=0.5U W=1.645U AS=0.4277P AD=0.7238P
+ PS=2.165U PD=4.17U
* device instance $1955 r0 *1 37.88,109.62 pfet
M$1955 \$927 A2|B|ZN$1 VDD \$888 pfet L=0.5U W=1.83U AS=0.8052P AD=0.52155P
+ PS=4.54U PD=2.4U
* device instance $1956 r0 *1 38.95,109.62 pfet
M$1956 A2|ZN$40 A1|I0|ZN \$927 \$888 pfet L=0.5U W=1.83U AS=0.52155P
+ AD=0.61275P PS=2.4U PD=2.53U
* device instance $1957 r0 *1 40.15,109.7125 pfet
M$1957 VDD A1|A2|B|ZN A2|ZN$40 \$888 pfet L=0.5U W=1.645U AS=0.61275P
+ AD=0.7238P PS=2.53U PD=4.17U
* device instance $1958 r0 *1 53.015,109.62 pfet
M$1958 VDD A1|A2|B2|Z \$914 \$888 pfet L=0.5U W=1.83U AS=0.8052P AD=0.4758P
+ PS=4.54U PD=2.35U
* device instance $1959 r0 *1 54.035,109.62 pfet
M$1959 \$914 B1|ZN$3 VDD \$888 pfet L=0.5U W=1.83U AS=0.4758P AD=0.4758P
+ PS=2.35U PD=2.35U
* device instance $1960 r0 *1 55.055,109.62 pfet
M$1960 A2|ZN$46 A1|ZN$20 \$914 \$888 pfet L=0.5U W=1.83U AS=0.4758P AD=0.4758P
+ PS=2.35U PD=2.35U
* device instance $1961 r0 *1 56.075,109.62 pfet
M$1961 \$914 A2|Z$5 A2|ZN$46 \$888 pfet L=0.5U W=1.83U AS=0.4758P AD=0.8052P
+ PS=2.35U PD=4.54U
* device instance $1962 r0 *1 70.345,102.1525 pfet
M$1962 A2|ZN$41 A1|A2|B|B2|C|Z VDD \$808 pfet L=0.5U W=1.645U AS=0.7238P
+ AD=0.4277P PS=4.17U PD=2.165U
* device instance $1963 r0 *1 71.365,102.1525 pfet
M$1963 VDD A2|ZN$37 A2|ZN$41 \$808 pfet L=0.5U W=1.645U AS=0.4277P AD=0.7238P
+ PS=2.165U PD=4.17U
* device instance $1964 r0 *1 71.53,109.395 pfet
M$1964 VDD CLK|clk \$889 \$888 pfet L=0.5U W=1.38U AS=0.6072P AD=0.3588P
+ PS=3.64U PD=1.9U
* device instance $1965 r0 *1 72.55,109.395 pfet
M$1965 \$880 \$889 VDD \$888 pfet L=0.5U W=1.38U AS=0.3588P AD=0.6072P PS=1.9U
+ PD=3.64U
* device instance $1966 r0 *1 74.59,109.205 pfet
M$1966 \$923 \$880 VDD \$888 pfet L=0.5U W=1U AS=0.9696P AD=0.12P PS=5.04U
+ PD=1.24U
* device instance $1967 r0 *1 75.33,109.205 pfet
M$1967 \$891 D|ZN$16 \$923 \$888 pfet L=0.5U W=1U AS=0.12P AD=0.4P PS=1.24U
+ PD=1.8U
* device instance $1968 r0 *1 76.63,109.205 pfet
M$1968 \$922 \$889 \$891 \$888 pfet L=0.5U W=1U AS=0.4P AD=0.12P PS=1.8U
+ PD=1.24U
* device instance $1969 r0 *1 77.37,109.205 pfet
M$1969 VDD \$881 \$922 \$888 pfet L=0.5U W=1U AS=0.12P AD=0.26P PS=1.24U
+ PD=1.52U
* device instance $1970 r0 *1 78.39,109.205 pfet
M$1970 \$881 \$891 VDD \$888 pfet L=0.5U W=1U AS=0.26P AD=0.26P PS=1.52U
+ PD=1.52U
* device instance $1971 r0 *1 79.41,109.205 pfet
M$1971 \$892 \$889 \$881 \$888 pfet L=0.5U W=1U AS=0.26P AD=0.6P PS=1.52U
+ PD=2.2U
* device instance $1972 r0 *1 81.11,109.205 pfet
M$1972 \$921 \$880 \$892 \$888 pfet L=0.5U W=1U AS=0.6P AD=0.13P PS=2.2U
+ PD=1.26U
* device instance $1973 r0 *1 81.87,109.205 pfet
M$1973 VDD \$882 \$921 \$888 pfet L=0.5U W=1U AS=0.13P AD=0.442P PS=1.26U
+ PD=1.94U
* device instance $1974 r0 *1 83.21,109.255 pfet
M$1974 \$882 \$892 VDD \$888 pfet L=0.5U W=1.1U AS=0.442P AD=0.484P PS=1.94U
+ PD=3.08U
* device instance $1975 r0 *1 84.95,109.62 pfet
M$1975 A1|A2|A4|I|Q \$882 VDD \$888 pfet L=0.5U W=1.83U AS=0.8052P AD=0.8052P
+ PS=4.54U PD=4.54U
* device instance $1976 r0 *1 88.33,109.395 pfet
M$1976 VDD CLK|clk \$893 \$888 pfet L=0.5U W=1.38U AS=0.6072P AD=0.3588P
+ PS=3.64U PD=1.9U
* device instance $1977 r0 *1 89.35,109.395 pfet
M$1977 \$883 \$893 VDD \$888 pfet L=0.5U W=1.38U AS=0.3588P AD=0.6072P PS=1.9U
+ PD=3.64U
* device instance $1978 r0 *1 91.39,109.205 pfet
M$1978 \$920 \$883 VDD \$888 pfet L=0.5U W=1U AS=0.9696P AD=0.12P PS=5.04U
+ PD=1.24U
* device instance $1979 r0 *1 92.13,109.205 pfet
M$1979 \$894 D|ZN$14 \$920 \$888 pfet L=0.5U W=1U AS=0.12P AD=0.4P PS=1.24U
+ PD=1.8U
* device instance $1980 r0 *1 93.43,109.205 pfet
M$1980 \$919 \$893 \$894 \$888 pfet L=0.5U W=1U AS=0.4P AD=0.12P PS=1.8U
+ PD=1.24U
* device instance $1981 r0 *1 94.17,109.205 pfet
M$1981 VDD \$884 \$919 \$888 pfet L=0.5U W=1U AS=0.12P AD=0.26P PS=1.24U
+ PD=1.52U
* device instance $1982 r0 *1 95.19,109.205 pfet
M$1982 \$884 \$894 VDD \$888 pfet L=0.5U W=1U AS=0.26P AD=0.26P PS=1.52U
+ PD=1.52U
* device instance $1983 r0 *1 96.21,109.205 pfet
M$1983 \$895 \$893 \$884 \$888 pfet L=0.5U W=1U AS=0.26P AD=0.6P PS=1.52U
+ PD=2.2U
* device instance $1984 r0 *1 97.91,109.205 pfet
M$1984 \$918 \$883 \$895 \$888 pfet L=0.5U W=1U AS=0.6P AD=0.13P PS=2.2U
+ PD=1.26U
* device instance $1985 r0 *1 98.67,109.205 pfet
M$1985 VDD \$885 \$918 \$888 pfet L=0.5U W=1U AS=0.13P AD=0.442P PS=1.26U
+ PD=1.94U
* device instance $1986 r0 *1 100.01,109.255 pfet
M$1986 \$885 \$895 VDD \$888 pfet L=0.5U W=1.1U AS=0.442P AD=0.484P PS=1.94U
+ PD=3.08U
* device instance $1987 r0 *1 101.75,109.62 pfet
M$1987 A1|A3|I|Q \$885 VDD \$888 pfet L=0.5U W=1.83U AS=0.8052P AD=0.8052P
+ PS=4.54U PD=4.54U
* device instance $1988 r0 *1 117.31,109.62 pfet
M$1988 \$915 B|ZN$15 VDD \$888 pfet L=0.5U W=1.83U AS=0.8052P AD=0.6405P
+ PS=4.54U PD=2.53U
* device instance $1989 r0 *1 118.51,109.62 pfet
M$1989 A2|ZN$47 A1|ZN$18 \$915 \$888 pfet L=0.5U W=1.83U AS=0.6405P AD=0.4758P
+ PS=2.53U PD=2.35U
* device instance $1990 r0 *1 119.53,109.62 pfet
M$1990 \$915 A2|ZN$43 A2|ZN$47 \$888 pfet L=0.5U W=1.83U AS=0.4758P AD=0.8052P
+ PS=2.35U PD=4.54U
* device instance $1991 r0 *1 133.595,109.62 pfet
M$1991 B|ZN$14 A2|Z$6 \$916 \$888 pfet L=0.5U W=1.83U AS=0.8052P AD=0.4758P
+ PS=4.54U PD=2.35U
* device instance $1992 r0 *1 134.615,109.62 pfet
M$1992 \$916 A1|ZN$20 B|ZN$14 \$888 pfet L=0.5U W=1.83U AS=0.4758P AD=0.5673P
+ PS=2.35U PD=2.45U
* device instance $1993 r0 *1 135.735,109.62 pfet
M$1993 \$924 B|ZN$12 \$916 \$888 pfet L=0.5U W=1.83U AS=0.5673P AD=0.5673P
+ PS=2.45U PD=2.45U
* device instance $1994 r0 *1 136.855,109.62 pfet
M$1994 VDD A1|A2|B|B2|C|Z \$924 \$888 pfet L=0.5U W=1.83U AS=0.5673P AD=0.8052P
+ PS=2.45U PD=4.54U
* device instance $1995 r0 *1 8.25,109.5425 pfet
M$1995 \$917 A2|A3|I1|ZN \$873 \$888 pfet L=0.5U W=0.495U AS=0.2178P
+ AD=0.141075P PS=1.87U PD=1.065U
* device instance $1996 r0 *1 9.32,109.5425 pfet
M$1996 VDD A1|A2|I|ZN \$917 \$888 pfet L=0.5U W=0.495U AS=0.141075P AD=0.282P
+ PS=1.065U PD=1.715U
* device instance $1997 r0 *1 10.62,109.7525 pfet
M$1997 \$912 \$873 VDD \$888 pfet L=0.5U W=0.915U AS=0.282P AD=0.260775P
+ PS=1.715U PD=1.485U
* device instance $1998 r0 *1 11.69,109.7525 pfet
M$1998 \$874 A1|A2|I|ZN \$912 \$888 pfet L=0.5U W=0.915U AS=0.260775P
+ AD=0.2379P PS=1.485U PD=1.435U
* device instance $1999 r0 *1 12.71,109.7525 pfet
M$1999 \$912 A2|A3|I1|ZN \$874 \$888 pfet L=0.5U W=0.915U AS=0.2379P AD=0.4026P
+ PS=1.435U PD=2.71U
* device instance $2000 r0 *1 24.955,112.2325 pfet
M$2000 A2|ZN$49 A2|ZN$45 VDD \$888 pfet L=0.5U W=1.645U AS=0.7238P AD=0.4277P
+ PS=4.17U PD=2.165U
* device instance $2001 r0 *1 25.975,112.2325 pfet
M$2001 VDD A1|Z$6 A2|ZN$49 \$888 pfet L=0.5U W=1.645U AS=0.4277P AD=0.7238P
+ PS=2.165U PD=4.17U
* device instance $2002 r0 *1 36.715,112.2325 pfet
M$2002 A2|ZN$51 A1|A2|A3|ZN$1 VDD \$888 pfet L=0.5U W=1.645U AS=0.7238P
+ AD=0.4277P PS=4.17U PD=2.165U
* device instance $2003 r0 *1 37.735,112.2325 pfet
M$2003 VDD A1|A2|I|Q A2|ZN$51 \$888 pfet L=0.5U W=1.645U AS=0.4277P AD=0.7238P
+ PS=2.165U PD=4.17U
* device instance $2004 r0 *1 51.425,111.6825 pfet
M$2004 \$943 A1|ZN$11 \$929 \$888 pfet L=0.5U W=0.915U AS=0.4026P AD=0.2379P
+ PS=2.71U PD=1.435U
* device instance $2005 r0 *1 52.445,111.6825 pfet
M$2005 VDD A2|ZN$36 \$943 \$888 pfet L=0.5U W=0.915U AS=0.2379P AD=0.57645P
+ PS=1.435U PD=2.69U
* device instance $2006 r0 *1 53.805,112.14 pfet
M$2006 A1|Z$7 \$929 VDD \$888 pfet L=0.5U W=1.83U AS=0.57645P AD=0.8052P
+ PS=2.69U PD=4.54U
* device instance $2007 r0 *1 61.355,112.2325 pfet
M$2007 A1|ZN$20 A1|A2|B2|Z VDD \$888 pfet L=0.5U W=1.645U AS=0.7238P AD=0.4277P
+ PS=4.17U PD=2.165U
* device instance $2008 r0 *1 62.375,112.2325 pfet
M$2008 VDD A1|A2|C|S|ZN A1|ZN$20 \$888 pfet L=0.5U W=1.645U AS=0.4277P
+ AD=0.7238P PS=2.165U PD=4.17U
* device instance $2009 r0 *1 71.43,112.14 pfet
M$2009 D|ZN$16 A2|ZN$41 \$931 \$888 pfet L=0.5U W=1.83U AS=0.8052P AD=0.4758P
+ PS=4.54U PD=2.35U
* device instance $2010 r0 *1 72.45,112.14 pfet
M$2010 \$931 A1|ZN$21 D|ZN$16 \$888 pfet L=0.5U W=1.83U AS=0.4758P AD=0.6405P
+ PS=2.35U PD=2.53U
* device instance $2011 r0 *1 73.65,112.14 pfet
M$2011 VDD A1|B|C|I|ZN \$931 \$888 pfet L=0.5U W=1.83U AS=0.6405P AD=0.8052P
+ PS=2.53U PD=4.54U
* device instance $2012 r0 *1 88.28,112.14 pfet
M$2012 \$947 A2|ZN$50 VDD \$888 pfet L=0.5U W=1.83U AS=0.8052P AD=0.5673P
+ PS=4.54U PD=2.45U
* device instance $2013 r0 *1 89.4,112.14 pfet
M$2013 B|ZN$13 A1|A2|B|B2|C|Z \$947 \$888 pfet L=0.5U W=1.83U AS=0.5673P
+ AD=0.8052P PS=2.45U PD=4.54U
* device instance $2014 r0 *1 101.77,112.2175 pfet
M$2014 \$948 A1|A2|ZN$4 \$932 \$888 pfet L=0.5U W=0.495U AS=0.2178P
+ AD=0.141075P PS=1.87U PD=1.065U
* device instance $2015 r0 *1 102.84,112.2175 pfet
M$2015 \$948 A1|A3|B|Q VDD \$888 pfet L=0.5U W=0.495U AS=0.282P AD=0.141075P
+ PS=1.715U PD=1.065U
* device instance $2016 r0 *1 104.14,112.0075 pfet
M$2016 \$933 \$932 VDD \$888 pfet L=0.5U W=0.915U AS=0.282P AD=0.260775P
+ PS=1.715U PD=1.485U
* device instance $2017 r0 *1 105.21,112.0075 pfet
M$2017 \$934 A1|A3|B|Q \$933 \$888 pfet L=0.5U W=0.915U AS=0.260775P AD=0.2379P
+ PS=1.485U PD=1.435U
* device instance $2018 r0 *1 106.23,112.0075 pfet
M$2018 \$933 A1|A2|ZN$4 \$934 \$888 pfet L=0.5U W=0.915U AS=0.2379P AD=0.4026P
+ PS=1.435U PD=2.71U
* device instance $2019 r0 *1 107.97,112.1725 pfet
M$2019 \$935 \$934 VDD \$888 pfet L=0.5U W=0.915U AS=0.4026P AD=0.2379P
+ PS=2.71U PD=1.435U
* device instance $2020 r0 *1 108.99,112.1725 pfet
M$2020 \$935 A3|ZN$1 VDD \$888 pfet L=0.5U W=0.915U AS=0.535925P AD=0.2379P
+ PS=2.58U PD=1.435U
* device instance $2021 r0 *1 110.24,112.14 pfet
M$2021 A2|ZN$43 \$935 VDD \$888 pfet L=0.5U W=1.83U AS=0.535925P AD=0.61305P
+ PS=2.58U PD=2.5U
* device instance $2022 r0 *1 111.41,112.14 pfet
M$2022 \$949 A3|ZN$1 A2|ZN$43 \$888 pfet L=0.5U W=1.83U AS=0.61305P AD=0.4758P
+ PS=2.5U PD=2.35U
* device instance $2023 r0 *1 112.43,112.14 pfet
M$2023 VDD \$934 \$949 \$888 pfet L=0.5U W=1.83U AS=0.4758P AD=0.8052P PS=2.35U
+ PD=4.54U
* device instance $2024 r0 *1 121.91,112.0475 pfet
M$2024 VDD A1|B|Z$1 B|ZN$16 \$888 pfet L=0.5U W=1.645U AS=0.61275P AD=0.7238P
+ PS=2.53U PD=4.17U
* device instance $2025 r0 *1 119.64,112.14 pfet
M$2025 \$950 A2|ZN$43 VDD \$888 pfet L=0.5U W=1.83U AS=0.8052P AD=0.52155P
+ PS=4.54U PD=2.4U
* device instance $2026 r0 *1 120.71,112.14 pfet
M$2026 B|ZN$16 A1|ZN$18 \$950 \$888 pfet L=0.5U W=1.83U AS=0.52155P AD=0.61275P
+ PS=2.4U PD=2.53U
* device instance $2027 r0 *1 125.345,110.0775 pfet
M$2027 \$926 A1|ZN$20 \$886 \$888 pfet L=0.5U W=0.915U AS=0.4026P AD=0.2379P
+ PS=2.71U PD=1.435U
* device instance $2028 r0 *1 126.365,110.0775 pfet
M$2028 \$926 A2|ZN$47 VDD \$888 pfet L=0.5U W=0.915U AS=0.57645P AD=0.2379P
+ PS=2.69U PD=1.435U
* device instance $2029 r0 *1 127.725,109.62 pfet
M$2029 B|Z$2 \$886 VDD \$888 pfet L=0.5U W=1.83U AS=0.57645P AD=0.8052P
+ PS=2.69U PD=4.54U
* device instance $2030 r0 *1 138.17,112.365 pfet
M$2030 VDD CLK|clk \$937 \$888 pfet L=0.5U W=1.38U AS=0.6072P AD=0.3588P
+ PS=3.64U PD=1.9U
* device instance $2031 r0 *1 139.19,112.365 pfet
M$2031 \$938 \$937 VDD \$888 pfet L=0.5U W=1.38U AS=0.3588P AD=0.6072P PS=1.9U
+ PD=3.64U
* device instance $2032 r0 *1 141.23,112.555 pfet
M$2032 \$946 \$938 VDD \$888 pfet L=0.5U W=1U AS=0.9696P AD=0.12P PS=5.04U
+ PD=1.24U
* device instance $2033 r0 *1 141.97,112.555 pfet
M$2033 \$939 D|ZN$15 \$946 \$888 pfet L=0.5U W=1U AS=0.12P AD=0.4P PS=1.24U
+ PD=1.8U
* device instance $2034 r0 *1 143.27,112.555 pfet
M$2034 \$945 \$937 \$939 \$888 pfet L=0.5U W=1U AS=0.4P AD=0.12P PS=1.8U
+ PD=1.24U
* device instance $2035 r0 *1 144.01,112.555 pfet
M$2035 VDD \$940 \$945 \$888 pfet L=0.5U W=1U AS=0.12P AD=0.26P PS=1.24U
+ PD=1.52U
* device instance $2036 r0 *1 145.03,112.555 pfet
M$2036 \$940 \$939 VDD \$888 pfet L=0.5U W=1U AS=0.26P AD=0.26P PS=1.52U
+ PD=1.52U
* device instance $2037 r0 *1 146.05,112.555 pfet
M$2037 \$941 \$937 \$940 \$888 pfet L=0.5U W=1U AS=0.26P AD=0.6P PS=1.52U
+ PD=2.2U
* device instance $2038 r0 *1 147.75,112.555 pfet
M$2038 \$944 \$938 \$941 \$888 pfet L=0.5U W=1U AS=0.6P AD=0.13P PS=2.2U
+ PD=1.26U
* device instance $2039 r0 *1 148.51,112.555 pfet
M$2039 \$944 \$942 VDD \$888 pfet L=0.5U W=1U AS=0.442P AD=0.13P PS=1.94U
+ PD=1.26U
* device instance $2040 r0 *1 149.85,112.505 pfet
M$2040 \$942 \$941 VDD \$888 pfet L=0.5U W=1.1U AS=0.442P AD=0.484P PS=1.94U
+ PD=3.08U
* device instance $2041 r0 *1 151.59,112.14 pfet
M$2041 A1|A3|B|Q \$942 VDD \$888 pfet L=0.5U W=1.83U AS=0.8052P AD=0.8052P
+ PS=4.54U PD=4.54U
* device instance $2042 r0 *1 23.495,122.6725 pfet
M$2042 \$1025 \$992 \$993 \$964 pfet L=0.5U W=0.915U AS=0.4026P AD=0.2447625P
+ PS=2.71U PD=1.45U
* device instance $2043 r0 *1 24.53,122.6725 pfet
M$2043 \$1025 A2|A3|ZN$7 VDD \$964 pfet L=0.5U W=0.915U AS=0.571875P
+ AD=0.2447625P PS=2.68U PD=1.45U
* device instance $2044 r0 *1 25.88,122.215 pfet
M$2044 \$994 \$993 VDD \$964 pfet L=0.5U W=1.83U AS=0.571875P AD=0.52155P
+ PS=2.68U PD=2.4U
* device instance $2045 r0 *1 26.95,122.215 pfet
M$2045 A1|B|Z$2 A2|A3|ZN$7 \$994 \$964 pfet L=0.5U W=1.83U AS=0.52155P
+ AD=0.4758P PS=2.4U PD=2.35U
* device instance $2046 r0 *1 27.97,122.215 pfet
M$2046 \$994 \$992 A1|B|Z$2 \$964 pfet L=0.5U W=1.83U AS=0.4758P AD=1.3176P
+ PS=2.35U PD=5.1U
* device instance $2047 r0 *1 27.29,119.2425 pfet
M$2047 \$989 A2|ZN$49 \$965 \$964 pfet L=0.5U W=0.915U AS=0.4026P AD=0.260775P
+ PS=2.71U PD=1.485U
* device instance $2048 r0 *1 28.36,119.2425 pfet
M$2048 VDD A1|B|Z$2 \$989 \$964 pfet L=0.5U W=0.915U AS=0.260775P AD=0.549P
+ PS=1.485U PD=2.63U
* device instance $2049 r0 *1 29.66,119.7 pfet
M$2049 \$985 \$965 VDD \$964 pfet L=0.5U W=1.83U AS=0.549P AD=0.52155P PS=2.63U
+ PD=2.4U
* device instance $2050 r0 *1 30.73,119.7 pfet
M$2050 A2|Z$7 A1|B|Z$2 \$985 \$964 pfet L=0.5U W=1.83U AS=0.52155P AD=0.4758P
+ PS=2.4U PD=2.35U
* device instance $2051 r0 *1 31.75,119.7 pfet
M$2051 \$985 A2|ZN$49 A2|Z$7 \$964 pfet L=0.5U W=1.83U AS=0.4758P AD=0.8052P
+ PS=2.35U PD=4.54U
* device instance $2052 r0 *1 37.275,119.6075 pfet
M$2052 B|ZN$17 A2|Z$7 VDD \$964 pfet L=0.5U W=1.645U AS=0.7238P AD=0.4277P
+ PS=4.17U PD=2.165U
* device instance $2053 r0 *1 38.295,119.6075 pfet
M$2053 VDD A1|A2|B2|Z B|ZN$17 \$964 pfet L=0.5U W=1.645U AS=0.4277P AD=0.7238P
+ PS=2.165U PD=4.17U
* device instance $2054 r0 *1 36.19,122.1375 pfet
M$2054 \$995 A2|ZN$51 VDD \$964 pfet L=0.5U W=0.915U AS=0.4026P AD=0.2379P
+ PS=2.71U PD=1.435U
* device instance $2055 r0 *1 37.21,122.1375 pfet
M$2055 \$995 A1|B|ZN$2 VDD \$964 pfet L=0.5U W=0.915U AS=0.526125P AD=0.2379P
+ PS=2.58U PD=1.435U
* device instance $2056 r0 *1 38.46,122.22 pfet
M$2056 A2|A3|ZN$7 \$995 VDD \$964 pfet L=0.5U W=1.83U AS=0.526125P AD=0.5673P
+ PS=2.58U PD=2.45U
* device instance $2057 r0 *1 39.58,122.22 pfet
M$2057 \$1027 A1|B|ZN$2 A2|A3|ZN$7 \$964 pfet L=0.5U W=1.83U AS=0.5673P
+ AD=0.52155P PS=2.45U PD=2.4U
* device instance $2058 r0 *1 40.65,122.22 pfet
M$2058 VDD A2|ZN$51 \$1027 \$964 pfet L=0.5U W=1.83U AS=0.52155P AD=0.8052P
+ PS=2.4U PD=4.54U
* device instance $2059 r0 *1 49.73,122.2525 pfet
M$2059 \$1000 \$999 VDD \$964 pfet L=0.5U W=0.915U AS=0.4026P AD=0.2379P
+ PS=2.71U PD=1.435U
* device instance $2060 r0 *1 50.75,122.2525 pfet
M$2060 \$1000 A2|A3|ZN$3 VDD \$964 pfet L=0.5U W=0.915U AS=0.535925P AD=0.2379P
+ PS=2.58U PD=1.435U
* device instance $2061 r0 *1 52,122.22 pfet
M$2061 A2|ZN$56 \$1000 VDD \$964 pfet L=0.5U W=1.83U AS=0.535925P AD=0.61305P
+ PS=2.58U PD=2.5U
* device instance $2062 r0 *1 53.17,122.22 pfet
M$2062 \$1028 A2|A3|ZN$3 A2|ZN$56 \$964 pfet L=0.5U W=1.83U AS=0.61305P
+ AD=0.4758P PS=2.5U PD=2.35U
* device instance $2063 r0 *1 54.19,122.22 pfet
M$2063 VDD \$999 \$1028 \$964 pfet L=0.5U W=1.83U AS=0.4758P AD=0.8052P
+ PS=2.35U PD=4.54U
* device instance $2064 r0 *1 55.325,119.6 pfet
M$2064 A2|ZN$55 A1|A2|A3|ZN$1 VDD \$964 pfet L=0.5U W=1.46U AS=0.6424P
+ AD=0.3796P PS=3.8U PD=1.98U
* device instance $2065 r0 *1 56.345,119.6 pfet
M$2065 VDD A1|A2|A4|I|Q A2|ZN$55 \$964 pfet L=0.5U W=1.46U AS=0.3796P
+ AD=0.3796P PS=1.98U PD=1.98U
* device instance $2066 r0 *1 57.365,119.6 pfet
M$2066 A2|ZN$55 A1|A2|I|Q VDD \$964 pfet L=0.5U W=1.46U AS=0.3796P AD=0.6424P
+ PS=1.98U PD=3.8U
* device instance $2067 r0 *1 60.385,121.7625 pfet
M$2067 \$1017 A1|Z$7 \$1002 \$964 pfet L=0.5U W=0.915U AS=0.4026P AD=0.2379P
+ PS=2.71U PD=1.435U
* device instance $2068 r0 *1 61.405,121.7625 pfet
M$2068 VDD A2|ZN$56 \$1017 \$964 pfet L=0.5U W=0.915U AS=0.2379P AD=0.57645P
+ PS=1.435U PD=2.69U
* device instance $2069 r0 *1 62.765,122.22 pfet
M$2069 A1|Z$8 \$1002 VDD \$964 pfet L=0.5U W=1.83U AS=0.57645P AD=0.8052P
+ PS=2.69U PD=4.54U
* device instance $2070 r0 *1 68.73,119.7 pfet
M$2070 \$990 A2|ZN$54 VDD \$964 pfet L=0.5U W=1.83U AS=0.8052P AD=0.4758P
+ PS=4.54U PD=2.35U
* device instance $2071 r0 *1 69.75,119.7 pfet
M$2071 A1|ZN$21 A1|B|Z$1 \$990 \$964 pfet L=0.5U W=1.83U AS=0.4758P AD=0.585P
+ PS=2.35U PD=2.53U
* device instance $2072 r0 *1 70.95,119.885 pfet
M$2072 VDD B|ZN$17 A1|ZN$21 \$964 pfet L=0.5U W=1.46U AS=0.585P AD=0.3796P
+ PS=2.53U PD=1.98U
* device instance $2073 r0 *1 71.97,119.885 pfet
M$2073 A1|ZN$21 A1|A2|C|S|ZN VDD \$964 pfet L=0.5U W=1.46U AS=0.3796P
+ AD=0.6424P PS=1.98U PD=3.8U
* device instance $2074 r0 *1 75.96,122.22 pfet
M$2074 \$1029 A2|ZN$55 VDD \$964 pfet L=0.5U W=1.83U AS=0.8052P AD=0.5673P
+ PS=4.54U PD=2.45U
* device instance $2075 r0 *1 77.08,122.22 pfet
M$2075 A2|A3|ZN$6 A1|ZN$23 \$1029 \$964 pfet L=0.5U W=1.83U AS=0.5673P
+ AD=0.8052P PS=2.45U PD=4.54U
* device instance $2076 r0 *1 83.815,119.7 pfet
M$2076 VDD A1|A2|B2|Z \$987 \$964 pfet L=0.5U W=1.83U AS=0.8052P AD=0.4758P
+ PS=4.54U PD=2.35U
* device instance $2077 r0 *1 84.835,119.7 pfet
M$2077 \$987 B1|ZN$4 VDD \$964 pfet L=0.5U W=1.83U AS=0.4758P AD=0.4758P
+ PS=2.35U PD=2.35U
* device instance $2078 r0 *1 85.855,119.7 pfet
M$2078 A2|ZN$50 A1|ZN$22 \$987 \$964 pfet L=0.5U W=1.83U AS=0.4758P AD=0.4758P
+ PS=2.35U PD=2.35U
* device instance $2079 r0 *1 86.875,119.7 pfet
M$2079 \$987 A2|ZN$52 A2|ZN$50 \$964 pfet L=0.5U W=1.83U AS=0.4758P AD=0.8052P
+ PS=2.35U PD=4.54U
* device instance $2080 r0 *1 88.12,122.22 pfet
M$2080 \$1030 A1|B|Z$1 A2|ZN$52 \$964 pfet L=0.5U W=1.83U AS=0.8052P AD=0.5673P
+ PS=4.54U PD=2.45U
* device instance $2081 r0 *1 89.24,122.22 pfet
M$2081 VDD A1|A2|B|ZN$1 \$1030 \$964 pfet L=0.5U W=1.83U AS=0.5673P AD=0.8052P
+ PS=2.45U PD=4.54U
* device instance $2082 r0 *1 99.39,119.7 pfet
M$2082 \$988 A1|A3|B|Q VDD \$964 pfet L=0.5U W=1.83U AS=0.8052P AD=0.6405P
+ PS=4.54U PD=2.53U
* device instance $2083 r0 *1 100.59,119.7 pfet
M$2083 A2|ZN$53 A1|A2|Q \$988 \$964 pfet L=0.5U W=1.83U AS=0.6405P AD=0.4758P
+ PS=2.53U PD=2.35U
* device instance $2084 r0 *1 101.61,119.7 pfet
M$2084 \$988 A2|A3|ZN$6 A2|ZN$53 \$964 pfet L=0.5U W=1.83U AS=0.4758P
+ AD=0.8052P PS=2.35U PD=4.54U
* device instance $2085 r0 *1 104.55,122.1275 pfet
M$2085 VDD B|ZN$18 B|ZN$15 \$964 pfet L=0.5U W=1.645U AS=0.61275P AD=0.7238P
+ PS=2.53U PD=4.17U
* device instance $2086 r0 *1 102.28,122.22 pfet
M$2086 \$1031 A2|ZN$53 VDD \$964 pfet L=0.5U W=1.83U AS=0.8052P AD=0.52155P
+ PS=4.54U PD=2.4U
* device instance $2087 r0 *1 103.35,122.22 pfet
M$2087 B|ZN$15 A1|A2|ZN$8 \$1031 \$964 pfet L=0.5U W=1.83U AS=0.52155P
+ AD=0.61275P PS=2.4U PD=2.53U
* device instance $2088 r0 *1 106.155,119.6075 pfet
M$2088 A3|ZN$1 A2|A3|ZN$6 VDD \$964 pfet L=0.5U W=1.645U AS=0.7238P AD=0.4277P
+ PS=4.17U PD=2.165U
* device instance $2089 r0 *1 107.175,119.6075 pfet
M$2089 VDD A1|A2|Q A3|ZN$1 \$964 pfet L=0.5U W=1.645U AS=0.4277P AD=0.7238P
+ PS=2.165U PD=4.17U
* device instance $2090 r0 *1 115.265,121.7625 pfet
M$2090 \$1016 A1|A2|B|ZN$1 \$1007 \$964 pfet L=0.5U W=0.915U AS=0.4026P
+ AD=0.2379P PS=2.71U PD=1.435U
* device instance $2091 r0 *1 116.285,121.7625 pfet
M$2091 VDD A2|C|ZN \$1016 \$964 pfet L=0.5U W=0.915U AS=0.2379P AD=0.57645P
+ PS=1.435U PD=2.69U
* device instance $2092 r0 *1 117.645,122.22 pfet
M$2092 A3|Z$2 \$1007 VDD \$964 pfet L=0.5U W=1.83U AS=0.57645P AD=0.8052P
+ PS=2.69U PD=4.54U
* device instance $2093 r0 *1 125.15,122.035 pfet
M$2093 VDD A2|C|ZN A2|ZN$58 \$964 pfet L=0.5U W=1.46U AS=0.6424P AD=0.3796P
+ PS=3.8U PD=1.98U
* device instance $2094 r0 *1 126.17,122.035 pfet
M$2094 A2|ZN$58 A1|A2|B|ZN$1 VDD \$964 pfet L=0.5U W=1.46U AS=0.3796P AD=0.585P
+ PS=1.98U PD=2.53U
* device instance $2095 r0 *1 127.37,122.22 pfet
M$2095 \$1026 A1|B|Z$3 A2|ZN$58 \$964 pfet L=0.5U W=1.83U AS=0.585P AD=0.4758P
+ PS=2.53U PD=2.35U
* device instance $2096 r0 *1 128.39,122.22 pfet
M$2096 VDD A2|ZN$59 \$1026 \$964 pfet L=0.5U W=1.83U AS=0.4758P AD=0.8052P
+ PS=2.35U PD=4.54U
* device instance $2097 r0 *1 132.47,122.22 pfet
M$2097 A3|ZN$2 A1|A2|ZN$8 \$1013 \$964 pfet L=0.5U W=1.83U AS=0.8052P
+ AD=0.4758P PS=4.54U PD=2.35U
* device instance $2098 r0 *1 133.49,122.22 pfet
M$2098 \$1013 A1|A3|B|Q A3|ZN$2 \$964 pfet L=0.5U W=1.83U AS=0.4758P AD=0.6405P
+ PS=2.35U PD=2.53U
* device instance $2099 r0 *1 134.69,122.22 pfet
M$2099 VDD A1|B|Z$3 \$1013 \$964 pfet L=0.5U W=1.83U AS=0.6405P AD=0.8052P
+ PS=2.53U PD=4.54U
* device instance $2100 r0 *1 17.21,122.5425 pfet
M$2100 \$1024 A2|ZN$27 \$1018 \$964 pfet L=0.5U W=0.495U AS=0.2178P AD=0.1287P
+ PS=1.87U PD=1.015U
* device instance $2101 r0 *1 18.23,122.5425 pfet
M$2101 \$1024 A1|A2|ZN$5 VDD \$964 pfet L=0.5U W=0.495U AS=0.294375P AD=0.1287P
+ PS=1.765U PD=1.015U
* device instance $2102 r0 *1 19.58,122.3325 pfet
M$2102 \$991 \$1018 VDD \$964 pfet L=0.5U W=0.915U AS=0.294375P AD=0.260775P
+ PS=1.765U PD=1.485U
* device instance $2103 r0 *1 20.65,122.3325 pfet
M$2103 \$992 A1|A2|ZN$5 \$991 \$964 pfet L=0.5U W=0.915U AS=0.260775P
+ AD=0.2379P PS=1.485U PD=1.435U
* device instance $2104 r0 *1 21.67,122.3325 pfet
M$2104 \$991 A2|ZN$27 \$992 \$964 pfet L=0.5U W=0.915U AS=0.2379P AD=0.4026P
+ PS=1.435U PD=2.71U
* device instance $2105 r0 *1 19.4,129.78 pfet
M$2105 \$1070 A2|ZN$27 VDD \$1063 pfet L=0.5U W=1.83U AS=0.8052P AD=0.5673P
+ PS=4.54U PD=2.45U
* device instance $2106 r0 *1 20.52,129.78 pfet
M$2106 A1|A2|ZN$8 A1|A2|ZN$5 \$1070 \$1063 pfet L=0.5U W=1.83U AS=0.5673P
+ AD=0.8052P PS=2.45U PD=4.54U
* device instance $2107 r0 *1 24.95,129.78 pfet
M$2107 A2|ZN$60 A2|ZN$45 \$1065 \$1063 pfet L=0.5U W=1.83U AS=0.8052P
+ AD=0.4758P PS=4.54U PD=2.35U
* device instance $2108 r0 *1 25.97,129.78 pfet
M$2108 \$1065 A1|Z$6 A2|ZN$60 \$1063 pfet L=0.5U W=1.83U AS=0.4758P AD=0.6405P
+ PS=2.35U PD=2.53U
* device instance $2109 r0 *1 27.17,129.78 pfet
M$2109 VDD A1|B|Z$2 \$1065 \$1063 pfet L=0.5U W=1.83U AS=0.6405P AD=0.8052P
+ PS=2.53U PD=4.54U
* device instance $2110 r0 *1 38.955,129.6875 pfet
M$2110 A1|A2|ZN$7 A2|A3|Z$2 VDD \$1063 pfet L=0.5U W=1.645U AS=0.7238P
+ AD=0.4277P PS=4.17U PD=2.165U
* device instance $2111 r0 *1 39.975,129.6875 pfet
M$2111 VDD A1|A2|ZN$4 A1|A2|ZN$7 \$1063 pfet L=0.5U W=1.645U AS=0.4277P
+ AD=0.7238P PS=2.165U PD=4.17U
* device instance $2112 r0 *1 41.8,129.78 pfet
M$2112 \$1072 A2|A3|ZN$7 VDD \$1063 pfet L=0.5U W=1.83U AS=0.8052P AD=0.5673P
+ PS=4.54U PD=2.45U
* device instance $2113 r0 *1 42.92,129.78 pfet
M$2113 A1|ZN$24 A1|A2|ZN$7 \$1072 \$1063 pfet L=0.5U W=1.83U AS=0.5673P
+ AD=0.8052P PS=2.45U PD=4.54U
* device instance $2114 r0 *1 43.53,122.2975 pfet
M$2114 \$1015 A1|A2|ZN$7 \$997 \$964 pfet L=0.5U W=0.495U AS=0.2178P
+ AD=0.141075P PS=1.87U PD=1.065U
* device instance $2115 r0 *1 44.6,122.2975 pfet
M$2115 \$1015 A1|B|ZN$2 VDD \$964 pfet L=0.5U W=0.495U AS=0.282P AD=0.141075P
+ PS=1.715U PD=1.065U
* device instance $2116 r0 *1 45.9,122.0875 pfet
M$2116 \$998 \$997 VDD \$964 pfet L=0.5U W=0.915U AS=0.282P AD=0.260775P
+ PS=1.715U PD=1.485U
* device instance $2117 r0 *1 46.97,122.0875 pfet
M$2117 \$999 A1|B|ZN$2 \$998 \$964 pfet L=0.5U W=0.915U AS=0.260775P AD=0.2379P
+ PS=1.485U PD=1.435U
* device instance $2118 r0 *1 47.99,122.0875 pfet
M$2118 \$998 A1|A2|ZN$7 \$999 \$964 pfet L=0.5U W=0.915U AS=0.2379P AD=0.4026P
+ PS=1.435U PD=2.71U
* device instance $2119 r0 *1 51.21,129.78 pfet
M$2119 VDD A1|A2|A4|I|Q A1|B|ZN$2 \$1063 pfet L=0.5U W=1.83U AS=0.8052P
+ AD=0.8052P PS=4.54U PD=4.54U
* device instance $2120 r0 *1 59.675,129.6875 pfet
M$2120 A2|ZN$57 A2|ZN$56 VDD \$1063 pfet L=0.5U W=1.645U AS=0.7238P AD=0.4277P
+ PS=4.17U PD=2.165U
* device instance $2121 r0 *1 60.695,129.6875 pfet
M$2121 VDD A1|Z$7 A2|ZN$57 \$1063 pfet L=0.5U W=1.645U AS=0.4277P AD=0.7238P
+ PS=2.165U PD=4.17U
* device instance $2122 r0 *1 65.275,122.3125 pfet
M$2122 A2|ZN$54 A2|ZN$57 VDD \$964 pfet L=0.5U W=1.645U AS=0.7238P AD=0.4277P
+ PS=4.17U PD=2.165U
* device instance $2123 r0 *1 66.295,122.3125 pfet
M$2123 VDD A1|Z$8 A2|ZN$54 \$964 pfet L=0.5U W=1.645U AS=0.4277P AD=0.7238P
+ PS=2.165U PD=4.17U
* device instance $2124 r0 *1 74.23,129.8625 pfet
M$2124 \$1048 A1|ZN$23 VDD \$1063 pfet L=0.5U W=0.915U AS=0.526125P AD=0.2379P
+ PS=2.58U PD=1.435U
* device instance $2125 r0 *1 75.25,129.8625 pfet
M$2125 VDD A2|ZN$55 \$1048 \$1063 pfet L=0.5U W=0.915U AS=0.2379P AD=0.4026P
+ PS=1.435U PD=2.71U
* device instance $2126 r0 *1 70.79,129.78 pfet
M$2126 \$1073 A2|ZN$55 VDD \$1063 pfet L=0.5U W=1.83U AS=0.8052P AD=0.52155P
+ PS=4.54U PD=2.4U
* device instance $2127 r0 *1 71.86,129.78 pfet
M$2127 A2|ZN$65 A1|ZN$23 \$1073 \$1063 pfet L=0.5U W=1.83U AS=0.52155P
+ AD=0.5673P PS=2.4U PD=2.45U
* device instance $2128 r0 *1 72.98,129.78 pfet
M$2128 VDD \$1048 A2|ZN$65 \$1063 pfet L=0.5U W=1.83U AS=0.5673P AD=0.526125P
+ PS=2.45U PD=2.58U
* device instance $2129 r0 *1 84.875,122.3125 pfet
M$2129 A1|ZN$22 A2|Z$8 VDD \$964 pfet L=0.5U W=1.645U AS=0.7238P AD=0.4277P
+ PS=4.17U PD=2.165U
* device instance $2130 r0 *1 85.895,122.3125 pfet
M$2130 VDD A1|Z$8 A1|ZN$22 \$964 pfet L=0.5U W=1.645U AS=0.4277P AD=0.7238P
+ PS=2.165U PD=4.17U
* device instance $2131 r0 *1 86.6,129.78 pfet
M$2131 \$1071 A2|Z$8 VDD \$1063 pfet L=0.5U W=1.83U AS=0.8052P AD=0.5673P
+ PS=4.54U PD=2.45U
* device instance $2132 r0 *1 87.72,129.78 pfet
M$2132 A1|A2|B|ZN$1 A1|Z$8 \$1071 \$1063 pfet L=0.5U W=1.83U AS=0.5673P
+ AD=0.8052P PS=2.45U PD=4.54U
* device instance $2133 r0 *1 119.625,122.3125 pfet
M$2133 A1|A2|ZN$9 A1|A2|B|ZN$1 VDD \$964 pfet L=0.5U W=1.645U AS=0.7238P
+ AD=0.4277P PS=4.17U PD=2.165U
* device instance $2134 r0 *1 120.645,122.3125 pfet
M$2134 VDD A2|C|ZN A1|A2|ZN$9 \$964 pfet L=0.5U W=1.645U AS=0.4277P AD=0.7238P
+ PS=2.165U PD=4.17U
* device instance $2135 r0 *1 133.73,129.7475 pfet
M$2135 \$1051 \$1050 VDD \$1063 pfet L=0.5U W=0.915U AS=0.4026P AD=0.2379P
+ PS=2.71U PD=1.435U
* device instance $2136 r0 *1 134.75,129.7475 pfet
M$2136 \$1051 A3|ZN$2 VDD \$1063 pfet L=0.5U W=0.915U AS=0.535925P AD=0.2379P
+ PS=2.58U PD=1.435U
* device instance $2137 r0 *1 136,129.78 pfet
M$2137 A2|ZN$44 \$1051 VDD \$1063 pfet L=0.5U W=1.83U AS=0.535925P AD=0.61305P
+ PS=2.58U PD=2.5U
* device instance $2138 r0 *1 137.17,129.78 pfet
M$2138 \$1069 A3|ZN$2 A2|ZN$44 \$1063 pfet L=0.5U W=1.83U AS=0.61305P
+ AD=0.4758P PS=2.5U PD=2.35U
* device instance $2139 r0 *1 138.19,129.78 pfet
M$2139 VDD \$1050 \$1069 \$1063 pfet L=0.5U W=1.83U AS=0.4758P AD=0.8052P
+ PS=2.35U PD=4.54U
* device instance $2140 r0 *1 37.79,132.3 pfet
M$2140 \$1074 B|ZN$21 VDD \$1063 pfet L=0.5U W=1.83U AS=0.8052P AD=0.6405P
+ PS=4.54U PD=2.53U
* device instance $2141 r0 *1 38.99,132.3 pfet
M$2141 A1|ZN$26 A1|ZN$25 \$1074 \$1063 pfet L=0.5U W=1.83U AS=0.6405P
+ AD=0.4758P PS=2.53U PD=2.35U
* device instance $2142 r0 *1 40.01,132.3 pfet
M$2142 \$1074 A2|A3|ZN$3 A1|ZN$26 \$1063 pfet L=0.5U W=1.83U AS=0.4758P
+ AD=0.8052P PS=2.35U PD=4.54U
* device instance $2143 r0 *1 53.61,131.8425 pfet
M$2143 \$1092 A1|ZN$24 \$1082 \$1063 pfet L=0.5U W=0.915U AS=0.4026P
+ AD=0.260775P PS=2.71U PD=1.485U
* device instance $2144 r0 *1 54.68,131.8425 pfet
M$2144 \$1093 A2|ZN$60 \$1092 \$1063 pfet L=0.5U W=0.915U AS=0.260775P
+ AD=0.343125P PS=1.485U PD=1.665U
* device instance $2145 r0 *1 55.93,131.8425 pfet
M$2145 VDD A3|B|ZN$1 \$1093 \$1063 pfet L=0.5U W=0.915U AS=0.343125P
+ AD=0.57645P PS=1.665U PD=2.69U
* device instance $2146 r0 *1 57.29,132.3 pfet
M$2146 A2|Z$9 \$1082 VDD \$1063 pfet L=0.5U W=1.83U AS=0.57645P AD=0.8052P
+ PS=2.69U PD=4.54U
* device instance $2147 r0 *1 73.07,132.115 pfet
M$2147 VDD A1|C|Z A1|ZN$18 \$1063 pfet L=0.5U W=1.46U AS=0.6424P AD=0.3796P
+ PS=3.8U PD=1.98U
* device instance $2148 r0 *1 74.09,132.115 pfet
M$2148 A1|ZN$18 B|ZN$19 VDD \$1063 pfet L=0.5U W=1.46U AS=0.3796P AD=0.585P
+ PS=1.98U PD=2.53U
* device instance $2149 r0 *1 75.29,132.3 pfet
M$2149 \$1095 A1|A2|ZN$8 A1|ZN$18 \$1063 pfet L=0.5U W=1.83U AS=0.585P
+ AD=0.4758P PS=2.53U PD=2.35U
* device instance $2150 r0 *1 76.31,132.3 pfet
M$2150 VDD A2|ZN$61 \$1095 \$1063 pfet L=0.5U W=1.83U AS=0.4758P AD=0.8052P
+ PS=2.35U PD=4.54U
* device instance $2151 r0 *1 90.41,132.3 pfet
M$2151 VDD A1|A3|I|Q A1|ZN$23 \$1063 pfet L=0.5U W=1.83U AS=0.8052P AD=0.8052P
+ PS=4.54U PD=4.54U
* device instance $2152 r0 *1 101.19,132.115 pfet
M$2152 VDD B|ZN$20 A2|A3|ZN$8 \$1063 pfet L=0.5U W=1.46U AS=0.585P AD=0.3796P
+ PS=2.53U PD=1.98U
* device instance $2153 r0 *1 102.21,132.115 pfet
M$2153 A2|A3|ZN$8 B|C|ZN$1 VDD \$1063 pfet L=0.5U W=1.46U AS=0.3796P AD=0.6424P
+ PS=1.98U PD=3.8U
* device instance $2154 r0 *1 98.97,132.3 pfet
M$2154 \$1096 A2|ZN$64 VDD \$1063 pfet L=0.5U W=1.83U AS=0.8052P AD=0.4758P
+ PS=4.54U PD=2.35U
* device instance $2155 r0 *1 99.99,132.3 pfet
M$2155 A2|A3|ZN$8 A1|ZN$26 \$1096 \$1063 pfet L=0.5U W=1.83U AS=0.4758P
+ AD=0.585P PS=2.35U PD=2.53U
* device instance $2156 r0 *1 101.245,129.68 pfet
M$2156 B|ZN$18 A2|A3|ZN$6 VDD \$1063 pfet L=0.5U W=1.46U AS=0.6424P AD=0.3796P
+ PS=3.8U PD=1.98U
* device instance $2157 r0 *1 102.265,129.68 pfet
M$2157 VDD A1|A2|Q B|ZN$18 \$1063 pfet L=0.5U W=1.46U AS=0.3796P AD=0.3796P
+ PS=1.98U PD=1.98U
* device instance $2158 r0 *1 103.285,129.68 pfet
M$2158 B|ZN$18 A1|A3|B|Q VDD \$1063 pfet L=0.5U W=1.46U AS=0.3796P AD=0.6424P
+ PS=1.98U PD=3.8U
* device instance $2159 r0 *1 116.795,129.68 pfet
M$2159 VDD A1|ZN$20 A1|ZN$17 \$1063 pfet L=0.5U W=1.46U AS=0.6424P AD=0.3796P
+ PS=3.8U PD=1.98U
* device instance $2160 r0 *1 117.815,129.68 pfet
M$2160 A1|ZN$17 A1|A2|ZN$9 VDD \$1063 pfet L=0.5U W=1.46U AS=0.3796P AD=0.3796P
+ PS=1.98U PD=1.98U
* device instance $2161 r0 *1 118.835,129.68 pfet
M$2161 VDD A3|Z$2 A1|ZN$17 \$1063 pfet L=0.5U W=1.46U AS=0.3796P AD=0.6424P
+ PS=1.98U PD=3.8U
* device instance $2162 r0 *1 127.53,129.7025 pfet
M$2162 \$1068 A2|ZN$58 \$1049 \$1063 pfet L=0.5U W=0.495U AS=0.2178P
+ AD=0.141075P PS=1.87U PD=1.065U
* device instance $2163 r0 *1 128.6,129.7025 pfet
M$2163 VDD A1|A2|B2|Z \$1068 \$1063 pfet L=0.5U W=0.495U AS=0.141075P AD=0.282P
+ PS=1.065U PD=1.715U
* device instance $2164 r0 *1 129.9,129.9125 pfet
M$2164 \$1067 \$1049 VDD \$1063 pfet L=0.5U W=0.915U AS=0.282P AD=0.260775P
+ PS=1.715U PD=1.485U
* device instance $2165 r0 *1 130.97,129.9125 pfet
M$2165 \$1050 A1|A2|B2|Z \$1067 \$1063 pfet L=0.5U W=0.915U AS=0.260775P
+ AD=0.2379P PS=1.485U PD=1.435U
* device instance $2166 r0 *1 131.99,129.9125 pfet
M$2166 \$1067 A2|ZN$58 \$1050 \$1063 pfet L=0.5U W=0.915U AS=0.2379P AD=0.4026P
+ PS=1.435U PD=2.71U
* device instance $2167 r0 *1 129.335,132.7525 pfet
M$2167 \$1091 \$1088 \$1090 \$1063 pfet L=0.5U W=0.915U AS=0.4026P
+ AD=0.2447625P PS=2.71U PD=1.45U
* device instance $2168 r0 *1 130.37,132.7525 pfet
M$2168 \$1091 A3|ZN$3 VDD \$1063 pfet L=0.5U W=0.915U AS=0.571875P
+ AD=0.2447625P PS=2.68U PD=1.45U
* device instance $2169 r0 *1 131.72,132.295 pfet
M$2169 \$1079 \$1090 VDD \$1063 pfet L=0.5U W=1.83U AS=0.571875P AD=0.52155P
+ PS=2.68U PD=2.4U
* device instance $2170 r0 *1 132.79,132.295 pfet
M$2170 A2|Z$6 A3|ZN$3 \$1079 \$1063 pfet L=0.5U W=1.83U AS=0.52155P AD=0.4758P
+ PS=2.4U PD=2.35U
* device instance $2171 r0 *1 133.81,132.295 pfet
M$2171 \$1079 \$1088 A2|Z$6 \$1063 pfet L=0.5U W=1.83U AS=0.4758P AD=1.3176P
+ PS=2.35U PD=5.1U
* device instance $2172 r0 *1 54.12,139.86 pfet
M$2172 \$1130 A2|ZN$60 VDD \$1127 pfet L=0.5U W=1.83U AS=0.8052P AD=0.52155P
+ PS=4.54U PD=2.4U
* device instance $2173 r0 *1 55.19,139.86 pfet
M$2173 A1|A2|ZN$10 A1|ZN$24 \$1130 \$1127 pfet L=0.5U W=1.83U AS=0.52155P
+ AD=0.61275P PS=2.4U PD=2.53U
* device instance $2174 r0 *1 56.39,139.9525 pfet
M$2174 VDD A3|B|ZN$1 A1|A2|ZN$10 \$1127 pfet L=0.5U W=1.645U AS=0.61275P
+ AD=0.7238P PS=2.53U PD=4.17U
* device instance $2175 r0 *1 61.355,139.7675 pfet
M$2175 B1|ZN$4 A2|Z$9 VDD \$1127 pfet L=0.5U W=1.645U AS=0.7238P AD=0.4277P
+ PS=4.17U PD=2.165U
* device instance $2176 r0 *1 62.375,139.7675 pfet
M$2176 VDD A1|A2|ZN$10 B1|ZN$4 \$1127 pfet L=0.5U W=1.645U AS=0.4277P
+ AD=0.7238P PS=2.165U PD=4.17U
* device instance $2177 r0 *1 70.875,139.7675 pfet
M$2177 A2|ZN$62 A1|A2|ZN$10 VDD \$1127 pfet L=0.5U W=1.645U AS=0.7238P
+ AD=0.4277P PS=4.17U PD=2.165U
* device instance $2178 r0 *1 71.895,139.7675 pfet
M$2178 VDD A1|C|Z A2|ZN$62 \$1127 pfet L=0.5U W=1.645U AS=0.4277P AD=0.7238P
+ PS=2.165U PD=4.17U
* device instance $2179 r0 *1 73.71,139.9425 pfet
M$2179 \$1110 A2|ZN$62 VDD \$1127 pfet L=0.5U W=0.915U AS=0.4026P AD=0.2379P
+ PS=2.71U PD=1.435U
* device instance $2180 r0 *1 74.73,139.9425 pfet
M$2180 \$1110 A1|C|ZN VDD \$1127 pfet L=0.5U W=0.915U AS=0.526125P AD=0.2379P
+ PS=2.58U PD=1.435U
* device instance $2181 r0 *1 75.98,139.86 pfet
M$2181 A2|ZN$63 \$1110 VDD \$1127 pfet L=0.5U W=1.83U AS=0.526125P AD=0.5673P
+ PS=2.58U PD=2.45U
* device instance $2182 r0 *1 77.1,139.86 pfet
M$2182 \$1132 A1|C|ZN A2|ZN$63 \$1127 pfet L=0.5U W=1.83U AS=0.5673P
+ AD=0.52155P PS=2.45U PD=2.4U
* device instance $2183 r0 *1 78.17,139.86 pfet
M$2183 VDD A2|ZN$62 \$1132 \$1127 pfet L=0.5U W=1.83U AS=0.52155P AD=0.8052P
+ PS=2.4U PD=4.54U
* device instance $2184 r0 *1 89.91,139.9425 pfet
M$2184 \$1114 A1|A2|Q VDD \$1127 pfet L=0.5U W=0.915U AS=0.526125P AD=0.2379P
+ PS=2.58U PD=1.435U
* device instance $2185 r0 *1 90.93,139.9425 pfet
M$2185 VDD A2|A3|ZN$6 \$1114 \$1127 pfet L=0.5U W=0.915U AS=0.2379P AD=0.4026P
+ PS=1.435U PD=2.71U
* device instance $2186 r0 *1 86.47,139.86 pfet
M$2186 \$1133 A2|A3|ZN$6 VDD \$1127 pfet L=0.5U W=1.83U AS=0.8052P AD=0.52155P
+ PS=4.54U PD=2.4U
* device instance $2187 r0 *1 87.54,139.86 pfet
M$2187 A2|ZN$61 A1|A2|Q \$1133 \$1127 pfet L=0.5U W=1.83U AS=0.52155P
+ AD=0.5673P PS=2.4U PD=2.45U
* device instance $2188 r0 *1 88.66,139.86 pfet
M$2188 VDD \$1114 A2|ZN$61 \$1127 pfet L=0.5U W=1.83U AS=0.5673P AD=0.526125P
+ PS=2.45U PD=2.58U
* device instance $2189 r0 *1 101.115,139.7675 pfet
M$2189 B|C|ZN$1 A1|A2|ZN$8 VDD \$1127 pfet L=0.5U W=1.645U AS=0.7238P
+ AD=0.4277P PS=4.17U PD=2.165U
* device instance $2190 r0 *1 102.135,139.7675 pfet
M$2190 VDD A1|A3|I|Q B|C|ZN$1 \$1127 pfet L=0.5U W=1.645U AS=0.4277P AD=0.7238P
+ PS=2.165U PD=4.17U
* device instance $2191 r0 *1 111.79,139.9425 pfet
M$2191 \$1115 A1|A2|ZN$4 VDD \$1127 pfet L=0.5U W=0.915U AS=0.4026P AD=0.2379P
+ PS=2.71U PD=1.435U
* device instance $2192 r0 *1 112.81,139.9425 pfet
M$2192 \$1115 A1|A3|B|Q VDD \$1127 pfet L=0.5U W=0.915U AS=0.526125P AD=0.2379P
+ PS=2.58U PD=1.435U
* device instance $2193 r0 *1 114.06,139.86 pfet
M$2193 A2|B|ZN$2 \$1115 VDD \$1127 pfet L=0.5U W=1.83U AS=0.526125P AD=0.5673P
+ PS=2.58U PD=2.45U
* device instance $2194 r0 *1 115.18,139.86 pfet
M$2194 \$1131 A1|A3|B|Q A2|B|ZN$2 \$1127 pfet L=0.5U W=1.83U AS=0.5673P
+ AD=0.52155P PS=2.45U PD=2.4U
* device instance $2195 r0 *1 116.25,139.86 pfet
M$2195 VDD A1|A2|ZN$4 \$1131 \$1127 pfet L=0.5U W=1.83U AS=0.52155P AD=0.8052P
+ PS=2.4U PD=4.54U
* device instance $2196 r0 *1 123.05,132.6225 pfet
M$2196 \$1094 A2|B|ZN$2 \$1086 \$1063 pfet L=0.5U W=0.495U AS=0.2178P
+ AD=0.1287P PS=1.87U PD=1.015U
* device instance $2197 r0 *1 124.07,132.6225 pfet
M$2197 \$1094 A1|A2|ZN$9 VDD \$1063 pfet L=0.5U W=0.495U AS=0.294375P
+ AD=0.1287P PS=1.765U PD=1.015U
* device instance $2198 r0 *1 125.42,132.4125 pfet
M$2198 \$1087 \$1086 VDD \$1063 pfet L=0.5U W=0.915U AS=0.294375P AD=0.260775P
+ PS=1.765U PD=1.485U
* device instance $2199 r0 *1 126.49,132.4125 pfet
M$2199 \$1088 A1|A2|ZN$9 \$1087 \$1063 pfet L=0.5U W=0.915U AS=0.260775P
+ AD=0.2379P PS=1.485U PD=1.435U
* device instance $2200 r0 *1 127.51,132.4125 pfet
M$2200 \$1087 A2|B|ZN$2 \$1088 \$1063 pfet L=0.5U W=0.915U AS=0.2379P
+ AD=0.4026P PS=1.435U PD=2.71U
* device instance $2201 r0 *1 124.59,139.86 pfet
M$2201 \$1129 A2|B|ZN$2 VDD \$1127 pfet L=0.5U W=1.83U AS=0.8052P AD=0.6405P
+ PS=4.54U PD=2.53U
* device instance $2202 r0 *1 125.79,139.86 pfet
M$2202 A2|ZN$59 A1|Z$9 \$1129 \$1127 pfet L=0.5U W=1.83U AS=0.6405P AD=0.4758P
+ PS=2.53U PD=2.35U
* device instance $2203 r0 *1 126.81,139.86 pfet
M$2203 \$1129 A2|A3|ZN$8 A2|ZN$59 \$1127 pfet L=0.5U W=1.83U AS=0.4758P
+ AD=0.8052P PS=2.35U PD=4.54U
* device instance $2204 r0 *1 36.285,139.76 pfet
M$2204 A1|ZN$25 A2|A3|Z$2 VDD \$1127 pfet L=0.5U W=1.46U AS=0.6424P AD=0.3796P
+ PS=3.8U PD=1.98U
* device instance $2205 r0 *1 37.305,139.76 pfet
M$2205 VDD A1|A2|ZN$4 A1|ZN$25 \$1127 pfet L=0.5U W=1.46U AS=0.3796P AD=0.3796P
+ PS=1.98U PD=1.98U
* device instance $2206 r0 *1 38.325,139.76 pfet
M$2206 A1|ZN$25 A1|B|ZN$2 VDD \$1127 pfet L=0.5U W=1.46U AS=0.3796P AD=0.6424P
+ PS=1.98U PD=3.8U
* device instance $2207 r0 *1 37.27,142.38 pfet
M$2207 B|ZN$21 A2|A3|Z$2 \$1134 \$1127 pfet L=0.5U W=1.83U AS=0.8052P
+ AD=0.4758P PS=4.54U PD=2.35U
* device instance $2208 r0 *1 38.29,142.38 pfet
M$2208 \$1134 A1|A2|ZN$4 B|ZN$21 \$1127 pfet L=0.5U W=1.83U AS=0.4758P
+ AD=0.6405P PS=2.35U PD=2.53U
* device instance $2209 r0 *1 39.49,142.38 pfet
M$2209 VDD A1|B|ZN$2 \$1134 \$1127 pfet L=0.5U W=1.83U AS=0.6405P AD=0.8052P
+ PS=2.53U PD=4.54U
* device instance $2210 r0 *1 57.51,142.195 pfet
M$2210 VDD A3|B|ZN$1 B|ZN$19 \$1127 pfet L=0.5U W=1.46U AS=0.585P AD=0.3796P
+ PS=2.53U PD=1.98U
* device instance $2211 r0 *1 58.53,142.195 pfet
M$2211 B|ZN$19 A1|C|ZN VDD \$1127 pfet L=0.5U W=1.46U AS=0.3796P AD=0.6424P
+ PS=1.98U PD=3.8U
* device instance $2212 r0 *1 55.29,142.38 pfet
M$2212 \$1145 A2|ZN$60 VDD \$1127 pfet L=0.5U W=1.83U AS=0.8052P AD=0.4758P
+ PS=4.54U PD=2.35U
* device instance $2213 r0 *1 56.31,142.38 pfet
M$2213 B|ZN$19 A1|ZN$24 \$1145 \$1127 pfet L=0.5U W=1.83U AS=0.4758P AD=0.585P
+ PS=2.35U PD=2.53U
* device instance $2214 r0 *1 75.35,142.2975 pfet
M$2214 \$1136 A1|A2|ZN$4 VDD \$1127 pfet L=0.5U W=0.915U AS=0.526125P
+ AD=0.2379P PS=2.58U PD=1.435U
* device instance $2215 r0 *1 76.37,142.2975 pfet
M$2215 VDD A2|ZN$61 \$1136 \$1127 pfet L=0.5U W=0.915U AS=0.2379P AD=0.4026P
+ PS=1.435U PD=2.71U
* device instance $2216 r0 *1 71.91,142.38 pfet
M$2216 \$1146 A2|ZN$61 VDD \$1127 pfet L=0.5U W=1.83U AS=0.8052P AD=0.52155P
+ PS=4.54U PD=2.4U
* device instance $2217 r0 *1 72.98,142.38 pfet
M$2217 A1|C|ZN A1|A2|ZN$4 \$1146 \$1127 pfet L=0.5U W=1.83U AS=0.52155P
+ AD=0.5673P PS=2.4U PD=2.45U
* device instance $2218 r0 *1 74.1,142.38 pfet
M$2218 VDD \$1136 A1|C|ZN \$1127 pfet L=0.5U W=1.83U AS=0.5673P AD=0.526125P
+ PS=2.45U PD=2.58U
* device instance $2219 r0 *1 86.41,142.38 pfet
M$2219 A2|Z$8 A2|ZN$64 \$1137 \$1127 pfet L=0.5U W=1.83U AS=0.8052P AD=0.4758P
+ PS=4.54U PD=2.35U
* device instance $2220 r0 *1 87.43,142.38 pfet
M$2220 \$1137 A1|ZN$26 A2|Z$8 \$1127 pfet L=0.5U W=1.83U AS=0.4758P AD=0.52155P
+ PS=2.35U PD=2.4U
* device instance $2221 r0 *1 88.5,142.38 pfet
M$2221 VDD \$1139 \$1137 \$1127 pfet L=0.5U W=1.83U AS=0.52155P AD=0.549P
+ PS=2.4U PD=2.63U
* device instance $2222 r0 *1 89.8,142.8375 pfet
M$2222 \$1147 A1|ZN$26 VDD \$1127 pfet L=0.5U W=0.915U AS=0.549P AD=0.260775P
+ PS=2.63U PD=1.485U
* device instance $2223 r0 *1 90.87,142.8375 pfet
M$2223 \$1139 A2|ZN$64 \$1147 \$1127 pfet L=0.5U W=0.915U AS=0.260775P
+ AD=0.4026P PS=1.485U PD=2.71U
* device instance $2224 r0 *1 112.45,142.4125 pfet
M$2224 \$1143 \$1142 VDD \$1127 pfet L=0.5U W=0.915U AS=0.4026P AD=0.2379P
+ PS=2.71U PD=1.435U
* device instance $2225 r0 *1 113.47,142.4125 pfet
M$2225 \$1143 A3|ZN$4 VDD \$1127 pfet L=0.5U W=0.915U AS=0.535925P AD=0.2379P
+ PS=2.58U PD=1.435U
* device instance $2226 r0 *1 114.72,142.38 pfet
M$2226 A2|C|ZN \$1143 VDD \$1127 pfet L=0.5U W=1.83U AS=0.535925P AD=0.61305P
+ PS=2.58U PD=2.5U
* device instance $2227 r0 *1 115.89,142.38 pfet
M$2227 \$1150 A3|ZN$4 A2|C|ZN \$1127 pfet L=0.5U W=1.83U AS=0.61305P AD=0.4758P
+ PS=2.5U PD=2.35U
* device instance $2228 r0 *1 116.91,142.38 pfet
M$2228 VDD \$1142 \$1150 \$1127 pfet L=0.5U W=1.83U AS=0.4758P AD=0.8052P
+ PS=2.35U PD=4.54U
* device instance $2229 r0 *1 123.105,141.9225 pfet
M$2229 \$1148 A1|A2|Q \$1144 \$1127 pfet L=0.5U W=0.915U AS=0.4026P AD=0.2379P
+ PS=2.71U PD=1.435U
* device instance $2230 r0 *1 124.125,141.9225 pfet
M$2230 VDD A1|A2|ZN$8 \$1148 \$1127 pfet L=0.5U W=0.915U AS=0.2379P AD=0.57645P
+ PS=1.435U PD=2.69U
* device instance $2231 r0 *1 125.485,142.38 pfet
M$2231 A1|Z$9 \$1144 VDD \$1127 pfet L=0.5U W=1.83U AS=0.57645P AD=0.8052P
+ PS=2.69U PD=4.54U
* device instance $2232 r0 *1 60.23,150.0225 pfet
M$2232 \$1164 A1|A2|ZN$4 VDD \$1175 pfet L=0.5U W=0.915U AS=0.526125P
+ AD=0.2379P PS=2.58U PD=1.435U
* device instance $2233 r0 *1 61.25,150.0225 pfet
M$2233 VDD A2|ZN$65 \$1164 \$1175 pfet L=0.5U W=0.915U AS=0.2379P AD=0.4026P
+ PS=1.435U PD=2.71U
* device instance $2234 r0 *1 56.79,149.94 pfet
M$2234 \$1176 A2|ZN$65 VDD \$1175 pfet L=0.5U W=1.83U AS=0.8052P AD=0.52155P
+ PS=4.54U PD=2.4U
* device instance $2235 r0 *1 57.86,149.94 pfet
M$2235 A3|B|ZN$1 A1|A2|ZN$4 \$1176 \$1175 pfet L=0.5U W=1.83U AS=0.52155P
+ AD=0.5673P PS=2.4U PD=2.45U
* device instance $2236 r0 *1 58.98,149.94 pfet
M$2236 VDD \$1164 A3|B|ZN$1 \$1175 pfet L=0.5U W=1.83U AS=0.5673P AD=0.526125P
+ PS=2.45U PD=2.58U
* device instance $2237 r0 *1 86.03,150.0225 pfet
M$2237 \$1167 A1|A2|ZN$4 VDD \$1175 pfet L=0.5U W=0.915U AS=0.4026P AD=0.2379P
+ PS=2.71U PD=1.435U
* device instance $2238 r0 *1 87.05,150.0225 pfet
M$2238 \$1167 A1|ZN$23 VDD \$1175 pfet L=0.5U W=0.915U AS=0.526125P AD=0.2379P
+ PS=2.58U PD=1.435U
* device instance $2239 r0 *1 88.3,149.94 pfet
M$2239 A2|ZN$64 \$1167 VDD \$1175 pfet L=0.5U W=1.83U AS=0.526125P AD=0.5673P
+ PS=2.58U PD=2.45U
* device instance $2240 r0 *1 89.42,149.94 pfet
M$2240 \$1179 A1|ZN$23 A2|ZN$64 \$1175 pfet L=0.5U W=1.83U AS=0.5673P
+ AD=0.52155P PS=2.45U PD=2.4U
* device instance $2241 r0 *1 90.49,149.94 pfet
M$2241 VDD A1|A2|ZN$4 \$1179 \$1175 pfet L=0.5U W=1.83U AS=0.52155P AD=0.8052P
+ PS=2.4U PD=4.54U
* device instance $2242 r0 *1 99.48,149.94 pfet
M$2242 \$1178 A2|ZN$64 VDD \$1175 pfet L=0.5U W=1.83U AS=0.8052P AD=0.52155P
+ PS=4.54U PD=2.4U
* device instance $2243 r0 *1 100.55,149.94 pfet
M$2243 A3|ZN$4 A1|ZN$26 \$1178 \$1175 pfet L=0.5U W=1.83U AS=0.52155P
+ AD=0.61275P PS=2.4U PD=2.53U
* device instance $2244 r0 *1 101.75,150.0325 pfet
M$2244 VDD B|C|ZN$1 A3|ZN$4 \$1175 pfet L=0.5U W=1.645U AS=0.61275P AD=0.7238P
+ PS=2.53U PD=4.17U
* device instance $2245 r0 *1 99.995,142.4725 pfet
M$2245 B|ZN$20 A1|A2|ZN$8 VDD \$1127 pfet L=0.5U W=1.645U AS=0.7238P AD=0.4277P
+ PS=4.17U PD=2.165U
* device instance $2246 r0 *1 101.015,142.4725 pfet
M$2246 VDD A1|A2|Q B|ZN$20 \$1127 pfet L=0.5U W=1.645U AS=0.4277P AD=0.7238P
+ PS=2.165U PD=4.17U
* device instance $2247 r0 *1 106.25,142.4575 pfet
M$2247 \$1149 A1|A2|ZN$8 \$1140 \$1127 pfet L=0.5U W=0.495U AS=0.2178P
+ AD=0.141075P PS=1.87U PD=1.065U
* device instance $2248 r0 *1 107.32,142.4575 pfet
M$2248 \$1149 A1|A2|Q VDD \$1127 pfet L=0.5U W=0.495U AS=0.282P AD=0.141075P
+ PS=1.715U PD=1.065U
* device instance $2249 r0 *1 108.62,142.2475 pfet
M$2249 \$1141 \$1140 VDD \$1127 pfet L=0.5U W=0.915U AS=0.282P AD=0.260775P
+ PS=1.715U PD=1.485U
* device instance $2250 r0 *1 109.69,142.2475 pfet
M$2250 \$1142 A1|A2|Q \$1141 \$1127 pfet L=0.5U W=0.915U AS=0.260775P
+ AD=0.2379P PS=1.485U PD=1.435U
* device instance $2251 r0 *1 110.71,142.2475 pfet
M$2251 \$1141 A1|A2|ZN$8 \$1142 \$1127 pfet L=0.5U W=0.915U AS=0.2379P
+ AD=0.4026P PS=1.435U PD=2.71U
* device instance $2252 r0 *1 127.435,142.4725 pfet
M$2252 A3|ZN$3 A2|A3|ZN$8 VDD \$1127 pfet L=0.5U W=1.645U AS=0.7238P AD=0.4277P
+ PS=4.17U PD=2.165U
* device instance $2253 r0 *1 128.455,142.4725 pfet
M$2253 VDD A1|Z$9 A3|ZN$3 \$1127 pfet L=0.5U W=1.645U AS=0.4277P AD=0.7238P
+ PS=2.165U PD=4.17U
* device instance $2254 r0 *1 69.905,150.3975 pfet
M$2254 \$1177 A1|A2|ZN$8 \$1166 \$1175 pfet L=0.5U W=0.915U AS=0.4026P
+ AD=0.2379P PS=2.71U PD=1.435U
* device instance $2255 r0 *1 70.925,150.3975 pfet
M$2255 \$1177 A2|ZN$65 VDD \$1175 pfet L=0.5U W=0.915U AS=0.57645P AD=0.2379P
+ PS=2.69U PD=1.435U
* device instance $2256 r0 *1 72.285,149.94 pfet
M$2256 A1|C|Z \$1166 VDD \$1175 pfet L=0.5U W=1.83U AS=0.57645P AD=0.8052P
+ PS=2.69U PD=4.54U
* device instance $2257 r0 *1 126.31,150.49 pfet
M$2257 VDD A1|Z$9 \$1170 \$1175 pfet L=0.5U W=0.73U AS=0.3212P AD=0.1898P
+ PS=2.34U PD=1.25U
* device instance $2258 r0 *1 127.33,150.49 pfet
M$2258 \$1170 A2|B|ZN$2 VDD \$1175 pfet L=0.5U W=0.73U AS=0.1898P AD=0.1898P
+ PS=1.25U PD=1.25U
* device instance $2259 r0 *1 128.35,150.49 pfet
M$2259 \$1170 A2|A3|ZN$8 VDD \$1175 pfet L=0.5U W=0.73U AS=0.5339P AD=0.1898P
+ PS=2.69U PD=1.25U
* device instance $2260 r0 *1 129.71,149.94 pfet
M$2260 A1|B|Z$3 \$1170 VDD \$1175 pfet L=0.5U W=1.83U AS=0.5339P AD=0.8052P
+ PS=2.69U PD=4.54U
.ENDS tmds_encoder
