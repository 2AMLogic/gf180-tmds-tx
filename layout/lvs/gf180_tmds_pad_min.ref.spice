* Reference (schematic-equivalent) netlist for gf180_tmds_pad_min (issue #2).
* Grounded-gate NMOS (GGNMOS) ESD clamp: drain=PAD, gate=source=body=VSS.
* Plain-element form per klt lvs's schematic-equivalent contract
* (docs/cli/lvs.md "Netlist form"): an M-card naming the klt-curated
* device class "nfet" directly, not a PDK subcircuit call.
.SUBCKT gf180_tmds_pad_min PAD VSS vsubs
M1 PAD VSS VSS vsubs nfet L=0.4U W=2U
.ENDS gf180_tmds_pad_min
