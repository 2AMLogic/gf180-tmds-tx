* Reference (schematic-equivalent) netlist for gf180_tmds_pad_ring_assembly
* (issue #86, T1 item 2 analog block-level assembly), checked against
* design/netlist/cml_driver.spice (issue #11's sized schematic) plus the
* two diode_nd2ps_06v0 ESD clamps and two diode_pd2nw_06v0 VDD-side clamps
* this assembly adds (DR-0011; the VDD-side leg and the VDD port: issue #210).
*
* Same two translations cml_driver_core.ref.spice's own header documents
* (folded W/L per klt lvs's schematic-equivalent contract; bulk stated
* directly, see below) plus one new one this assembly's own substrate tap
* makes possible:
*
*  1. Folded W/L, no nf/m -- unchanged from cml_driver_core.ref.spice, see
*     that file's header and design/cml-driver-sizing.md section 1.3.
*  2. Bulk = VSS, not vsubs. Unlike cml_driver_core.ref.spice (whose NMOS
*     bodies tie only to the deck's synthesized "vsubs" global, since that
*     cell draws no substrate tap), this assembly draws an explicit
*     Pplus/Comp substrate tap wired into the DVSS ring strap and labelled
*     "VSS" (gen_pad_ring_assembly.py's `_draw_substrate_tap`) -- per
*     klayout_tools/decks/gf180mcu.py's issue-#1084 `tap_pplus` derivation,
*     this ties the deck's "vsubs" synthesized net into the real, drawn VSS
*     net. `klt extract`'s own output confirms this: every nfet device's
*     body net is "VSS" directly (device_count for VSS net = 550, no
*     separate "vsubs" net exists at all) -- the exact
*     `device.body_unverified`-class gap DR-0011 flags as open for the
*     "eventual driver-integrated pad" is closed by this assembly, not
*     merely carried forward.
*
* The two ESD clamps: diode_nd2ps_06v0, cathode = the protected output
* (OUTP / OUTN), anode = VSS (same substrate/VSS net the tap above ties
* together) -- gen_pad_ring_assembly.py's `_draw_production_pad`, reusing
* gen_pad_v2.py's own DRC/LVS-verified 20-finger clamp array geometry
* (issue #87/#143/#149), translated per pad. One combined D-card per pad,
* aggregate area/perimeter across all 20 fingers (klt lvs's
* options.combine_devices folds the per-finger extraction back into one
* device per schematic line -- same convention
* layout/lvs/gf180_tmds_pad_v2.ref.spice already established):
*   A_total = 20 * 2.0 um^2  = 40 um^2  -> A=40P
*   P_total = 20 * 6.0 um    = 120 um   -> P=120U
*
* The two VDD-side ESD clamps (issue #210, DR-0011's symmetric P-clamp-toward-
* VDD leg): diode_pd2nw_06v0, anode = the protected output (OUTP / OUTN),
* cathode = VDD (the Nwell, tied to the DVDD ring strap by an Nplus Nwell tap
* and labelled "VDD"). Same 20-finger geometry as the VSS-side leg, so the
* same aggregate card parameters (one combined D-card per pad, as above):
*   A_total = 20 * 2.0 um^2  = 40 um^2  -> A=40P
*   P_total = 20 * 6.0 um    = 120 um   -> P=120U
* VDD is now a real port: the DVDD strap is connected to those clamps and the
* Nwell tap, so `klt extract` no longer reports it as dead metal.
*
* Not modelled here (see gen_pad_ring_assembly.py's own module docstring for
* the full scope note): the CML driver itself has no VDD pin (VDD is carried
* by the ring clamps and the Nwell tap only); INP/INN/IBIAS are not routed to
* pads (out of scope -- this issue targets the *output* pad-ring integration,
* not driver inputs).
.SUBCKT gf180_tmds_pad_ring_assembly OUTP OUTN INP INN IBIAS VSS VDD
M1 OUTP INP TAIL VSS nfet L=0.28U W=128U
M2 OUTN INN TAIL VSS nfet L=0.28U W=128U
MT TAIL IBIAS VSS VSS nfet L=0.5U W=400U
MB IBIAS IBIAS VSS VSS nfet L=0.5U W=20U
D1 VSS OUTP diode_nd2ps_06v0 A=40P P=120U
D2 VSS OUTN diode_nd2ps_06v0 A=40P P=120U
D3 OUTP VDD diode_pd2nw_06v0 A=40P P=120U
D4 OUTN VDD diode_pd2nw_06v0 A=40P P=120U
.ENDS gf180_tmds_pad_ring_assembly
