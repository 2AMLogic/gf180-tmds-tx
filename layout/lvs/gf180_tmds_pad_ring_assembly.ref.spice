* Reference (schematic-equivalent) netlist for gf180_tmds_pad_ring_assembly
* (issue #86, T1 item 2 analog block-level assembly), checked against
* design/netlist/cml_driver.spice (issue #11's sized schematic) plus the
* two diode_nd2ps_06v0 ESD clamps this assembly adds (DR-0011).
*
* Same two translations cml_driver_core.ref.spice's own header documents
* (folded W/L per klt lvs's schematic-equivalent contract; bulk stated
* directly, see below) plus one new one this assembly's own substrate tap
* makes possible:
*
*  1. Folded W/L, no nf/m -- unchanged from cml_driver_core.ref.spice, see
*     that file's header and design/cml-driver-sizing.md section 1.3.
*  2. Bulk = VSS, not vsubs. Unlike cml_driver_core.ref.spice (whose NMOS
*     bodies tie only to the deck's synthesized "vsubs" global, since that
*     cell draws no substrate tap), this assembly draws an explicit
*     Pplus/Comp substrate tap wired into the DVSS ring strap and labelled
*     "VSS" (gen_pad_ring_assembly.py's `_draw_substrate_tap`) -- per
*     klayout_tools/decks/gf180mcu.py's issue-#1084 `tap_pplus` derivation,
*     this ties the deck's "vsubs" synthesized net into the real, drawn VSS
*     net. `klt extract`'s own output confirms this: every nfet device's
*     body net is "VSS" directly (device_count for VSS net = 550, no
*     separate "vsubs" net exists at all) -- the exact
*     `device.body_unverified`-class gap DR-0011 flags as open for the
*     "eventual driver-integrated pad" is closed by this assembly, not
*     merely carried forward.
*
* The two ESD clamps: diode_nd2ps_06v0, cathode = the protected output
* (OUTP / OUTN), anode = VSS (same substrate/VSS net the tap above ties
* together) -- gen_pad_ring_assembly.py's `_draw_production_pad`, reusing
* gen_pad_v2.py's own DRC/LVS-verified 20-finger clamp array geometry
* (issue #87/#143/#149), translated per pad. One combined D-card per pad,
* aggregate area/perimeter across all 20 fingers (klt lvs's
* options.combine_devices folds the per-finger extraction back into one
* device per schematic line -- same convention
* layout/lvs/gf180_tmds_pad_v2.ref.spice already established):
*   A_total = 20 * 2.0 um^2  = 40 um^2  -> A=40P
*   P_total = 20 * 6.0 um    = 120 um   -> P=120U
*
* Not modelled here (see gen_pad_ring_assembly.py's own module docstring
* for the full scope note): the DVDD ring strap (drawn for ring continuity,
* but this driver has no VDD pin and nothing else in this increment
* connects to it -- `klt extract` correctly reports it as disconnected
* "dead metal", not a missing connection); INP/INN/IBIAS are not routed to
* pads (out of scope -- this issue targets the *output* pad-ring
* integration, not driver inputs).
.SUBCKT gf180_tmds_pad_ring_assembly OUTP OUTN INP INN IBIAS VSS
M1 OUTP INP TAIL VSS nfet L=0.28U W=128U
M2 OUTN INN TAIL VSS nfet L=0.28U W=128U
MT TAIL IBIAS VSS VSS nfet L=0.5U W=400U
MB IBIAS IBIAS VSS VSS nfet L=0.5U W=20U
D1 VSS OUTP diode_nd2ps_06v0 A=40P P=120U
D2 VSS OUTN diode_nd2ps_06v0 A=40P P=120U
.ENDS gf180_tmds_pad_ring_assembly
