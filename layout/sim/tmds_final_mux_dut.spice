* tmds_final_mux_dut.spice -- post-layout DUT fragment for tmds_final_mux (issue #311)
*
* GENERATED by layout/scripts/gen_tmds_final_mux_dut.py -- do not edit.
* source        : layout/gds/tmds_final_mux.spice
* source sha256 : 2b236fa8fba4d9da3fb94bfc93ef27a61f3761d2582efa91cc1d77b8869edb4a
* devices       : 658 extracted per-finger nfet devices, bound to nfet_03v3
* resistors     : 4 extracted ppolyf_u bodies, emitted as plain ngspice R elements
*
* Four mechanical translations, all documented in the generator's header:
*   1. MOS class 'nfet' -> PDK subcircuit 'nfet_03v3' (M-card -> X-card),
*      carrying the extracted AS/AD/PS/PD junction geometry through unchanged;
*   2. ppolyf_u R-cards -> plain ngspice R elements carrying the
*      extraction's own ohms, body terminal dropped (the same convention
*      layout/lvs/tmds_final_mux.ref.spice uses for LVS signoff);
*   3. the deck-synthesized body net 'vsubs' tied to VSS in the wrapper below
*      (NMOS-only cell in the common p-substrate -- the sized schematic's
*      own B=VSS);
*   4. the extracted cell renamed tmds_final_mux -> tmds_final_mux_extracted, so that the
*      schematic-level name tmds_final_mux is defined exactly once by the wrapper
*      below -- two same-named .subckt definitions in one deck are resolved
*      silently by ngspice rather than reported.
*
* NOT modelled here (state this in any record taken against this netlist):
*   - no parasitic RC: the source extraction is schematic-equivalent
*     (devices + connectivity); klt extract --parasitics was not used;
*   - no NRD/NRS: the extraction carries no diffusion sheet counts, so
*     nfet_03v3's defaults (0) apply, unlike the schematic DUT;
*   - NO POLY SHEET-RHO CORNER DEPENDENCE. The ppolyf_u bodies are
*     fixed-ohms R elements (translation 2), because the extraction reports
*     ohms with no r_width/r_length and R = rsh*(r_length/r_width) fixes
*     only the ratio. They therefore do NOT move with the
*     res_typical/res_ss/res_ff corner (350/420/280 ohm/sq, a +/-20%
*     spread). design/tmds-final-mux-sizing.md section 3's
*     process-invariance argument -- that RC/RLP/RLN/RREF cancel because
*     they share one rsh_ppolyf_u -- is NOT exercised by a multi-corner run
*     against this DUT: the resistor sheet-rho axis is absent, not swept.
*     Do not attribute the resulting schematic-vs-extracted difference to
*     a layout effect.
*     This is a property of the INPUT, not a klt limitation: klt's --pdk
*     binding is geometry-parameterized for gf180mcu ppolyf_u (r_length/
*     r_width, read off the extracted device), so the way to recover the
*     corner dependence is a --pdk-bound re-extraction feeding a variant of
*     this translator -- NOT a change to the resistor branch below, which
*     has only ohms to work from. Re-verify what that form carries on the
*     MOS side before switching: the committed input is the --deck form
*     precisely because it carries per-device AS/AD/PS/PD.
*
* Not a drop-in --dut for sim/tmds-final-mux-eye: that testbench consumes
*   the composite sim/dut/tmds_output_stage.spice (mux + a real cml_driver).
*   This fragment is the mux half only.

.subckt tmds_final_mux OUTP OUTN D0P D0N D1P D1N CLKP CLKN VDD VSS
* tmds_final_mux_extracted pin order is the extraction's own (alphabetical: the
* schematic's 10 pins, the promoted internal nodes IBIAS, SA, SB, TAIL, TOP, and the body net vsubs).
* IBIAS, SA, SB, TAIL, TOP stay wrapper-internal nodes of unchanged name, so
* sim/tmds-final-mux-eye's v(xmux_m.sa) / v(xmux_m.tail) resolve unchanged.
xcore CLKN CLKP D0N D0P D1N D1P IBIAS OUTN OUTP SA SB TAIL TOP VDD VSS VSS tmds_final_mux_extracted
.ends

* extracted by klt extract --deck gf180mcu
* cell tmds_final_mux
* pin CLKN
* pin CLKP
* pin D0N
* pin D0P
* pin D1N
* pin D1P
* pin IBIAS
* pin OUTN
* pin OUTP
* pin SA
* pin SB
* pin TAIL
* pin TOP
* pin VDD
* pin VSS
* pin vsubs
.SUBCKT tmds_final_mux_extracted CLKN CLKP D0N D0P D1N D1P IBIAS OUTN OUTP SA SB TAIL TOP VDD VSS vsubs
* device instance $1 r0 *1 33.39,1.82 nfet
XM$1 OUTP D0P SA vsubs nfet_03v3 L=0.28U W=2U AS=1P AD=0.58P PS=5U PD=2.58U
* device instance $2 r0 *1 34.25,1.82 nfet
XM$2 SA D0P OUTP vsubs nfet_03v3 L=0.28U W=2U AS=0.58P AD=0.58P PS=2.58U PD=2.58U
* device instance $3 r0 *1 35.11,1.82 nfet
XM$3 OUTP D0P SA vsubs nfet_03v3 L=0.28U W=2U AS=0.58P AD=0.58P PS=2.58U PD=2.58U
* device instance $4 r0 *1 35.97,1.82 nfet
XM$4 SA D0P OUTP vsubs nfet_03v3 L=0.28U W=2U AS=0.58P AD=0.58P PS=2.58U PD=2.58U
* device instance $5 r0 *1 36.83,1.82 nfet
XM$5 OUTP D0P SA vsubs nfet_03v3 L=0.28U W=2U AS=0.58P AD=0.58P PS=2.58U PD=2.58U
* device instance $6 r0 *1 37.69,1.82 nfet
XM$6 SA D0P OUTP vsubs nfet_03v3 L=0.28U W=2U AS=0.58P AD=0.58P PS=2.58U PD=2.58U
* device instance $7 r0 *1 38.55,1.82 nfet
XM$7 OUTP D0P SA vsubs nfet_03v3 L=0.28U W=2U AS=0.58P AD=0.58P PS=2.58U PD=2.58U
* device instance $8 r0 *1 39.41,1.82 nfet
XM$8 SA D0P OUTP vsubs nfet_03v3 L=0.28U W=2U AS=0.58P AD=0.58P PS=2.58U PD=2.58U
* device instance $9 r0 *1 40.27,1.82 nfet
XM$9 OUTP D0P SA vsubs nfet_03v3 L=0.28U W=2U AS=0.58P AD=0.58P PS=2.58U PD=2.58U
* device instance $10 r0 *1 41.13,1.82 nfet
XM$10 SA D0P OUTP vsubs nfet_03v3 L=0.28U W=2U AS=0.58P AD=0.58P PS=2.58U PD=2.58U
* device instance $11 r0 *1 41.99,1.82 nfet
XM$11 OUTP D0P SA vsubs nfet_03v3 L=0.28U W=2U AS=0.58P AD=0.58P PS=2.58U PD=2.58U
* device instance $12 r0 *1 42.85,1.82 nfet
XM$12 SA D0P OUTP vsubs nfet_03v3 L=0.28U W=2U AS=0.58P AD=0.58P PS=2.58U PD=2.58U
* device instance $13 r0 *1 43.71,1.82 nfet
XM$13 OUTP D0P SA vsubs nfet_03v3 L=0.28U W=2U AS=0.58P AD=0.58P PS=2.58U PD=2.58U
* device instance $14 r0 *1 44.57,1.82 nfet
XM$14 SA D0P OUTP vsubs nfet_03v3 L=0.28U W=2U AS=0.58P AD=0.58P PS=2.58U PD=2.58U
* device instance $15 r0 *1 45.43,1.82 nfet
XM$15 OUTP D0P SA vsubs nfet_03v3 L=0.28U W=2U AS=0.58P AD=0.58P PS=2.58U PD=2.58U
* device instance $16 r0 *1 46.29,1.82 nfet
XM$16 SA D0P OUTP vsubs nfet_03v3 L=0.28U W=2U AS=0.58P AD=0.58P PS=2.58U PD=2.58U
* device instance $17 r0 *1 47.15,1.82 nfet
XM$17 OUTP D0P SA vsubs nfet_03v3 L=0.28U W=2U AS=0.58P AD=0.58P PS=2.58U PD=2.58U
* device instance $18 r0 *1 48.01,1.82 nfet
XM$18 SA D0P OUTP vsubs nfet_03v3 L=0.28U W=2U AS=0.58P AD=0.58P PS=2.58U PD=2.58U
* device instance $19 r0 *1 48.87,1.82 nfet
XM$19 OUTP D0P SA vsubs nfet_03v3 L=0.28U W=2U AS=0.58P AD=0.58P PS=2.58U PD=2.58U
* device instance $20 r0 *1 49.73,1.82 nfet
XM$20 SA D0P OUTP vsubs nfet_03v3 L=0.28U W=2U AS=0.58P AD=0.58P PS=2.58U PD=2.58U
* device instance $21 r0 *1 50.59,1.82 nfet
XM$21 OUTP D0P SA vsubs nfet_03v3 L=0.28U W=2U AS=0.58P AD=0.58P PS=2.58U PD=2.58U
* device instance $22 r0 *1 51.45,1.82 nfet
XM$22 SA D0P OUTP vsubs nfet_03v3 L=0.28U W=2U AS=0.58P AD=0.58P PS=2.58U PD=2.58U
* device instance $23 r0 *1 52.31,1.82 nfet
XM$23 OUTP D0P SA vsubs nfet_03v3 L=0.28U W=2U AS=0.58P AD=0.58P PS=2.58U PD=2.58U
* device instance $24 r0 *1 53.17,1.82 nfet
XM$24 SA D0P OUTP vsubs nfet_03v3 L=0.28U W=2U AS=0.58P AD=0.58P PS=2.58U PD=2.58U
* device instance $25 r0 *1 54.03,1.82 nfet
XM$25 OUTP D0P SA vsubs nfet_03v3 L=0.28U W=2U AS=0.58P AD=0.58P PS=2.58U PD=2.58U
* device instance $26 r0 *1 54.89,1.82 nfet
XM$26 SA D0P OUTP vsubs nfet_03v3 L=0.28U W=2U AS=0.58P AD=0.58P PS=2.58U PD=2.58U
* device instance $27 r0 *1 55.75,1.82 nfet
XM$27 OUTP D0P SA vsubs nfet_03v3 L=0.28U W=2U AS=0.58P AD=0.58P PS=2.58U PD=2.58U
* device instance $28 r0 *1 56.61,1.82 nfet
XM$28 SA D0P OUTP vsubs nfet_03v3 L=0.28U W=2U AS=0.58P AD=0.58P PS=2.58U PD=2.58U
* device instance $29 r0 *1 57.47,1.82 nfet
XM$29 OUTP D0P SA vsubs nfet_03v3 L=0.28U W=2U AS=0.58P AD=0.58P PS=2.58U PD=2.58U
* device instance $30 r0 *1 58.33,1.82 nfet
XM$30 SA D0P OUTP vsubs nfet_03v3 L=0.28U W=2U AS=0.58P AD=0.58P PS=2.58U PD=2.58U
* device instance $31 r0 *1 59.19,1.82 nfet
XM$31 OUTP D0P SA vsubs nfet_03v3 L=0.28U W=2U AS=0.58P AD=0.58P PS=2.58U PD=2.58U
* device instance $32 r0 *1 60.05,1.82 nfet
XM$32 SA D0P OUTP vsubs nfet_03v3 L=0.28U W=2U AS=0.58P AD=0.58P PS=2.58U PD=2.58U
* device instance $33 r0 *1 60.91,1.82 nfet
XM$33 OUTP D0P SA vsubs nfet_03v3 L=0.28U W=2U AS=0.58P AD=0.58P PS=2.58U PD=2.58U
* device instance $34 r0 *1 61.77,1.82 nfet
XM$34 SA D0P OUTP vsubs nfet_03v3 L=0.28U W=2U AS=0.58P AD=0.58P PS=2.58U PD=2.58U
* device instance $35 r0 *1 62.63,1.82 nfet
XM$35 OUTP D0P SA vsubs nfet_03v3 L=0.28U W=2U AS=0.58P AD=0.58P PS=2.58U PD=2.58U
* device instance $36 r0 *1 63.49,1.82 nfet
XM$36 SA D0P OUTP vsubs nfet_03v3 L=0.28U W=2U AS=0.58P AD=0.58P PS=2.58U PD=2.58U
* device instance $37 r0 *1 64.35,1.82 nfet
XM$37 OUTP D0P SA vsubs nfet_03v3 L=0.28U W=2U AS=0.58P AD=0.58P PS=2.58U PD=2.58U
* device instance $38 r0 *1 65.21,1.82 nfet
XM$38 SA D0P OUTP vsubs nfet_03v3 L=0.28U W=2U AS=0.58P AD=0.58P PS=2.58U PD=2.58U
* device instance $39 r0 *1 66.07,1.82 nfet
XM$39 OUTP D0P SA vsubs nfet_03v3 L=0.28U W=2U AS=0.58P AD=0.58P PS=2.58U PD=2.58U
* device instance $40 r0 *1 66.93,1.82 nfet
XM$40 SA D0P OUTP vsubs nfet_03v3 L=0.28U W=2U AS=0.58P AD=0.58P PS=2.58U PD=2.58U
* device instance $41 r0 *1 67.79,1.82 nfet
XM$41 OUTP D0P SA vsubs nfet_03v3 L=0.28U W=2U AS=0.58P AD=0.58P PS=2.58U PD=2.58U
* device instance $42 r0 *1 68.65,1.82 nfet
XM$42 SA D0P OUTP vsubs nfet_03v3 L=0.28U W=2U AS=0.58P AD=0.58P PS=2.58U PD=2.58U
* device instance $43 r0 *1 69.51,1.82 nfet
XM$43 OUTP D0P SA vsubs nfet_03v3 L=0.28U W=2U AS=0.58P AD=0.58P PS=2.58U PD=2.58U
* device instance $44 r0 *1 70.37,1.82 nfet
XM$44 SA D0P OUTP vsubs nfet_03v3 L=0.28U W=2U AS=0.58P AD=0.58P PS=2.58U PD=2.58U
* device instance $45 r0 *1 71.23,1.82 nfet
XM$45 OUTP D0P SA vsubs nfet_03v3 L=0.28U W=2U AS=0.58P AD=0.58P PS=2.58U PD=2.58U
* device instance $46 r0 *1 72.09,1.82 nfet
XM$46 SA D0P OUTP vsubs nfet_03v3 L=0.28U W=2U AS=0.58P AD=0.58P PS=2.58U PD=2.58U
* device instance $47 r0 *1 72.95,1.82 nfet
XM$47 OUTP D0P SA vsubs nfet_03v3 L=0.28U W=2U AS=0.58P AD=0.58P PS=2.58U PD=2.58U
* device instance $48 r0 *1 73.81,1.82 nfet
XM$48 SA D0P OUTP vsubs nfet_03v3 L=0.28U W=2U AS=0.58P AD=0.58P PS=2.58U PD=2.58U
* device instance $49 r0 *1 74.67,1.82 nfet
XM$49 OUTP D0P SA vsubs nfet_03v3 L=0.28U W=2U AS=0.58P AD=0.58P PS=2.58U PD=2.58U
* device instance $50 r0 *1 75.53,1.82 nfet
XM$50 SA D0P OUTP vsubs nfet_03v3 L=0.28U W=2U AS=0.58P AD=0.58P PS=2.58U PD=2.58U
* device instance $51 r0 *1 76.39,1.82 nfet
XM$51 OUTP D0P SA vsubs nfet_03v3 L=0.28U W=2U AS=0.58P AD=0.58P PS=2.58U PD=2.58U
* device instance $52 r0 *1 77.25,1.82 nfet
XM$52 SA D0P OUTP vsubs nfet_03v3 L=0.28U W=2U AS=0.58P AD=0.58P PS=2.58U PD=2.58U
* device instance $53 r0 *1 78.11,1.82 nfet
XM$53 OUTP D0P SA vsubs nfet_03v3 L=0.28U W=2U AS=0.58P AD=0.58P PS=2.58U PD=2.58U
* device instance $54 r0 *1 78.97,1.82 nfet
XM$54 SA D0P OUTP vsubs nfet_03v3 L=0.28U W=2U AS=0.58P AD=0.58P PS=2.58U PD=2.58U
* device instance $55 r0 *1 79.83,1.82 nfet
XM$55 OUTP D0P SA vsubs nfet_03v3 L=0.28U W=2U AS=0.58P AD=0.58P PS=2.58U PD=2.58U
* device instance $56 r0 *1 80.69,1.82 nfet
XM$56 SA D0P OUTP vsubs nfet_03v3 L=0.28U W=2U AS=0.58P AD=0.58P PS=2.58U PD=2.58U
* device instance $57 r0 *1 81.55,1.82 nfet
XM$57 OUTP D0P SA vsubs nfet_03v3 L=0.28U W=2U AS=0.58P AD=0.58P PS=2.58U PD=2.58U
* device instance $58 r0 *1 82.41,1.82 nfet
XM$58 SA D0P OUTP vsubs nfet_03v3 L=0.28U W=2U AS=0.58P AD=0.58P PS=2.58U PD=2.58U
* device instance $59 r0 *1 83.27,1.82 nfet
XM$59 OUTP D0P SA vsubs nfet_03v3 L=0.28U W=2U AS=0.58P AD=0.58P PS=2.58U PD=2.58U
* device instance $60 r0 *1 84.13,1.82 nfet
XM$60 SA D0P OUTP vsubs nfet_03v3 L=0.28U W=2U AS=0.58P AD=0.58P PS=2.58U PD=2.58U
* device instance $61 r0 *1 84.99,1.82 nfet
XM$61 OUTP D0P SA vsubs nfet_03v3 L=0.28U W=2U AS=0.58P AD=0.58P PS=2.58U PD=2.58U
* device instance $62 r0 *1 85.85,1.82 nfet
XM$62 SA D0P OUTP vsubs nfet_03v3 L=0.28U W=2U AS=0.58P AD=0.58P PS=2.58U PD=2.58U
* device instance $63 r0 *1 86.71,1.82 nfet
XM$63 OUTP D0P SA vsubs nfet_03v3 L=0.28U W=2U AS=0.58P AD=0.58P PS=2.58U PD=2.58U
* device instance $64 r0 *1 87.57,1.82 nfet
XM$64 SA D0P OUTP vsubs nfet_03v3 L=0.28U W=2U AS=0.58P AD=1P PS=2.58U PD=5U
* device instance $65 r0 *1 129.35,1.82 nfet
XM$65 OUTN D0N SA vsubs nfet_03v3 L=0.28U W=2U AS=1P AD=0.58P PS=5U PD=2.58U
* device instance $66 r0 *1 130.21,1.82 nfet
XM$66 SA D0N OUTN vsubs nfet_03v3 L=0.28U W=2U AS=0.58P AD=0.58P PS=2.58U PD=2.58U
* device instance $67 r0 *1 131.07,1.82 nfet
XM$67 OUTN D0N SA vsubs nfet_03v3 L=0.28U W=2U AS=0.58P AD=0.58P PS=2.58U PD=2.58U
* device instance $68 r0 *1 131.93,1.82 nfet
XM$68 SA D0N OUTN vsubs nfet_03v3 L=0.28U W=2U AS=0.58P AD=0.58P PS=2.58U PD=2.58U
* device instance $69 r0 *1 132.79,1.82 nfet
XM$69 OUTN D0N SA vsubs nfet_03v3 L=0.28U W=2U AS=0.58P AD=0.58P PS=2.58U PD=2.58U
* device instance $70 r0 *1 133.65,1.82 nfet
XM$70 SA D0N OUTN vsubs nfet_03v3 L=0.28U W=2U AS=0.58P AD=0.58P PS=2.58U PD=2.58U
* device instance $71 r0 *1 134.51,1.82 nfet
XM$71 OUTN D0N SA vsubs nfet_03v3 L=0.28U W=2U AS=0.58P AD=0.58P PS=2.58U PD=2.58U
* device instance $72 r0 *1 135.37,1.82 nfet
XM$72 SA D0N OUTN vsubs nfet_03v3 L=0.28U W=2U AS=0.58P AD=0.58P PS=2.58U PD=2.58U
* device instance $73 r0 *1 136.23,1.82 nfet
XM$73 OUTN D0N SA vsubs nfet_03v3 L=0.28U W=2U AS=0.58P AD=0.58P PS=2.58U PD=2.58U
* device instance $74 r0 *1 137.09,1.82 nfet
XM$74 SA D0N OUTN vsubs nfet_03v3 L=0.28U W=2U AS=0.58P AD=0.58P PS=2.58U PD=2.58U
* device instance $75 r0 *1 137.95,1.82 nfet
XM$75 OUTN D0N SA vsubs nfet_03v3 L=0.28U W=2U AS=0.58P AD=0.58P PS=2.58U PD=2.58U
* device instance $76 r0 *1 138.81,1.82 nfet
XM$76 SA D0N OUTN vsubs nfet_03v3 L=0.28U W=2U AS=0.58P AD=0.58P PS=2.58U PD=2.58U
* device instance $77 r0 *1 139.67,1.82 nfet
XM$77 OUTN D0N SA vsubs nfet_03v3 L=0.28U W=2U AS=0.58P AD=0.58P PS=2.58U PD=2.58U
* device instance $78 r0 *1 140.53,1.82 nfet
XM$78 SA D0N OUTN vsubs nfet_03v3 L=0.28U W=2U AS=0.58P AD=0.58P PS=2.58U PD=2.58U
* device instance $79 r0 *1 141.39,1.82 nfet
XM$79 OUTN D0N SA vsubs nfet_03v3 L=0.28U W=2U AS=0.58P AD=0.58P PS=2.58U PD=2.58U
* device instance $80 r0 *1 142.25,1.82 nfet
XM$80 SA D0N OUTN vsubs nfet_03v3 L=0.28U W=2U AS=0.58P AD=0.58P PS=2.58U PD=2.58U
* device instance $81 r0 *1 143.11,1.82 nfet
XM$81 OUTN D0N SA vsubs nfet_03v3 L=0.28U W=2U AS=0.58P AD=0.58P PS=2.58U PD=2.58U
* device instance $82 r0 *1 143.97,1.82 nfet
XM$82 SA D0N OUTN vsubs nfet_03v3 L=0.28U W=2U AS=0.58P AD=0.58P PS=2.58U PD=2.58U
* device instance $83 r0 *1 144.83,1.82 nfet
XM$83 OUTN D0N SA vsubs nfet_03v3 L=0.28U W=2U AS=0.58P AD=0.58P PS=2.58U PD=2.58U
* device instance $84 r0 *1 145.69,1.82 nfet
XM$84 SA D0N OUTN vsubs nfet_03v3 L=0.28U W=2U AS=0.58P AD=0.58P PS=2.58U PD=2.58U
* device instance $85 r0 *1 146.55,1.82 nfet
XM$85 OUTN D0N SA vsubs nfet_03v3 L=0.28U W=2U AS=0.58P AD=0.58P PS=2.58U PD=2.58U
* device instance $86 r0 *1 147.41,1.82 nfet
XM$86 SA D0N OUTN vsubs nfet_03v3 L=0.28U W=2U AS=0.58P AD=0.58P PS=2.58U PD=2.58U
* device instance $87 r0 *1 148.27,1.82 nfet
XM$87 OUTN D0N SA vsubs nfet_03v3 L=0.28U W=2U AS=0.58P AD=0.58P PS=2.58U PD=2.58U
* device instance $88 r0 *1 149.13,1.82 nfet
XM$88 SA D0N OUTN vsubs nfet_03v3 L=0.28U W=2U AS=0.58P AD=0.58P PS=2.58U PD=2.58U
* device instance $89 r0 *1 149.99,1.82 nfet
XM$89 OUTN D0N SA vsubs nfet_03v3 L=0.28U W=2U AS=0.58P AD=0.58P PS=2.58U PD=2.58U
* device instance $90 r0 *1 150.85,1.82 nfet
XM$90 SA D0N OUTN vsubs nfet_03v3 L=0.28U W=2U AS=0.58P AD=0.58P PS=2.58U PD=2.58U
* device instance $91 r0 *1 151.71,1.82 nfet
XM$91 OUTN D0N SA vsubs nfet_03v3 L=0.28U W=2U AS=0.58P AD=0.58P PS=2.58U PD=2.58U
* device instance $92 r0 *1 152.57,1.82 nfet
XM$92 SA D0N OUTN vsubs nfet_03v3 L=0.28U W=2U AS=0.58P AD=0.58P PS=2.58U PD=2.58U
* device instance $93 r0 *1 153.43,1.82 nfet
XM$93 OUTN D0N SA vsubs nfet_03v3 L=0.28U W=2U AS=0.58P AD=0.58P PS=2.58U PD=2.58U
* device instance $94 r0 *1 154.29,1.82 nfet
XM$94 SA D0N OUTN vsubs nfet_03v3 L=0.28U W=2U AS=0.58P AD=0.58P PS=2.58U PD=2.58U
* device instance $95 r0 *1 155.15,1.82 nfet
XM$95 OUTN D0N SA vsubs nfet_03v3 L=0.28U W=2U AS=0.58P AD=0.58P PS=2.58U PD=2.58U
* device instance $96 r0 *1 156.01,1.82 nfet
XM$96 SA D0N OUTN vsubs nfet_03v3 L=0.28U W=2U AS=0.58P AD=0.58P PS=2.58U PD=2.58U
* device instance $97 r0 *1 156.87,1.82 nfet
XM$97 OUTN D0N SA vsubs nfet_03v3 L=0.28U W=2U AS=0.58P AD=0.58P PS=2.58U PD=2.58U
* device instance $98 r0 *1 157.73,1.82 nfet
XM$98 SA D0N OUTN vsubs nfet_03v3 L=0.28U W=2U AS=0.58P AD=0.58P PS=2.58U PD=2.58U
* device instance $99 r0 *1 158.59,1.82 nfet
XM$99 OUTN D0N SA vsubs nfet_03v3 L=0.28U W=2U AS=0.58P AD=0.58P PS=2.58U PD=2.58U
* device instance $100 r0 *1 159.45,1.82 nfet
XM$100 SA D0N OUTN vsubs nfet_03v3 L=0.28U W=2U AS=0.58P AD=0.58P PS=2.58U PD=2.58U
* device instance $101 r0 *1 160.31,1.82 nfet
XM$101 OUTN D0N SA vsubs nfet_03v3 L=0.28U W=2U AS=0.58P AD=0.58P PS=2.58U PD=2.58U
* device instance $102 r0 *1 161.17,1.82 nfet
XM$102 SA D0N OUTN vsubs nfet_03v3 L=0.28U W=2U AS=0.58P AD=0.58P PS=2.58U PD=2.58U
* device instance $103 r0 *1 162.03,1.82 nfet
XM$103 OUTN D0N SA vsubs nfet_03v3 L=0.28U W=2U AS=0.58P AD=0.58P PS=2.58U PD=2.58U
* device instance $104 r0 *1 162.89,1.82 nfet
XM$104 SA D0N OUTN vsubs nfet_03v3 L=0.28U W=2U AS=0.58P AD=0.58P PS=2.58U PD=2.58U
* device instance $105 r0 *1 163.75,1.82 nfet
XM$105 OUTN D0N SA vsubs nfet_03v3 L=0.28U W=2U AS=0.58P AD=0.58P PS=2.58U PD=2.58U
* device instance $106 r0 *1 164.61,1.82 nfet
XM$106 SA D0N OUTN vsubs nfet_03v3 L=0.28U W=2U AS=0.58P AD=0.58P PS=2.58U PD=2.58U
* device instance $107 r0 *1 165.47,1.82 nfet
XM$107 OUTN D0N SA vsubs nfet_03v3 L=0.28U W=2U AS=0.58P AD=0.58P PS=2.58U PD=2.58U
* device instance $108 r0 *1 166.33,1.82 nfet
XM$108 SA D0N OUTN vsubs nfet_03v3 L=0.28U W=2U AS=0.58P AD=0.58P PS=2.58U PD=2.58U
* device instance $109 r0 *1 167.19,1.82 nfet
XM$109 OUTN D0N SA vsubs nfet_03v3 L=0.28U W=2U AS=0.58P AD=0.58P PS=2.58U PD=2.58U
* device instance $110 r0 *1 168.05,1.82 nfet
XM$110 SA D0N OUTN vsubs nfet_03v3 L=0.28U W=2U AS=0.58P AD=0.58P PS=2.58U PD=2.58U
* device instance $111 r0 *1 168.91,1.82 nfet
XM$111 OUTN D0N SA vsubs nfet_03v3 L=0.28U W=2U AS=0.58P AD=0.58P PS=2.58U PD=2.58U
* device instance $112 r0 *1 169.77,1.82 nfet
XM$112 SA D0N OUTN vsubs nfet_03v3 L=0.28U W=2U AS=0.58P AD=0.58P PS=2.58U PD=2.58U
* device instance $113 r0 *1 170.63,1.82 nfet
XM$113 OUTN D0N SA vsubs nfet_03v3 L=0.28U W=2U AS=0.58P AD=0.58P PS=2.58U PD=2.58U
* device instance $114 r0 *1 171.49,1.82 nfet
XM$114 SA D0N OUTN vsubs nfet_03v3 L=0.28U W=2U AS=0.58P AD=0.58P PS=2.58U PD=2.58U
* device instance $115 r0 *1 172.35,1.82 nfet
XM$115 OUTN D0N SA vsubs nfet_03v3 L=0.28U W=2U AS=0.58P AD=0.58P PS=2.58U PD=2.58U
* device instance $116 r0 *1 173.21,1.82 nfet
XM$116 SA D0N OUTN vsubs nfet_03v3 L=0.28U W=2U AS=0.58P AD=0.58P PS=2.58U PD=2.58U
* device instance $117 r0 *1 174.07,1.82 nfet
XM$117 OUTN D0N SA vsubs nfet_03v3 L=0.28U W=2U AS=0.58P AD=0.58P PS=2.58U PD=2.58U
* device instance $118 r0 *1 174.93,1.82 nfet
XM$118 SA D0N OUTN vsubs nfet_03v3 L=0.28U W=2U AS=0.58P AD=0.58P PS=2.58U PD=2.58U
* device instance $119 r0 *1 175.79,1.82 nfet
XM$119 OUTN D0N SA vsubs nfet_03v3 L=0.28U W=2U AS=0.58P AD=0.58P PS=2.58U PD=2.58U
* device instance $120 r0 *1 176.65,1.82 nfet
XM$120 SA D0N OUTN vsubs nfet_03v3 L=0.28U W=2U AS=0.58P AD=0.58P PS=2.58U PD=2.58U
* device instance $121 r0 *1 177.51,1.82 nfet
XM$121 OUTN D0N SA vsubs nfet_03v3 L=0.28U W=2U AS=0.58P AD=0.58P PS=2.58U PD=2.58U
* device instance $122 r0 *1 178.37,1.82 nfet
XM$122 SA D0N OUTN vsubs nfet_03v3 L=0.28U W=2U AS=0.58P AD=0.58P PS=2.58U PD=2.58U
* device instance $123 r0 *1 179.23,1.82 nfet
XM$123 OUTN D0N SA vsubs nfet_03v3 L=0.28U W=2U AS=0.58P AD=0.58P PS=2.58U PD=2.58U
* device instance $124 r0 *1 180.09,1.82 nfet
XM$124 SA D0N OUTN vsubs nfet_03v3 L=0.28U W=2U AS=0.58P AD=0.58P PS=2.58U PD=2.58U
* device instance $125 r0 *1 180.95,1.82 nfet
XM$125 OUTN D0N SA vsubs nfet_03v3 L=0.28U W=2U AS=0.58P AD=0.58P PS=2.58U PD=2.58U
* device instance $126 r0 *1 181.81,1.82 nfet
XM$126 SA D0N OUTN vsubs nfet_03v3 L=0.28U W=2U AS=0.58P AD=0.58P PS=2.58U PD=2.58U
* device instance $127 r0 *1 182.67,1.82 nfet
XM$127 OUTN D0N SA vsubs nfet_03v3 L=0.28U W=2U AS=0.58P AD=0.58P PS=2.58U PD=2.58U
* device instance $128 r0 *1 183.53,1.82 nfet
XM$128 SA D0N OUTN vsubs nfet_03v3 L=0.28U W=2U AS=0.58P AD=1P PS=2.58U PD=5U
* device instance $129 r0 *1 1,30.74 nfet
XM$129 IBIAS IBIAS VSS vsubs nfet_03v3 L=0.5U W=2U AS=1P AD=0.58P PS=5U PD=2.58U
* device instance $130 r0 *1 2.08,30.74 nfet
XM$130 VSS IBIAS IBIAS vsubs nfet_03v3 L=0.5U W=2U AS=0.58P AD=0.58P PS=2.58U PD=2.58U
* device instance $131 r0 *1 3.16,30.74 nfet
XM$131 IBIAS IBIAS VSS vsubs nfet_03v3 L=0.5U W=2U AS=0.58P AD=0.58P PS=2.58U PD=2.58U
* device instance $132 r0 *1 4.24,30.74 nfet
XM$132 VSS IBIAS IBIAS vsubs nfet_03v3 L=0.5U W=2U AS=0.58P AD=0.58P PS=2.58U PD=2.58U
* device instance $133 r0 *1 5.32,30.74 nfet
XM$133 IBIAS IBIAS VSS vsubs nfet_03v3 L=0.5U W=2U AS=0.58P AD=0.58P PS=2.58U PD=2.58U
* device instance $134 r0 *1 6.4,30.74 nfet
XM$134 VSS IBIAS IBIAS vsubs nfet_03v3 L=0.5U W=2U AS=0.58P AD=0.58P PS=2.58U PD=2.58U
* device instance $135 r0 *1 7.48,30.74 nfet
XM$135 IBIAS IBIAS VSS vsubs nfet_03v3 L=0.5U W=2U AS=0.58P AD=0.58P PS=2.58U PD=2.58U
* device instance $136 r0 *1 8.56,30.74 nfet
XM$136 VSS IBIAS IBIAS vsubs nfet_03v3 L=0.5U W=2U AS=0.58P AD=0.58P PS=2.58U PD=2.58U
* device instance $137 r0 *1 9.64,30.74 nfet
XM$137 IBIAS IBIAS VSS vsubs nfet_03v3 L=0.5U W=2U AS=0.58P AD=0.58P PS=2.58U PD=2.58U
* device instance $138 r0 *1 10.72,30.74 nfet
XM$138 VSS IBIAS IBIAS vsubs nfet_03v3 L=0.5U W=2U AS=0.58P AD=1P PS=2.58U PD=5U
* device instance $139 r0 *1 109,45.2 nfet
XM$139 TAIL IBIAS VSS vsubs nfet_03v3 L=0.5U W=2U AS=0.58P AD=0.58P PS=2.58U PD=2.58U
* device instance $140 r0 *1 110.08,45.2 nfet
XM$140 VSS IBIAS TAIL vsubs nfet_03v3 L=0.5U W=2U AS=0.58P AD=0.58P PS=2.58U PD=2.58U
* device instance $141 r0 *1 111.16,45.2 nfet
XM$141 TAIL IBIAS VSS vsubs nfet_03v3 L=0.5U W=2U AS=0.58P AD=0.58P PS=2.58U PD=2.58U
* device instance $142 r0 *1 112.24,45.2 nfet
XM$142 VSS IBIAS TAIL vsubs nfet_03v3 L=0.5U W=2U AS=0.58P AD=0.58P PS=2.58U PD=2.58U
* device instance $143 r0 *1 113.32,45.2 nfet
XM$143 TAIL IBIAS VSS vsubs nfet_03v3 L=0.5U W=2U AS=0.58P AD=0.58P PS=2.58U PD=2.58U
* device instance $144 r0 *1 114.4,45.2 nfet
XM$144 VSS IBIAS TAIL vsubs nfet_03v3 L=0.5U W=2U AS=0.58P AD=0.58P PS=2.58U PD=2.58U
* device instance $145 r0 *1 115.48,45.2 nfet
XM$145 TAIL IBIAS VSS vsubs nfet_03v3 L=0.5U W=2U AS=0.58P AD=0.58P PS=2.58U PD=2.58U
* device instance $146 r0 *1 116.56,45.2 nfet
XM$146 VSS IBIAS TAIL vsubs nfet_03v3 L=0.5U W=2U AS=0.58P AD=0.58P PS=2.58U PD=2.58U
* device instance $147 r0 *1 117.64,45.2 nfet
XM$147 TAIL IBIAS VSS vsubs nfet_03v3 L=0.5U W=2U AS=0.58P AD=0.58P PS=2.58U PD=2.58U
* device instance $148 r0 *1 118.72,45.2 nfet
XM$148 VSS IBIAS TAIL vsubs nfet_03v3 L=0.5U W=2U AS=0.58P AD=0.58P PS=2.58U PD=2.58U
* device instance $149 r0 *1 119.8,45.2 nfet
XM$149 TAIL IBIAS VSS vsubs nfet_03v3 L=0.5U W=2U AS=0.58P AD=0.58P PS=2.58U PD=2.58U
* device instance $150 r0 *1 120.88,45.2 nfet
XM$150 VSS IBIAS TAIL vsubs nfet_03v3 L=0.5U W=2U AS=0.58P AD=0.58P PS=2.58U PD=2.58U
* device instance $151 r0 *1 121.96,45.2 nfet
XM$151 TAIL IBIAS VSS vsubs nfet_03v3 L=0.5U W=2U AS=0.58P AD=0.58P PS=2.58U PD=2.58U
* device instance $152 r0 *1 123.04,45.2 nfet
XM$152 VSS IBIAS TAIL vsubs nfet_03v3 L=0.5U W=2U AS=0.58P AD=0.58P PS=2.58U PD=2.58U
* device instance $153 r0 *1 124.12,45.2 nfet
XM$153 TAIL IBIAS VSS vsubs nfet_03v3 L=0.5U W=2U AS=0.58P AD=0.58P PS=2.58U PD=2.58U
* device instance $154 r0 *1 125.2,45.2 nfet
XM$154 VSS IBIAS TAIL vsubs nfet_03v3 L=0.5U W=2U AS=0.58P AD=0.58P PS=2.58U PD=2.58U
* device instance $155 r0 *1 126.28,45.2 nfet
XM$155 TAIL IBIAS VSS vsubs nfet_03v3 L=0.5U W=2U AS=0.58P AD=0.58P PS=2.58U PD=2.58U
* device instance $156 r0 *1 127.36,45.2 nfet
XM$156 VSS IBIAS TAIL vsubs nfet_03v3 L=0.5U W=2U AS=0.58P AD=0.58P PS=2.58U PD=2.58U
* device instance $157 r0 *1 128.44,45.2 nfet
XM$157 TAIL IBIAS VSS vsubs nfet_03v3 L=0.5U W=2U AS=0.58P AD=0.58P PS=2.58U PD=2.58U
* device instance $158 r0 *1 129.52,45.2 nfet
XM$158 VSS IBIAS TAIL vsubs nfet_03v3 L=0.5U W=2U AS=0.58P AD=0.58P PS=2.58U PD=2.58U
* device instance $159 r0 *1 130.6,45.2 nfet
XM$159 TAIL IBIAS VSS vsubs nfet_03v3 L=0.5U W=2U AS=0.58P AD=0.58P PS=2.58U PD=2.58U
* device instance $160 r0 *1 131.68,45.2 nfet
XM$160 VSS IBIAS TAIL vsubs nfet_03v3 L=0.5U W=2U AS=0.58P AD=0.58P PS=2.58U PD=2.58U
* device instance $161 r0 *1 132.76,45.2 nfet
XM$161 TAIL IBIAS VSS vsubs nfet_03v3 L=0.5U W=2U AS=0.58P AD=0.58P PS=2.58U PD=2.58U
* device instance $162 r0 *1 133.84,45.2 nfet
XM$162 VSS IBIAS TAIL vsubs nfet_03v3 L=0.5U W=2U AS=0.58P AD=0.58P PS=2.58U PD=2.58U
* device instance $163 r0 *1 134.92,45.2 nfet
XM$163 TAIL IBIAS VSS vsubs nfet_03v3 L=0.5U W=2U AS=0.58P AD=0.58P PS=2.58U PD=2.58U
* device instance $164 r0 *1 136,45.2 nfet
XM$164 VSS IBIAS TAIL vsubs nfet_03v3 L=0.5U W=2U AS=0.58P AD=0.58P PS=2.58U PD=2.58U
* device instance $165 r0 *1 137.08,45.2 nfet
XM$165 TAIL IBIAS VSS vsubs nfet_03v3 L=0.5U W=2U AS=0.58P AD=0.58P PS=2.58U PD=2.58U
* device instance $166 r0 *1 138.16,45.2 nfet
XM$166 VSS IBIAS TAIL vsubs nfet_03v3 L=0.5U W=2U AS=0.58P AD=0.58P PS=2.58U PD=2.58U
* device instance $167 r0 *1 139.24,45.2 nfet
XM$167 TAIL IBIAS VSS vsubs nfet_03v3 L=0.5U W=2U AS=0.58P AD=0.58P PS=2.58U PD=2.58U
* device instance $168 r0 *1 140.32,45.2 nfet
XM$168 VSS IBIAS TAIL vsubs nfet_03v3 L=0.5U W=2U AS=0.58P AD=0.58P PS=2.58U PD=2.58U
* device instance $169 r0 *1 141.4,45.2 nfet
XM$169 TAIL IBIAS VSS vsubs nfet_03v3 L=0.5U W=2U AS=0.58P AD=0.58P PS=2.58U PD=2.58U
* device instance $170 r0 *1 142.48,45.2 nfet
XM$170 VSS IBIAS TAIL vsubs nfet_03v3 L=0.5U W=2U AS=0.58P AD=0.58P PS=2.58U PD=2.58U
* device instance $171 r0 *1 143.56,45.2 nfet
XM$171 TAIL IBIAS VSS vsubs nfet_03v3 L=0.5U W=2U AS=0.58P AD=0.58P PS=2.58U PD=2.58U
* device instance $172 r0 *1 144.64,45.2 nfet
XM$172 VSS IBIAS TAIL vsubs nfet_03v3 L=0.5U W=2U AS=0.58P AD=0.58P PS=2.58U PD=2.58U
* device instance $173 r0 *1 145.72,45.2 nfet
XM$173 TAIL IBIAS VSS vsubs nfet_03v3 L=0.5U W=2U AS=0.58P AD=0.58P PS=2.58U PD=2.58U
* device instance $174 r0 *1 146.8,45.2 nfet
XM$174 VSS IBIAS TAIL vsubs nfet_03v3 L=0.5U W=2U AS=0.58P AD=0.58P PS=2.58U PD=2.58U
* device instance $175 r0 *1 147.88,45.2 nfet
XM$175 TAIL IBIAS VSS vsubs nfet_03v3 L=0.5U W=2U AS=0.58P AD=0.58P PS=2.58U PD=2.58U
* device instance $176 r0 *1 148.96,45.2 nfet
XM$176 VSS IBIAS TAIL vsubs nfet_03v3 L=0.5U W=2U AS=0.58P AD=0.58P PS=2.58U PD=2.58U
* device instance $177 r0 *1 150.04,45.2 nfet
XM$177 TAIL IBIAS VSS vsubs nfet_03v3 L=0.5U W=2U AS=0.58P AD=0.58P PS=2.58U PD=2.58U
* device instance $178 r0 *1 151.12,45.2 nfet
XM$178 VSS IBIAS TAIL vsubs nfet_03v3 L=0.5U W=2U AS=0.58P AD=0.58P PS=2.58U PD=2.58U
* device instance $179 r0 *1 152.2,45.2 nfet
XM$179 TAIL IBIAS VSS vsubs nfet_03v3 L=0.5U W=2U AS=0.58P AD=0.58P PS=2.58U PD=2.58U
* device instance $180 r0 *1 153.28,45.2 nfet
XM$180 VSS IBIAS TAIL vsubs nfet_03v3 L=0.5U W=2U AS=0.58P AD=0.58P PS=2.58U PD=2.58U
* device instance $181 r0 *1 154.36,45.2 nfet
XM$181 TAIL IBIAS VSS vsubs nfet_03v3 L=0.5U W=2U AS=0.58P AD=0.58P PS=2.58U PD=2.58U
* device instance $182 r0 *1 155.44,45.2 nfet
XM$182 VSS IBIAS TAIL vsubs nfet_03v3 L=0.5U W=2U AS=0.58P AD=0.58P PS=2.58U PD=2.58U
* device instance $183 r0 *1 156.52,45.2 nfet
XM$183 TAIL IBIAS VSS vsubs nfet_03v3 L=0.5U W=2U AS=0.58P AD=0.58P PS=2.58U PD=2.58U
* device instance $184 r0 *1 157.6,45.2 nfet
XM$184 VSS IBIAS TAIL vsubs nfet_03v3 L=0.5U W=2U AS=0.58P AD=0.58P PS=2.58U PD=2.58U
* device instance $185 r0 *1 158.68,45.2 nfet
XM$185 TAIL IBIAS VSS vsubs nfet_03v3 L=0.5U W=2U AS=0.58P AD=0.58P PS=2.58U PD=2.58U
* device instance $186 r0 *1 159.76,45.2 nfet
XM$186 VSS IBIAS TAIL vsubs nfet_03v3 L=0.5U W=2U AS=0.58P AD=0.58P PS=2.58U PD=2.58U
* device instance $187 r0 *1 160.84,45.2 nfet
XM$187 TAIL IBIAS VSS vsubs nfet_03v3 L=0.5U W=2U AS=0.58P AD=0.58P PS=2.58U PD=2.58U
* device instance $188 r0 *1 161.92,45.2 nfet
XM$188 VSS IBIAS TAIL vsubs nfet_03v3 L=0.5U W=2U AS=0.58P AD=0.58P PS=2.58U PD=2.58U
* device instance $189 r0 *1 163,45.2 nfet
XM$189 TAIL IBIAS VSS vsubs nfet_03v3 L=0.5U W=2U AS=0.58P AD=0.58P PS=2.58U PD=2.58U
* device instance $190 r0 *1 164.08,45.2 nfet
XM$190 VSS IBIAS TAIL vsubs nfet_03v3 L=0.5U W=2U AS=0.58P AD=0.58P PS=2.58U PD=2.58U
* device instance $191 r0 *1 165.16,45.2 nfet
XM$191 TAIL IBIAS VSS vsubs nfet_03v3 L=0.5U W=2U AS=0.58P AD=0.58P PS=2.58U PD=2.58U
* device instance $192 r0 *1 166.24,45.2 nfet
XM$192 VSS IBIAS TAIL vsubs nfet_03v3 L=0.5U W=2U AS=0.58P AD=0.58P PS=2.58U PD=2.58U
* device instance $193 r0 *1 167.32,45.2 nfet
XM$193 TAIL IBIAS VSS vsubs nfet_03v3 L=0.5U W=2U AS=0.58P AD=0.58P PS=2.58U PD=2.58U
* device instance $194 r0 *1 168.4,45.2 nfet
XM$194 VSS IBIAS TAIL vsubs nfet_03v3 L=0.5U W=2U AS=0.58P AD=0.58P PS=2.58U PD=2.58U
* device instance $195 r0 *1 169.48,45.2 nfet
XM$195 TAIL IBIAS VSS vsubs nfet_03v3 L=0.5U W=2U AS=0.58P AD=0.58P PS=2.58U PD=2.58U
* device instance $196 r0 *1 170.56,45.2 nfet
XM$196 VSS IBIAS TAIL vsubs nfet_03v3 L=0.5U W=2U AS=0.58P AD=0.58P PS=2.58U PD=2.58U
* device instance $197 r0 *1 171.64,45.2 nfet
XM$197 TAIL IBIAS VSS vsubs nfet_03v3 L=0.5U W=2U AS=0.58P AD=0.58P PS=2.58U PD=2.58U
* device instance $198 r0 *1 172.72,45.2 nfet
XM$198 VSS IBIAS TAIL vsubs nfet_03v3 L=0.5U W=2U AS=0.58P AD=0.58P PS=2.58U PD=2.58U
* device instance $199 r0 *1 173.8,45.2 nfet
XM$199 TAIL IBIAS VSS vsubs nfet_03v3 L=0.5U W=2U AS=0.58P AD=0.58P PS=2.58U PD=2.58U
* device instance $200 r0 *1 174.88,45.2 nfet
XM$200 VSS IBIAS TAIL vsubs nfet_03v3 L=0.5U W=2U AS=0.58P AD=0.58P PS=2.58U PD=2.58U
* device instance $201 r0 *1 175.96,45.2 nfet
XM$201 TAIL IBIAS VSS vsubs nfet_03v3 L=0.5U W=2U AS=0.58P AD=0.58P PS=2.58U PD=2.58U
* device instance $202 r0 *1 177.04,45.2 nfet
XM$202 VSS IBIAS TAIL vsubs nfet_03v3 L=0.5U W=2U AS=0.58P AD=0.58P PS=2.58U PD=2.58U
* device instance $203 r0 *1 178.12,45.2 nfet
XM$203 TAIL IBIAS VSS vsubs nfet_03v3 L=0.5U W=2U AS=0.58P AD=0.58P PS=2.58U PD=2.58U
* device instance $204 r0 *1 179.2,45.2 nfet
XM$204 VSS IBIAS TAIL vsubs nfet_03v3 L=0.5U W=2U AS=0.58P AD=0.58P PS=2.58U PD=2.58U
* device instance $205 r0 *1 180.28,45.2 nfet
XM$205 TAIL IBIAS VSS vsubs nfet_03v3 L=0.5U W=2U AS=0.58P AD=0.58P PS=2.58U PD=2.58U
* device instance $206 r0 *1 181.36,45.2 nfet
XM$206 VSS IBIAS TAIL vsubs nfet_03v3 L=0.5U W=2U AS=0.58P AD=0.58P PS=2.58U PD=2.58U
* device instance $207 r0 *1 182.44,45.2 nfet
XM$207 TAIL IBIAS VSS vsubs nfet_03v3 L=0.5U W=2U AS=0.58P AD=0.58P PS=2.58U PD=2.58U
* device instance $208 r0 *1 183.52,45.2 nfet
XM$208 VSS IBIAS TAIL vsubs nfet_03v3 L=0.5U W=2U AS=0.58P AD=0.58P PS=2.58U PD=2.58U
* device instance $209 r0 *1 184.6,45.2 nfet
XM$209 TAIL IBIAS VSS vsubs nfet_03v3 L=0.5U W=2U AS=0.58P AD=0.58P PS=2.58U PD=2.58U
* device instance $210 r0 *1 185.68,45.2 nfet
XM$210 VSS IBIAS TAIL vsubs nfet_03v3 L=0.5U W=2U AS=0.58P AD=0.58P PS=2.58U PD=2.58U
* device instance $211 r0 *1 186.76,45.2 nfet
XM$211 TAIL IBIAS VSS vsubs nfet_03v3 L=0.5U W=2U AS=0.58P AD=0.58P PS=2.58U PD=2.58U
* device instance $212 r0 *1 187.84,45.2 nfet
XM$212 VSS IBIAS TAIL vsubs nfet_03v3 L=0.5U W=2U AS=0.58P AD=0.58P PS=2.58U PD=2.58U
* device instance $213 r0 *1 188.92,45.2 nfet
XM$213 TAIL IBIAS VSS vsubs nfet_03v3 L=0.5U W=2U AS=0.58P AD=0.58P PS=2.58U PD=2.58U
* device instance $214 r0 *1 190,45.2 nfet
XM$214 VSS IBIAS TAIL vsubs nfet_03v3 L=0.5U W=2U AS=0.58P AD=0.58P PS=2.58U PD=2.58U
* device instance $215 r0 *1 191.08,45.2 nfet
XM$215 TAIL IBIAS VSS vsubs nfet_03v3 L=0.5U W=2U AS=0.58P AD=0.58P PS=2.58U PD=2.58U
* device instance $216 r0 *1 192.16,45.2 nfet
XM$216 VSS IBIAS TAIL vsubs nfet_03v3 L=0.5U W=2U AS=0.58P AD=0.58P PS=2.58U PD=2.58U
* device instance $217 r0 *1 193.24,45.2 nfet
XM$217 TAIL IBIAS VSS vsubs nfet_03v3 L=0.5U W=2U AS=0.58P AD=0.58P PS=2.58U PD=2.58U
* device instance $218 r0 *1 194.32,45.2 nfet
XM$218 VSS IBIAS TAIL vsubs nfet_03v3 L=0.5U W=2U AS=0.58P AD=0.58P PS=2.58U PD=2.58U
* device instance $219 r0 *1 195.4,45.2 nfet
XM$219 TAIL IBIAS VSS vsubs nfet_03v3 L=0.5U W=2U AS=0.58P AD=0.58P PS=2.58U PD=2.58U
* device instance $220 r0 *1 196.48,45.2 nfet
XM$220 VSS IBIAS TAIL vsubs nfet_03v3 L=0.5U W=2U AS=0.58P AD=0.58P PS=2.58U PD=2.58U
* device instance $221 r0 *1 197.56,45.2 nfet
XM$221 TAIL IBIAS VSS vsubs nfet_03v3 L=0.5U W=2U AS=0.58P AD=0.58P PS=2.58U PD=2.58U
* device instance $222 r0 *1 198.64,45.2 nfet
XM$222 VSS IBIAS TAIL vsubs nfet_03v3 L=0.5U W=2U AS=0.58P AD=0.58P PS=2.58U PD=2.58U
* device instance $223 r0 *1 199.72,45.2 nfet
XM$223 TAIL IBIAS VSS vsubs nfet_03v3 L=0.5U W=2U AS=0.58P AD=0.58P PS=2.58U PD=2.58U
* device instance $224 r0 *1 200.8,45.2 nfet
XM$224 VSS IBIAS TAIL vsubs nfet_03v3 L=0.5U W=2U AS=0.58P AD=0.58P PS=2.58U PD=2.58U
* device instance $225 r0 *1 201.88,45.2 nfet
XM$225 TAIL IBIAS VSS vsubs nfet_03v3 L=0.5U W=2U AS=0.58P AD=0.58P PS=2.58U PD=2.58U
* device instance $226 r0 *1 202.96,45.2 nfet
XM$226 VSS IBIAS TAIL vsubs nfet_03v3 L=0.5U W=2U AS=0.58P AD=0.58P PS=2.58U PD=2.58U
* device instance $227 r0 *1 204.04,45.2 nfet
XM$227 TAIL IBIAS VSS vsubs nfet_03v3 L=0.5U W=2U AS=0.58P AD=0.58P PS=2.58U PD=2.58U
* device instance $228 r0 *1 205.12,45.2 nfet
XM$228 VSS IBIAS TAIL vsubs nfet_03v3 L=0.5U W=2U AS=0.58P AD=0.58P PS=2.58U PD=2.58U
* device instance $229 r0 *1 206.2,45.2 nfet
XM$229 TAIL IBIAS VSS vsubs nfet_03v3 L=0.5U W=2U AS=0.58P AD=0.58P PS=2.58U PD=2.58U
* device instance $230 r0 *1 207.28,45.2 nfet
XM$230 VSS IBIAS TAIL vsubs nfet_03v3 L=0.5U W=2U AS=0.58P AD=0.58P PS=2.58U PD=2.58U
* device instance $231 r0 *1 208.36,45.2 nfet
XM$231 TAIL IBIAS VSS vsubs nfet_03v3 L=0.5U W=2U AS=0.58P AD=0.58P PS=2.58U PD=2.58U
* device instance $232 r0 *1 209.44,45.2 nfet
XM$232 VSS IBIAS TAIL vsubs nfet_03v3 L=0.5U W=2U AS=0.58P AD=0.58P PS=2.58U PD=2.58U
* device instance $233 r0 *1 210.52,45.2 nfet
XM$233 TAIL IBIAS VSS vsubs nfet_03v3 L=0.5U W=2U AS=0.58P AD=0.58P PS=2.58U PD=2.58U
* device instance $234 r0 *1 211.6,45.2 nfet
XM$234 VSS IBIAS TAIL vsubs nfet_03v3 L=0.5U W=2U AS=0.58P AD=0.58P PS=2.58U PD=2.58U
* device instance $235 r0 *1 212.68,45.2 nfet
XM$235 TAIL IBIAS VSS vsubs nfet_03v3 L=0.5U W=2U AS=0.58P AD=0.58P PS=2.58U PD=2.58U
* device instance $236 r0 *1 213.76,45.2 nfet
XM$236 VSS IBIAS TAIL vsubs nfet_03v3 L=0.5U W=2U AS=0.58P AD=0.58P PS=2.58U PD=2.58U
* device instance $237 r0 *1 214.84,45.2 nfet
XM$237 TAIL IBIAS VSS vsubs nfet_03v3 L=0.5U W=2U AS=0.58P AD=0.58P PS=2.58U PD=2.58U
* device instance $238 r0 *1 215.92,45.2 nfet
XM$238 VSS IBIAS TAIL vsubs nfet_03v3 L=0.5U W=2U AS=0.58P AD=1P PS=2.58U PD=5U
* device instance $239 r0 *1 1,45.2 nfet
XM$239 TAIL IBIAS VSS vsubs nfet_03v3 L=0.5U W=2U AS=1P AD=0.58P PS=5U PD=2.58U
* device instance $240 r0 *1 2.08,45.2 nfet
XM$240 VSS IBIAS TAIL vsubs nfet_03v3 L=0.5U W=2U AS=0.58P AD=0.58P PS=2.58U PD=2.58U
* device instance $241 r0 *1 3.16,45.2 nfet
XM$241 TAIL IBIAS VSS vsubs nfet_03v3 L=0.5U W=2U AS=0.58P AD=0.58P PS=2.58U PD=2.58U
* device instance $242 r0 *1 4.24,45.2 nfet
XM$242 VSS IBIAS TAIL vsubs nfet_03v3 L=0.5U W=2U AS=0.58P AD=0.58P PS=2.58U PD=2.58U
* device instance $243 r0 *1 5.32,45.2 nfet
XM$243 TAIL IBIAS VSS vsubs nfet_03v3 L=0.5U W=2U AS=0.58P AD=0.58P PS=2.58U PD=2.58U
* device instance $244 r0 *1 6.4,45.2 nfet
XM$244 VSS IBIAS TAIL vsubs nfet_03v3 L=0.5U W=2U AS=0.58P AD=0.58P PS=2.58U PD=2.58U
* device instance $245 r0 *1 7.48,45.2 nfet
XM$245 TAIL IBIAS VSS vsubs nfet_03v3 L=0.5U W=2U AS=0.58P AD=0.58P PS=2.58U PD=2.58U
* device instance $246 r0 *1 8.56,45.2 nfet
XM$246 VSS IBIAS TAIL vsubs nfet_03v3 L=0.5U W=2U AS=0.58P AD=0.58P PS=2.58U PD=2.58U
* device instance $247 r0 *1 9.64,45.2 nfet
XM$247 TAIL IBIAS VSS vsubs nfet_03v3 L=0.5U W=2U AS=0.58P AD=0.58P PS=2.58U PD=2.58U
* device instance $248 r0 *1 10.72,45.2 nfet
XM$248 VSS IBIAS TAIL vsubs nfet_03v3 L=0.5U W=2U AS=0.58P AD=0.58P PS=2.58U PD=2.58U
* device instance $249 r0 *1 11.8,45.2 nfet
XM$249 TAIL IBIAS VSS vsubs nfet_03v3 L=0.5U W=2U AS=0.58P AD=0.58P PS=2.58U PD=2.58U
* device instance $250 r0 *1 12.88,45.2 nfet
XM$250 VSS IBIAS TAIL vsubs nfet_03v3 L=0.5U W=2U AS=0.58P AD=0.58P PS=2.58U PD=2.58U
* device instance $251 r0 *1 13.96,45.2 nfet
XM$251 TAIL IBIAS VSS vsubs nfet_03v3 L=0.5U W=2U AS=0.58P AD=0.58P PS=2.58U PD=2.58U
* device instance $252 r0 *1 15.04,45.2 nfet
XM$252 VSS IBIAS TAIL vsubs nfet_03v3 L=0.5U W=2U AS=0.58P AD=0.58P PS=2.58U PD=2.58U
* device instance $253 r0 *1 16.12,45.2 nfet
XM$253 TAIL IBIAS VSS vsubs nfet_03v3 L=0.5U W=2U AS=0.58P AD=0.58P PS=2.58U PD=2.58U
* device instance $254 r0 *1 17.2,45.2 nfet
XM$254 VSS IBIAS TAIL vsubs nfet_03v3 L=0.5U W=2U AS=0.58P AD=0.58P PS=2.58U PD=2.58U
* device instance $255 r0 *1 18.28,45.2 nfet
XM$255 TAIL IBIAS VSS vsubs nfet_03v3 L=0.5U W=2U AS=0.58P AD=0.58P PS=2.58U PD=2.58U
* device instance $256 r0 *1 19.36,45.2 nfet
XM$256 VSS IBIAS TAIL vsubs nfet_03v3 L=0.5U W=2U AS=0.58P AD=0.58P PS=2.58U PD=2.58U
* device instance $257 r0 *1 20.44,45.2 nfet
XM$257 TAIL IBIAS VSS vsubs nfet_03v3 L=0.5U W=2U AS=0.58P AD=0.58P PS=2.58U PD=2.58U
* device instance $258 r0 *1 21.52,45.2 nfet
XM$258 VSS IBIAS TAIL vsubs nfet_03v3 L=0.5U W=2U AS=0.58P AD=0.58P PS=2.58U PD=2.58U
* device instance $259 r0 *1 22.6,45.2 nfet
XM$259 TAIL IBIAS VSS vsubs nfet_03v3 L=0.5U W=2U AS=0.58P AD=0.58P PS=2.58U PD=2.58U
* device instance $260 r0 *1 23.68,45.2 nfet
XM$260 VSS IBIAS TAIL vsubs nfet_03v3 L=0.5U W=2U AS=0.58P AD=0.58P PS=2.58U PD=2.58U
* device instance $261 r0 *1 24.76,45.2 nfet
XM$261 TAIL IBIAS VSS vsubs nfet_03v3 L=0.5U W=2U AS=0.58P AD=0.58P PS=2.58U PD=2.58U
* device instance $262 r0 *1 25.84,45.2 nfet
XM$262 VSS IBIAS TAIL vsubs nfet_03v3 L=0.5U W=2U AS=0.58P AD=0.58P PS=2.58U PD=2.58U
* device instance $263 r0 *1 26.92,45.2 nfet
XM$263 TAIL IBIAS VSS vsubs nfet_03v3 L=0.5U W=2U AS=0.58P AD=0.58P PS=2.58U PD=2.58U
* device instance $264 r0 *1 28,45.2 nfet
XM$264 VSS IBIAS TAIL vsubs nfet_03v3 L=0.5U W=2U AS=0.58P AD=0.58P PS=2.58U PD=2.58U
* device instance $265 r0 *1 29.08,45.2 nfet
XM$265 TAIL IBIAS VSS vsubs nfet_03v3 L=0.5U W=2U AS=0.58P AD=0.58P PS=2.58U PD=2.58U
* device instance $266 r0 *1 30.16,45.2 nfet
XM$266 VSS IBIAS TAIL vsubs nfet_03v3 L=0.5U W=2U AS=0.58P AD=0.58P PS=2.58U PD=2.58U
* device instance $267 r0 *1 31.24,45.2 nfet
XM$267 TAIL IBIAS VSS vsubs nfet_03v3 L=0.5U W=2U AS=0.58P AD=0.58P PS=2.58U PD=2.58U
* device instance $268 r0 *1 32.32,45.2 nfet
XM$268 VSS IBIAS TAIL vsubs nfet_03v3 L=0.5U W=2U AS=0.58P AD=0.58P PS=2.58U PD=2.58U
* device instance $269 r0 *1 33.4,45.2 nfet
XM$269 TAIL IBIAS VSS vsubs nfet_03v3 L=0.5U W=2U AS=0.58P AD=0.58P PS=2.58U PD=2.58U
* device instance $270 r0 *1 34.48,45.2 nfet
XM$270 VSS IBIAS TAIL vsubs nfet_03v3 L=0.5U W=2U AS=0.58P AD=0.58P PS=2.58U PD=2.58U
* device instance $271 r0 *1 35.56,45.2 nfet
XM$271 TAIL IBIAS VSS vsubs nfet_03v3 L=0.5U W=2U AS=0.58P AD=0.58P PS=2.58U PD=2.58U
* device instance $272 r0 *1 36.64,45.2 nfet
XM$272 VSS IBIAS TAIL vsubs nfet_03v3 L=0.5U W=2U AS=0.58P AD=0.58P PS=2.58U PD=2.58U
* device instance $273 r0 *1 37.72,45.2 nfet
XM$273 TAIL IBIAS VSS vsubs nfet_03v3 L=0.5U W=2U AS=0.58P AD=0.58P PS=2.58U PD=2.58U
* device instance $274 r0 *1 38.8,45.2 nfet
XM$274 VSS IBIAS TAIL vsubs nfet_03v3 L=0.5U W=2U AS=0.58P AD=0.58P PS=2.58U PD=2.58U
* device instance $275 r0 *1 39.88,45.2 nfet
XM$275 TAIL IBIAS VSS vsubs nfet_03v3 L=0.5U W=2U AS=0.58P AD=0.58P PS=2.58U PD=2.58U
* device instance $276 r0 *1 40.96,45.2 nfet
XM$276 VSS IBIAS TAIL vsubs nfet_03v3 L=0.5U W=2U AS=0.58P AD=0.58P PS=2.58U PD=2.58U
* device instance $277 r0 *1 42.04,45.2 nfet
XM$277 TAIL IBIAS VSS vsubs nfet_03v3 L=0.5U W=2U AS=0.58P AD=0.58P PS=2.58U PD=2.58U
* device instance $278 r0 *1 43.12,45.2 nfet
XM$278 VSS IBIAS TAIL vsubs nfet_03v3 L=0.5U W=2U AS=0.58P AD=0.58P PS=2.58U PD=2.58U
* device instance $279 r0 *1 44.2,45.2 nfet
XM$279 TAIL IBIAS VSS vsubs nfet_03v3 L=0.5U W=2U AS=0.58P AD=0.58P PS=2.58U PD=2.58U
* device instance $280 r0 *1 45.28,45.2 nfet
XM$280 VSS IBIAS TAIL vsubs nfet_03v3 L=0.5U W=2U AS=0.58P AD=0.58P PS=2.58U PD=2.58U
* device instance $281 r0 *1 46.36,45.2 nfet
XM$281 TAIL IBIAS VSS vsubs nfet_03v3 L=0.5U W=2U AS=0.58P AD=0.58P PS=2.58U PD=2.58U
* device instance $282 r0 *1 47.44,45.2 nfet
XM$282 VSS IBIAS TAIL vsubs nfet_03v3 L=0.5U W=2U AS=0.58P AD=0.58P PS=2.58U PD=2.58U
* device instance $283 r0 *1 48.52,45.2 nfet
XM$283 TAIL IBIAS VSS vsubs nfet_03v3 L=0.5U W=2U AS=0.58P AD=0.58P PS=2.58U PD=2.58U
* device instance $284 r0 *1 49.6,45.2 nfet
XM$284 VSS IBIAS TAIL vsubs nfet_03v3 L=0.5U W=2U AS=0.58P AD=0.58P PS=2.58U PD=2.58U
* device instance $285 r0 *1 50.68,45.2 nfet
XM$285 TAIL IBIAS VSS vsubs nfet_03v3 L=0.5U W=2U AS=0.58P AD=0.58P PS=2.58U PD=2.58U
* device instance $286 r0 *1 51.76,45.2 nfet
XM$286 VSS IBIAS TAIL vsubs nfet_03v3 L=0.5U W=2U AS=0.58P AD=0.58P PS=2.58U PD=2.58U
* device instance $287 r0 *1 52.84,45.2 nfet
XM$287 TAIL IBIAS VSS vsubs nfet_03v3 L=0.5U W=2U AS=0.58P AD=0.58P PS=2.58U PD=2.58U
* device instance $288 r0 *1 53.92,45.2 nfet
XM$288 VSS IBIAS TAIL vsubs nfet_03v3 L=0.5U W=2U AS=0.58P AD=0.58P PS=2.58U PD=2.58U
* device instance $289 r0 *1 55,45.2 nfet
XM$289 TAIL IBIAS VSS vsubs nfet_03v3 L=0.5U W=2U AS=0.58P AD=0.58P PS=2.58U PD=2.58U
* device instance $290 r0 *1 56.08,45.2 nfet
XM$290 VSS IBIAS TAIL vsubs nfet_03v3 L=0.5U W=2U AS=0.58P AD=0.58P PS=2.58U PD=2.58U
* device instance $291 r0 *1 57.16,45.2 nfet
XM$291 TAIL IBIAS VSS vsubs nfet_03v3 L=0.5U W=2U AS=0.58P AD=0.58P PS=2.58U PD=2.58U
* device instance $292 r0 *1 58.24,45.2 nfet
XM$292 VSS IBIAS TAIL vsubs nfet_03v3 L=0.5U W=2U AS=0.58P AD=0.58P PS=2.58U PD=2.58U
* device instance $293 r0 *1 59.32,45.2 nfet
XM$293 TAIL IBIAS VSS vsubs nfet_03v3 L=0.5U W=2U AS=0.58P AD=0.58P PS=2.58U PD=2.58U
* device instance $294 r0 *1 60.4,45.2 nfet
XM$294 VSS IBIAS TAIL vsubs nfet_03v3 L=0.5U W=2U AS=0.58P AD=0.58P PS=2.58U PD=2.58U
* device instance $295 r0 *1 61.48,45.2 nfet
XM$295 TAIL IBIAS VSS vsubs nfet_03v3 L=0.5U W=2U AS=0.58P AD=0.58P PS=2.58U PD=2.58U
* device instance $296 r0 *1 62.56,45.2 nfet
XM$296 VSS IBIAS TAIL vsubs nfet_03v3 L=0.5U W=2U AS=0.58P AD=0.58P PS=2.58U PD=2.58U
* device instance $297 r0 *1 63.64,45.2 nfet
XM$297 TAIL IBIAS VSS vsubs nfet_03v3 L=0.5U W=2U AS=0.58P AD=0.58P PS=2.58U PD=2.58U
* device instance $298 r0 *1 64.72,45.2 nfet
XM$298 VSS IBIAS TAIL vsubs nfet_03v3 L=0.5U W=2U AS=0.58P AD=0.58P PS=2.58U PD=2.58U
* device instance $299 r0 *1 65.8,45.2 nfet
XM$299 TAIL IBIAS VSS vsubs nfet_03v3 L=0.5U W=2U AS=0.58P AD=0.58P PS=2.58U PD=2.58U
* device instance $300 r0 *1 66.88,45.2 nfet
XM$300 VSS IBIAS TAIL vsubs nfet_03v3 L=0.5U W=2U AS=0.58P AD=0.58P PS=2.58U PD=2.58U
* device instance $301 r0 *1 67.96,45.2 nfet
XM$301 TAIL IBIAS VSS vsubs nfet_03v3 L=0.5U W=2U AS=0.58P AD=0.58P PS=2.58U PD=2.58U
* device instance $302 r0 *1 69.04,45.2 nfet
XM$302 VSS IBIAS TAIL vsubs nfet_03v3 L=0.5U W=2U AS=0.58P AD=0.58P PS=2.58U PD=2.58U
* device instance $303 r0 *1 70.12,45.2 nfet
XM$303 TAIL IBIAS VSS vsubs nfet_03v3 L=0.5U W=2U AS=0.58P AD=0.58P PS=2.58U PD=2.58U
* device instance $304 r0 *1 71.2,45.2 nfet
XM$304 VSS IBIAS TAIL vsubs nfet_03v3 L=0.5U W=2U AS=0.58P AD=0.58P PS=2.58U PD=2.58U
* device instance $305 r0 *1 72.28,45.2 nfet
XM$305 TAIL IBIAS VSS vsubs nfet_03v3 L=0.5U W=2U AS=0.58P AD=0.58P PS=2.58U PD=2.58U
* device instance $306 r0 *1 73.36,45.2 nfet
XM$306 VSS IBIAS TAIL vsubs nfet_03v3 L=0.5U W=2U AS=0.58P AD=0.58P PS=2.58U PD=2.58U
* device instance $307 r0 *1 74.44,45.2 nfet
XM$307 TAIL IBIAS VSS vsubs nfet_03v3 L=0.5U W=2U AS=0.58P AD=0.58P PS=2.58U PD=2.58U
* device instance $308 r0 *1 75.52,45.2 nfet
XM$308 VSS IBIAS TAIL vsubs nfet_03v3 L=0.5U W=2U AS=0.58P AD=0.58P PS=2.58U PD=2.58U
* device instance $309 r0 *1 76.6,45.2 nfet
XM$309 TAIL IBIAS VSS vsubs nfet_03v3 L=0.5U W=2U AS=0.58P AD=0.58P PS=2.58U PD=2.58U
* device instance $310 r0 *1 77.68,45.2 nfet
XM$310 VSS IBIAS TAIL vsubs nfet_03v3 L=0.5U W=2U AS=0.58P AD=0.58P PS=2.58U PD=2.58U
* device instance $311 r0 *1 78.76,45.2 nfet
XM$311 TAIL IBIAS VSS vsubs nfet_03v3 L=0.5U W=2U AS=0.58P AD=0.58P PS=2.58U PD=2.58U
* device instance $312 r0 *1 79.84,45.2 nfet
XM$312 VSS IBIAS TAIL vsubs nfet_03v3 L=0.5U W=2U AS=0.58P AD=0.58P PS=2.58U PD=2.58U
* device instance $313 r0 *1 80.92,45.2 nfet
XM$313 TAIL IBIAS VSS vsubs nfet_03v3 L=0.5U W=2U AS=0.58P AD=0.58P PS=2.58U PD=2.58U
* device instance $314 r0 *1 82,45.2 nfet
XM$314 VSS IBIAS TAIL vsubs nfet_03v3 L=0.5U W=2U AS=0.58P AD=0.58P PS=2.58U PD=2.58U
* device instance $315 r0 *1 83.08,45.2 nfet
XM$315 TAIL IBIAS VSS vsubs nfet_03v3 L=0.5U W=2U AS=0.58P AD=0.58P PS=2.58U PD=2.58U
* device instance $316 r0 *1 84.16,45.2 nfet
XM$316 VSS IBIAS TAIL vsubs nfet_03v3 L=0.5U W=2U AS=0.58P AD=0.58P PS=2.58U PD=2.58U
* device instance $317 r0 *1 85.24,45.2 nfet
XM$317 TAIL IBIAS VSS vsubs nfet_03v3 L=0.5U W=2U AS=0.58P AD=0.58P PS=2.58U PD=2.58U
* device instance $318 r0 *1 86.32,45.2 nfet
XM$318 VSS IBIAS TAIL vsubs nfet_03v3 L=0.5U W=2U AS=0.58P AD=0.58P PS=2.58U PD=2.58U
* device instance $319 r0 *1 87.4,45.2 nfet
XM$319 TAIL IBIAS VSS vsubs nfet_03v3 L=0.5U W=2U AS=0.58P AD=0.58P PS=2.58U PD=2.58U
* device instance $320 r0 *1 88.48,45.2 nfet
XM$320 VSS IBIAS TAIL vsubs nfet_03v3 L=0.5U W=2U AS=0.58P AD=0.58P PS=2.58U PD=2.58U
* device instance $321 r0 *1 89.56,45.2 nfet
XM$321 TAIL IBIAS VSS vsubs nfet_03v3 L=0.5U W=2U AS=0.58P AD=0.58P PS=2.58U PD=2.58U
* device instance $322 r0 *1 90.64,45.2 nfet
XM$322 VSS IBIAS TAIL vsubs nfet_03v3 L=0.5U W=2U AS=0.58P AD=0.58P PS=2.58U PD=2.58U
* device instance $323 r0 *1 91.72,45.2 nfet
XM$323 TAIL IBIAS VSS vsubs nfet_03v3 L=0.5U W=2U AS=0.58P AD=0.58P PS=2.58U PD=2.58U
* device instance $324 r0 *1 92.8,45.2 nfet
XM$324 VSS IBIAS TAIL vsubs nfet_03v3 L=0.5U W=2U AS=0.58P AD=0.58P PS=2.58U PD=2.58U
* device instance $325 r0 *1 93.88,45.2 nfet
XM$325 TAIL IBIAS VSS vsubs nfet_03v3 L=0.5U W=2U AS=0.58P AD=0.58P PS=2.58U PD=2.58U
* device instance $326 r0 *1 94.96,45.2 nfet
XM$326 VSS IBIAS TAIL vsubs nfet_03v3 L=0.5U W=2U AS=0.58P AD=0.58P PS=2.58U PD=2.58U
* device instance $327 r0 *1 96.04,45.2 nfet
XM$327 TAIL IBIAS VSS vsubs nfet_03v3 L=0.5U W=2U AS=0.58P AD=0.58P PS=2.58U PD=2.58U
* device instance $328 r0 *1 97.12,45.2 nfet
XM$328 VSS IBIAS TAIL vsubs nfet_03v3 L=0.5U W=2U AS=0.58P AD=0.58P PS=2.58U PD=2.58U
* device instance $329 r0 *1 98.2,45.2 nfet
XM$329 TAIL IBIAS VSS vsubs nfet_03v3 L=0.5U W=2U AS=0.58P AD=0.58P PS=2.58U PD=2.58U
* device instance $330 r0 *1 99.28,45.2 nfet
XM$330 VSS IBIAS TAIL vsubs nfet_03v3 L=0.5U W=2U AS=0.58P AD=0.58P PS=2.58U PD=2.58U
* device instance $331 r0 *1 100.36,45.2 nfet
XM$331 TAIL IBIAS VSS vsubs nfet_03v3 L=0.5U W=2U AS=0.58P AD=0.58P PS=2.58U PD=2.58U
* device instance $332 r0 *1 101.44,45.2 nfet
XM$332 VSS IBIAS TAIL vsubs nfet_03v3 L=0.5U W=2U AS=0.58P AD=0.58P PS=2.58U PD=2.58U
* device instance $333 r0 *1 102.52,45.2 nfet
XM$333 TAIL IBIAS VSS vsubs nfet_03v3 L=0.5U W=2U AS=0.58P AD=0.58P PS=2.58U PD=2.58U
* device instance $334 r0 *1 103.6,45.2 nfet
XM$334 VSS IBIAS TAIL vsubs nfet_03v3 L=0.5U W=2U AS=0.58P AD=0.58P PS=2.58U PD=2.58U
* device instance $335 r0 *1 104.68,45.2 nfet
XM$335 TAIL IBIAS VSS vsubs nfet_03v3 L=0.5U W=2U AS=0.58P AD=0.58P PS=2.58U PD=2.58U
* device instance $336 r0 *1 105.76,45.2 nfet
XM$336 VSS IBIAS TAIL vsubs nfet_03v3 L=0.5U W=2U AS=0.58P AD=0.58P PS=2.58U PD=2.58U
* device instance $337 r0 *1 106.84,45.2 nfet
XM$337 TAIL IBIAS VSS vsubs nfet_03v3 L=0.5U W=2U AS=0.58P AD=0.58P PS=2.58U PD=2.58U
* device instance $338 r0 *1 107.92,45.2 nfet
XM$338 VSS IBIAS TAIL vsubs nfet_03v3 L=0.5U W=2U AS=0.58P AD=0.58P PS=2.58U PD=2.58U
* device instance $339 r0 *1 25.41,16.28 nfet
XM$339 SA CLKP TAIL vsubs nfet_03v3 L=0.28U W=2U AS=1P AD=0.58P PS=5U PD=2.58U
* device instance $340 r0 *1 26.27,16.28 nfet
XM$340 TAIL CLKP SA vsubs nfet_03v3 L=0.28U W=2U AS=0.58P AD=0.58P PS=2.58U PD=2.58U
* device instance $341 r0 *1 27.13,16.28 nfet
XM$341 SA CLKP TAIL vsubs nfet_03v3 L=0.28U W=2U AS=0.58P AD=0.58P PS=2.58U PD=2.58U
* device instance $342 r0 *1 27.99,16.28 nfet
XM$342 TAIL CLKP SA vsubs nfet_03v3 L=0.28U W=2U AS=0.58P AD=0.58P PS=2.58U PD=2.58U
* device instance $343 r0 *1 28.85,16.28 nfet
XM$343 SA CLKP TAIL vsubs nfet_03v3 L=0.28U W=2U AS=0.58P AD=0.58P PS=2.58U PD=2.58U
* device instance $344 r0 *1 29.71,16.28 nfet
XM$344 TAIL CLKP SA vsubs nfet_03v3 L=0.28U W=2U AS=0.58P AD=0.58P PS=2.58U PD=2.58U
* device instance $345 r0 *1 30.57,16.28 nfet
XM$345 SA CLKP TAIL vsubs nfet_03v3 L=0.28U W=2U AS=0.58P AD=0.58P PS=2.58U PD=2.58U
* device instance $346 r0 *1 31.43,16.28 nfet
XM$346 TAIL CLKP SA vsubs nfet_03v3 L=0.28U W=2U AS=0.58P AD=0.58P PS=2.58U PD=2.58U
* device instance $347 r0 *1 32.29,16.28 nfet
XM$347 SA CLKP TAIL vsubs nfet_03v3 L=0.28U W=2U AS=0.58P AD=0.58P PS=2.58U PD=2.58U
* device instance $348 r0 *1 33.15,16.28 nfet
XM$348 TAIL CLKP SA vsubs nfet_03v3 L=0.28U W=2U AS=0.58P AD=0.58P PS=2.58U PD=2.58U
* device instance $349 r0 *1 34.01,16.28 nfet
XM$349 SA CLKP TAIL vsubs nfet_03v3 L=0.28U W=2U AS=0.58P AD=0.58P PS=2.58U PD=2.58U
* device instance $350 r0 *1 34.87,16.28 nfet
XM$350 TAIL CLKP SA vsubs nfet_03v3 L=0.28U W=2U AS=0.58P AD=0.58P PS=2.58U PD=2.58U
* device instance $351 r0 *1 35.73,16.28 nfet
XM$351 SA CLKP TAIL vsubs nfet_03v3 L=0.28U W=2U AS=0.58P AD=0.58P PS=2.58U PD=2.58U
* device instance $352 r0 *1 36.59,16.28 nfet
XM$352 TAIL CLKP SA vsubs nfet_03v3 L=0.28U W=2U AS=0.58P AD=0.58P PS=2.58U PD=2.58U
* device instance $353 r0 *1 37.45,16.28 nfet
XM$353 SA CLKP TAIL vsubs nfet_03v3 L=0.28U W=2U AS=0.58P AD=0.58P PS=2.58U PD=2.58U
* device instance $354 r0 *1 38.31,16.28 nfet
XM$354 TAIL CLKP SA vsubs nfet_03v3 L=0.28U W=2U AS=0.58P AD=0.58P PS=2.58U PD=2.58U
* device instance $355 r0 *1 39.17,16.28 nfet
XM$355 SA CLKP TAIL vsubs nfet_03v3 L=0.28U W=2U AS=0.58P AD=0.58P PS=2.58U PD=2.58U
* device instance $356 r0 *1 40.03,16.28 nfet
XM$356 TAIL CLKP SA vsubs nfet_03v3 L=0.28U W=2U AS=0.58P AD=0.58P PS=2.58U PD=2.58U
* device instance $357 r0 *1 40.89,16.28 nfet
XM$357 SA CLKP TAIL vsubs nfet_03v3 L=0.28U W=2U AS=0.58P AD=0.58P PS=2.58U PD=2.58U
* device instance $358 r0 *1 41.75,16.28 nfet
XM$358 TAIL CLKP SA vsubs nfet_03v3 L=0.28U W=2U AS=0.58P AD=0.58P PS=2.58U PD=2.58U
* device instance $359 r0 *1 42.61,16.28 nfet
XM$359 SA CLKP TAIL vsubs nfet_03v3 L=0.28U W=2U AS=0.58P AD=0.58P PS=2.58U PD=2.58U
* device instance $360 r0 *1 43.47,16.28 nfet
XM$360 TAIL CLKP SA vsubs nfet_03v3 L=0.28U W=2U AS=0.58P AD=0.58P PS=2.58U PD=2.58U
* device instance $361 r0 *1 44.33,16.28 nfet
XM$361 SA CLKP TAIL vsubs nfet_03v3 L=0.28U W=2U AS=0.58P AD=0.58P PS=2.58U PD=2.58U
* device instance $362 r0 *1 45.19,16.28 nfet
XM$362 TAIL CLKP SA vsubs nfet_03v3 L=0.28U W=2U AS=0.58P AD=0.58P PS=2.58U PD=2.58U
* device instance $363 r0 *1 46.05,16.28 nfet
XM$363 SA CLKP TAIL vsubs nfet_03v3 L=0.28U W=2U AS=0.58P AD=0.58P PS=2.58U PD=2.58U
* device instance $364 r0 *1 46.91,16.28 nfet
XM$364 TAIL CLKP SA vsubs nfet_03v3 L=0.28U W=2U AS=0.58P AD=0.58P PS=2.58U PD=2.58U
* device instance $365 r0 *1 47.77,16.28 nfet
XM$365 SA CLKP TAIL vsubs nfet_03v3 L=0.28U W=2U AS=0.58P AD=0.58P PS=2.58U PD=2.58U
* device instance $366 r0 *1 48.63,16.28 nfet
XM$366 TAIL CLKP SA vsubs nfet_03v3 L=0.28U W=2U AS=0.58P AD=0.58P PS=2.58U PD=2.58U
* device instance $367 r0 *1 49.49,16.28 nfet
XM$367 SA CLKP TAIL vsubs nfet_03v3 L=0.28U W=2U AS=0.58P AD=0.58P PS=2.58U PD=2.58U
* device instance $368 r0 *1 50.35,16.28 nfet
XM$368 TAIL CLKP SA vsubs nfet_03v3 L=0.28U W=2U AS=0.58P AD=0.58P PS=2.58U PD=2.58U
* device instance $369 r0 *1 51.21,16.28 nfet
XM$369 SA CLKP TAIL vsubs nfet_03v3 L=0.28U W=2U AS=0.58P AD=0.58P PS=2.58U PD=2.58U
* device instance $370 r0 *1 52.07,16.28 nfet
XM$370 TAIL CLKP SA vsubs nfet_03v3 L=0.28U W=2U AS=0.58P AD=0.58P PS=2.58U PD=2.58U
* device instance $371 r0 *1 52.93,16.28 nfet
XM$371 SA CLKP TAIL vsubs nfet_03v3 L=0.28U W=2U AS=0.58P AD=0.58P PS=2.58U PD=2.58U
* device instance $372 r0 *1 53.79,16.28 nfet
XM$372 TAIL CLKP SA vsubs nfet_03v3 L=0.28U W=2U AS=0.58P AD=0.58P PS=2.58U PD=2.58U
* device instance $373 r0 *1 54.65,16.28 nfet
XM$373 SA CLKP TAIL vsubs nfet_03v3 L=0.28U W=2U AS=0.58P AD=0.58P PS=2.58U PD=2.58U
* device instance $374 r0 *1 55.51,16.28 nfet
XM$374 TAIL CLKP SA vsubs nfet_03v3 L=0.28U W=2U AS=0.58P AD=0.58P PS=2.58U PD=2.58U
* device instance $375 r0 *1 56.37,16.28 nfet
XM$375 SA CLKP TAIL vsubs nfet_03v3 L=0.28U W=2U AS=0.58P AD=0.58P PS=2.58U PD=2.58U
* device instance $376 r0 *1 57.23,16.28 nfet
XM$376 TAIL CLKP SA vsubs nfet_03v3 L=0.28U W=2U AS=0.58P AD=0.58P PS=2.58U PD=2.58U
* device instance $377 r0 *1 58.09,16.28 nfet
XM$377 SA CLKP TAIL vsubs nfet_03v3 L=0.28U W=2U AS=0.58P AD=0.58P PS=2.58U PD=2.58U
* device instance $378 r0 *1 58.95,16.28 nfet
XM$378 TAIL CLKP SA vsubs nfet_03v3 L=0.28U W=2U AS=0.58P AD=0.58P PS=2.58U PD=2.58U
* device instance $379 r0 *1 59.81,16.28 nfet
XM$379 SA CLKP TAIL vsubs nfet_03v3 L=0.28U W=2U AS=0.58P AD=0.58P PS=2.58U PD=2.58U
* device instance $380 r0 *1 60.67,16.28 nfet
XM$380 TAIL CLKP SA vsubs nfet_03v3 L=0.28U W=2U AS=0.58P AD=0.58P PS=2.58U PD=2.58U
* device instance $381 r0 *1 61.53,16.28 nfet
XM$381 SA CLKP TAIL vsubs nfet_03v3 L=0.28U W=2U AS=0.58P AD=0.58P PS=2.58U PD=2.58U
* device instance $382 r0 *1 62.39,16.28 nfet
XM$382 TAIL CLKP SA vsubs nfet_03v3 L=0.28U W=2U AS=0.58P AD=0.58P PS=2.58U PD=2.58U
* device instance $383 r0 *1 63.25,16.28 nfet
XM$383 SA CLKP TAIL vsubs nfet_03v3 L=0.28U W=2U AS=0.58P AD=0.58P PS=2.58U PD=2.58U
* device instance $384 r0 *1 64.11,16.28 nfet
XM$384 TAIL CLKP SA vsubs nfet_03v3 L=0.28U W=2U AS=0.58P AD=0.58P PS=2.58U PD=2.58U
* device instance $385 r0 *1 64.97,16.28 nfet
XM$385 SA CLKP TAIL vsubs nfet_03v3 L=0.28U W=2U AS=0.58P AD=0.58P PS=2.58U PD=2.58U
* device instance $386 r0 *1 65.83,16.28 nfet
XM$386 TAIL CLKP SA vsubs nfet_03v3 L=0.28U W=2U AS=0.58P AD=0.58P PS=2.58U PD=2.58U
* device instance $387 r0 *1 66.69,16.28 nfet
XM$387 SA CLKP TAIL vsubs nfet_03v3 L=0.28U W=2U AS=0.58P AD=0.58P PS=2.58U PD=2.58U
* device instance $388 r0 *1 67.55,16.28 nfet
XM$388 TAIL CLKP SA vsubs nfet_03v3 L=0.28U W=2U AS=0.58P AD=0.58P PS=2.58U PD=2.58U
* device instance $389 r0 *1 68.41,16.28 nfet
XM$389 SA CLKP TAIL vsubs nfet_03v3 L=0.28U W=2U AS=0.58P AD=0.58P PS=2.58U PD=2.58U
* device instance $390 r0 *1 69.27,16.28 nfet
XM$390 TAIL CLKP SA vsubs nfet_03v3 L=0.28U W=2U AS=0.58P AD=0.58P PS=2.58U PD=2.58U
* device instance $391 r0 *1 70.13,16.28 nfet
XM$391 SA CLKP TAIL vsubs nfet_03v3 L=0.28U W=2U AS=0.58P AD=0.58P PS=2.58U PD=2.58U
* device instance $392 r0 *1 70.99,16.28 nfet
XM$392 TAIL CLKP SA vsubs nfet_03v3 L=0.28U W=2U AS=0.58P AD=0.58P PS=2.58U PD=2.58U
* device instance $393 r0 *1 71.85,16.28 nfet
XM$393 SA CLKP TAIL vsubs nfet_03v3 L=0.28U W=2U AS=0.58P AD=0.58P PS=2.58U PD=2.58U
* device instance $394 r0 *1 72.71,16.28 nfet
XM$394 TAIL CLKP SA vsubs nfet_03v3 L=0.28U W=2U AS=0.58P AD=0.58P PS=2.58U PD=2.58U
* device instance $395 r0 *1 73.57,16.28 nfet
XM$395 SA CLKP TAIL vsubs nfet_03v3 L=0.28U W=2U AS=0.58P AD=0.58P PS=2.58U PD=2.58U
* device instance $396 r0 *1 74.43,16.28 nfet
XM$396 TAIL CLKP SA vsubs nfet_03v3 L=0.28U W=2U AS=0.58P AD=0.58P PS=2.58U PD=2.58U
* device instance $397 r0 *1 75.29,16.28 nfet
XM$397 SA CLKP TAIL vsubs nfet_03v3 L=0.28U W=2U AS=0.58P AD=0.58P PS=2.58U PD=2.58U
* device instance $398 r0 *1 76.15,16.28 nfet
XM$398 TAIL CLKP SA vsubs nfet_03v3 L=0.28U W=2U AS=0.58P AD=0.58P PS=2.58U PD=2.58U
* device instance $399 r0 *1 77.01,16.28 nfet
XM$399 SA CLKP TAIL vsubs nfet_03v3 L=0.28U W=2U AS=0.58P AD=0.58P PS=2.58U PD=2.58U
* device instance $400 r0 *1 77.87,16.28 nfet
XM$400 TAIL CLKP SA vsubs nfet_03v3 L=0.28U W=2U AS=0.58P AD=0.58P PS=2.58U PD=2.58U
* device instance $401 r0 *1 78.73,16.28 nfet
XM$401 SA CLKP TAIL vsubs nfet_03v3 L=0.28U W=2U AS=0.58P AD=0.58P PS=2.58U PD=2.58U
* device instance $402 r0 *1 79.59,16.28 nfet
XM$402 TAIL CLKP SA vsubs nfet_03v3 L=0.28U W=2U AS=0.58P AD=0.58P PS=2.58U PD=2.58U
* device instance $403 r0 *1 80.45,16.28 nfet
XM$403 SA CLKP TAIL vsubs nfet_03v3 L=0.28U W=2U AS=0.58P AD=0.58P PS=2.58U PD=2.58U
* device instance $404 r0 *1 81.31,16.28 nfet
XM$404 TAIL CLKP SA vsubs nfet_03v3 L=0.28U W=2U AS=0.58P AD=0.58P PS=2.58U PD=2.58U
* device instance $405 r0 *1 82.17,16.28 nfet
XM$405 SA CLKP TAIL vsubs nfet_03v3 L=0.28U W=2U AS=0.58P AD=0.58P PS=2.58U PD=2.58U
* device instance $406 r0 *1 83.03,16.28 nfet
XM$406 TAIL CLKP SA vsubs nfet_03v3 L=0.28U W=2U AS=0.58P AD=0.58P PS=2.58U PD=2.58U
* device instance $407 r0 *1 83.89,16.28 nfet
XM$407 SA CLKP TAIL vsubs nfet_03v3 L=0.28U W=2U AS=0.58P AD=0.58P PS=2.58U PD=2.58U
* device instance $408 r0 *1 84.75,16.28 nfet
XM$408 TAIL CLKP SA vsubs nfet_03v3 L=0.28U W=2U AS=0.58P AD=0.58P PS=2.58U PD=2.58U
* device instance $409 r0 *1 85.61,16.28 nfet
XM$409 SA CLKP TAIL vsubs nfet_03v3 L=0.28U W=2U AS=0.58P AD=0.58P PS=2.58U PD=2.58U
* device instance $410 r0 *1 86.47,16.28 nfet
XM$410 TAIL CLKP SA vsubs nfet_03v3 L=0.28U W=2U AS=0.58P AD=0.58P PS=2.58U PD=2.58U
* device instance $411 r0 *1 87.33,16.28 nfet
XM$411 SA CLKP TAIL vsubs nfet_03v3 L=0.28U W=2U AS=0.58P AD=0.58P PS=2.58U PD=2.58U
* device instance $412 r0 *1 88.19,16.28 nfet
XM$412 TAIL CLKP SA vsubs nfet_03v3 L=0.28U W=2U AS=0.58P AD=0.58P PS=2.58U PD=2.58U
* device instance $413 r0 *1 89.05,16.28 nfet
XM$413 SA CLKP TAIL vsubs nfet_03v3 L=0.28U W=2U AS=0.58P AD=0.58P PS=2.58U PD=2.58U
* device instance $414 r0 *1 89.91,16.28 nfet
XM$414 TAIL CLKP SA vsubs nfet_03v3 L=0.28U W=2U AS=0.58P AD=0.58P PS=2.58U PD=2.58U
* device instance $415 r0 *1 90.77,16.28 nfet
XM$415 SA CLKP TAIL vsubs nfet_03v3 L=0.28U W=2U AS=0.58P AD=0.58P PS=2.58U PD=2.58U
* device instance $416 r0 *1 91.63,16.28 nfet
XM$416 TAIL CLKP SA vsubs nfet_03v3 L=0.28U W=2U AS=0.58P AD=0.58P PS=2.58U PD=2.58U
* device instance $417 r0 *1 92.49,16.28 nfet
XM$417 SA CLKP TAIL vsubs nfet_03v3 L=0.28U W=2U AS=0.58P AD=0.58P PS=2.58U PD=2.58U
* device instance $418 r0 *1 93.35,16.28 nfet
XM$418 TAIL CLKP SA vsubs nfet_03v3 L=0.28U W=2U AS=0.58P AD=0.58P PS=2.58U PD=2.58U
* device instance $419 r0 *1 94.21,16.28 nfet
XM$419 SA CLKP TAIL vsubs nfet_03v3 L=0.28U W=2U AS=0.58P AD=0.58P PS=2.58U PD=2.58U
* device instance $420 r0 *1 95.07,16.28 nfet
XM$420 TAIL CLKP SA vsubs nfet_03v3 L=0.28U W=2U AS=0.58P AD=0.58P PS=2.58U PD=2.58U
* device instance $421 r0 *1 95.93,16.28 nfet
XM$421 SA CLKP TAIL vsubs nfet_03v3 L=0.28U W=2U AS=0.58P AD=0.58P PS=2.58U PD=2.58U
* device instance $422 r0 *1 96.79,16.28 nfet
XM$422 TAIL CLKP SA vsubs nfet_03v3 L=0.28U W=2U AS=0.58P AD=0.58P PS=2.58U PD=2.58U
* device instance $423 r0 *1 97.65,16.28 nfet
XM$423 SA CLKP TAIL vsubs nfet_03v3 L=0.28U W=2U AS=0.58P AD=0.58P PS=2.58U PD=2.58U
* device instance $424 r0 *1 98.51,16.28 nfet
XM$424 TAIL CLKP SA vsubs nfet_03v3 L=0.28U W=2U AS=0.58P AD=0.58P PS=2.58U PD=2.58U
* device instance $425 r0 *1 99.37,16.28 nfet
XM$425 SA CLKP TAIL vsubs nfet_03v3 L=0.28U W=2U AS=0.58P AD=0.58P PS=2.58U PD=2.58U
* device instance $426 r0 *1 100.23,16.28 nfet
XM$426 TAIL CLKP SA vsubs nfet_03v3 L=0.28U W=2U AS=0.58P AD=0.58P PS=2.58U PD=2.58U
* device instance $427 r0 *1 101.09,16.28 nfet
XM$427 SA CLKP TAIL vsubs nfet_03v3 L=0.28U W=2U AS=0.58P AD=0.58P PS=2.58U PD=2.58U
* device instance $428 r0 *1 101.95,16.28 nfet
XM$428 TAIL CLKP SA vsubs nfet_03v3 L=0.28U W=2U AS=0.58P AD=0.58P PS=2.58U PD=2.58U
* device instance $429 r0 *1 102.81,16.28 nfet
XM$429 SA CLKP TAIL vsubs nfet_03v3 L=0.28U W=2U AS=0.58P AD=0.58P PS=2.58U PD=2.58U
* device instance $430 r0 *1 103.67,16.28 nfet
XM$430 TAIL CLKP SA vsubs nfet_03v3 L=0.28U W=2U AS=0.58P AD=0.58P PS=2.58U PD=2.58U
* device instance $431 r0 *1 104.53,16.28 nfet
XM$431 SA CLKP TAIL vsubs nfet_03v3 L=0.28U W=2U AS=0.58P AD=0.58P PS=2.58U PD=2.58U
* device instance $432 r0 *1 105.39,16.28 nfet
XM$432 TAIL CLKP SA vsubs nfet_03v3 L=0.28U W=2U AS=0.58P AD=0.58P PS=2.58U PD=2.58U
* device instance $433 r0 *1 106.25,16.28 nfet
XM$433 SA CLKP TAIL vsubs nfet_03v3 L=0.28U W=2U AS=0.58P AD=0.58P PS=2.58U PD=2.58U
* device instance $434 r0 *1 107.11,16.28 nfet
XM$434 TAIL CLKP SA vsubs nfet_03v3 L=0.28U W=2U AS=0.58P AD=1P PS=2.58U PD=5U
* device instance $435 r0 *1 33.39,76.12 nfet
XM$435 OUTP D1P SB vsubs nfet_03v3 L=0.28U W=2U AS=1P AD=0.58P PS=5U PD=2.58U
* device instance $436 r0 *1 34.25,76.12 nfet
XM$436 SB D1P OUTP vsubs nfet_03v3 L=0.28U W=2U AS=0.58P AD=0.58P PS=2.58U PD=2.58U
* device instance $437 r0 *1 35.11,76.12 nfet
XM$437 OUTP D1P SB vsubs nfet_03v3 L=0.28U W=2U AS=0.58P AD=0.58P PS=2.58U PD=2.58U
* device instance $438 r0 *1 35.97,76.12 nfet
XM$438 SB D1P OUTP vsubs nfet_03v3 L=0.28U W=2U AS=0.58P AD=0.58P PS=2.58U PD=2.58U
* device instance $439 r0 *1 36.83,76.12 nfet
XM$439 OUTP D1P SB vsubs nfet_03v3 L=0.28U W=2U AS=0.58P AD=0.58P PS=2.58U PD=2.58U
* device instance $440 r0 *1 37.69,76.12 nfet
XM$440 SB D1P OUTP vsubs nfet_03v3 L=0.28U W=2U AS=0.58P AD=0.58P PS=2.58U PD=2.58U
* device instance $441 r0 *1 38.55,76.12 nfet
XM$441 OUTP D1P SB vsubs nfet_03v3 L=0.28U W=2U AS=0.58P AD=0.58P PS=2.58U PD=2.58U
* device instance $442 r0 *1 39.41,76.12 nfet
XM$442 SB D1P OUTP vsubs nfet_03v3 L=0.28U W=2U AS=0.58P AD=0.58P PS=2.58U PD=2.58U
* device instance $443 r0 *1 40.27,76.12 nfet
XM$443 OUTP D1P SB vsubs nfet_03v3 L=0.28U W=2U AS=0.58P AD=0.58P PS=2.58U PD=2.58U
* device instance $444 r0 *1 41.13,76.12 nfet
XM$444 SB D1P OUTP vsubs nfet_03v3 L=0.28U W=2U AS=0.58P AD=0.58P PS=2.58U PD=2.58U
* device instance $445 r0 *1 41.99,76.12 nfet
XM$445 OUTP D1P SB vsubs nfet_03v3 L=0.28U W=2U AS=0.58P AD=0.58P PS=2.58U PD=2.58U
* device instance $446 r0 *1 42.85,76.12 nfet
XM$446 SB D1P OUTP vsubs nfet_03v3 L=0.28U W=2U AS=0.58P AD=0.58P PS=2.58U PD=2.58U
* device instance $447 r0 *1 43.71,76.12 nfet
XM$447 OUTP D1P SB vsubs nfet_03v3 L=0.28U W=2U AS=0.58P AD=0.58P PS=2.58U PD=2.58U
* device instance $448 r0 *1 44.57,76.12 nfet
XM$448 SB D1P OUTP vsubs nfet_03v3 L=0.28U W=2U AS=0.58P AD=0.58P PS=2.58U PD=2.58U
* device instance $449 r0 *1 45.43,76.12 nfet
XM$449 OUTP D1P SB vsubs nfet_03v3 L=0.28U W=2U AS=0.58P AD=0.58P PS=2.58U PD=2.58U
* device instance $450 r0 *1 46.29,76.12 nfet
XM$450 SB D1P OUTP vsubs nfet_03v3 L=0.28U W=2U AS=0.58P AD=0.58P PS=2.58U PD=2.58U
* device instance $451 r0 *1 47.15,76.12 nfet
XM$451 OUTP D1P SB vsubs nfet_03v3 L=0.28U W=2U AS=0.58P AD=0.58P PS=2.58U PD=2.58U
* device instance $452 r0 *1 48.01,76.12 nfet
XM$452 SB D1P OUTP vsubs nfet_03v3 L=0.28U W=2U AS=0.58P AD=0.58P PS=2.58U PD=2.58U
* device instance $453 r0 *1 48.87,76.12 nfet
XM$453 OUTP D1P SB vsubs nfet_03v3 L=0.28U W=2U AS=0.58P AD=0.58P PS=2.58U PD=2.58U
* device instance $454 r0 *1 49.73,76.12 nfet
XM$454 SB D1P OUTP vsubs nfet_03v3 L=0.28U W=2U AS=0.58P AD=0.58P PS=2.58U PD=2.58U
* device instance $455 r0 *1 50.59,76.12 nfet
XM$455 OUTP D1P SB vsubs nfet_03v3 L=0.28U W=2U AS=0.58P AD=0.58P PS=2.58U PD=2.58U
* device instance $456 r0 *1 51.45,76.12 nfet
XM$456 SB D1P OUTP vsubs nfet_03v3 L=0.28U W=2U AS=0.58P AD=0.58P PS=2.58U PD=2.58U
* device instance $457 r0 *1 52.31,76.12 nfet
XM$457 OUTP D1P SB vsubs nfet_03v3 L=0.28U W=2U AS=0.58P AD=0.58P PS=2.58U PD=2.58U
* device instance $458 r0 *1 53.17,76.12 nfet
XM$458 SB D1P OUTP vsubs nfet_03v3 L=0.28U W=2U AS=0.58P AD=0.58P PS=2.58U PD=2.58U
* device instance $459 r0 *1 54.03,76.12 nfet
XM$459 OUTP D1P SB vsubs nfet_03v3 L=0.28U W=2U AS=0.58P AD=0.58P PS=2.58U PD=2.58U
* device instance $460 r0 *1 54.89,76.12 nfet
XM$460 SB D1P OUTP vsubs nfet_03v3 L=0.28U W=2U AS=0.58P AD=0.58P PS=2.58U PD=2.58U
* device instance $461 r0 *1 55.75,76.12 nfet
XM$461 OUTP D1P SB vsubs nfet_03v3 L=0.28U W=2U AS=0.58P AD=0.58P PS=2.58U PD=2.58U
* device instance $462 r0 *1 56.61,76.12 nfet
XM$462 SB D1P OUTP vsubs nfet_03v3 L=0.28U W=2U AS=0.58P AD=0.58P PS=2.58U PD=2.58U
* device instance $463 r0 *1 57.47,76.12 nfet
XM$463 OUTP D1P SB vsubs nfet_03v3 L=0.28U W=2U AS=0.58P AD=0.58P PS=2.58U PD=2.58U
* device instance $464 r0 *1 58.33,76.12 nfet
XM$464 SB D1P OUTP vsubs nfet_03v3 L=0.28U W=2U AS=0.58P AD=0.58P PS=2.58U PD=2.58U
* device instance $465 r0 *1 59.19,76.12 nfet
XM$465 OUTP D1P SB vsubs nfet_03v3 L=0.28U W=2U AS=0.58P AD=0.58P PS=2.58U PD=2.58U
* device instance $466 r0 *1 60.05,76.12 nfet
XM$466 SB D1P OUTP vsubs nfet_03v3 L=0.28U W=2U AS=0.58P AD=0.58P PS=2.58U PD=2.58U
* device instance $467 r0 *1 60.91,76.12 nfet
XM$467 OUTP D1P SB vsubs nfet_03v3 L=0.28U W=2U AS=0.58P AD=0.58P PS=2.58U PD=2.58U
* device instance $468 r0 *1 61.77,76.12 nfet
XM$468 SB D1P OUTP vsubs nfet_03v3 L=0.28U W=2U AS=0.58P AD=0.58P PS=2.58U PD=2.58U
* device instance $469 r0 *1 62.63,76.12 nfet
XM$469 OUTP D1P SB vsubs nfet_03v3 L=0.28U W=2U AS=0.58P AD=0.58P PS=2.58U PD=2.58U
* device instance $470 r0 *1 63.49,76.12 nfet
XM$470 SB D1P OUTP vsubs nfet_03v3 L=0.28U W=2U AS=0.58P AD=0.58P PS=2.58U PD=2.58U
* device instance $471 r0 *1 64.35,76.12 nfet
XM$471 OUTP D1P SB vsubs nfet_03v3 L=0.28U W=2U AS=0.58P AD=0.58P PS=2.58U PD=2.58U
* device instance $472 r0 *1 65.21,76.12 nfet
XM$472 SB D1P OUTP vsubs nfet_03v3 L=0.28U W=2U AS=0.58P AD=0.58P PS=2.58U PD=2.58U
* device instance $473 r0 *1 66.07,76.12 nfet
XM$473 OUTP D1P SB vsubs nfet_03v3 L=0.28U W=2U AS=0.58P AD=0.58P PS=2.58U PD=2.58U
* device instance $474 r0 *1 66.93,76.12 nfet
XM$474 SB D1P OUTP vsubs nfet_03v3 L=0.28U W=2U AS=0.58P AD=0.58P PS=2.58U PD=2.58U
* device instance $475 r0 *1 67.79,76.12 nfet
XM$475 OUTP D1P SB vsubs nfet_03v3 L=0.28U W=2U AS=0.58P AD=0.58P PS=2.58U PD=2.58U
* device instance $476 r0 *1 68.65,76.12 nfet
XM$476 SB D1P OUTP vsubs nfet_03v3 L=0.28U W=2U AS=0.58P AD=0.58P PS=2.58U PD=2.58U
* device instance $477 r0 *1 69.51,76.12 nfet
XM$477 OUTP D1P SB vsubs nfet_03v3 L=0.28U W=2U AS=0.58P AD=0.58P PS=2.58U PD=2.58U
* device instance $478 r0 *1 70.37,76.12 nfet
XM$478 SB D1P OUTP vsubs nfet_03v3 L=0.28U W=2U AS=0.58P AD=0.58P PS=2.58U PD=2.58U
* device instance $479 r0 *1 71.23,76.12 nfet
XM$479 OUTP D1P SB vsubs nfet_03v3 L=0.28U W=2U AS=0.58P AD=0.58P PS=2.58U PD=2.58U
* device instance $480 r0 *1 72.09,76.12 nfet
XM$480 SB D1P OUTP vsubs nfet_03v3 L=0.28U W=2U AS=0.58P AD=0.58P PS=2.58U PD=2.58U
* device instance $481 r0 *1 72.95,76.12 nfet
XM$481 OUTP D1P SB vsubs nfet_03v3 L=0.28U W=2U AS=0.58P AD=0.58P PS=2.58U PD=2.58U
* device instance $482 r0 *1 73.81,76.12 nfet
XM$482 SB D1P OUTP vsubs nfet_03v3 L=0.28U W=2U AS=0.58P AD=0.58P PS=2.58U PD=2.58U
* device instance $483 r0 *1 74.67,76.12 nfet
XM$483 OUTP D1P SB vsubs nfet_03v3 L=0.28U W=2U AS=0.58P AD=0.58P PS=2.58U PD=2.58U
* device instance $484 r0 *1 75.53,76.12 nfet
XM$484 SB D1P OUTP vsubs nfet_03v3 L=0.28U W=2U AS=0.58P AD=0.58P PS=2.58U PD=2.58U
* device instance $485 r0 *1 76.39,76.12 nfet
XM$485 OUTP D1P SB vsubs nfet_03v3 L=0.28U W=2U AS=0.58P AD=0.58P PS=2.58U PD=2.58U
* device instance $486 r0 *1 77.25,76.12 nfet
XM$486 SB D1P OUTP vsubs nfet_03v3 L=0.28U W=2U AS=0.58P AD=0.58P PS=2.58U PD=2.58U
* device instance $487 r0 *1 78.11,76.12 nfet
XM$487 OUTP D1P SB vsubs nfet_03v3 L=0.28U W=2U AS=0.58P AD=0.58P PS=2.58U PD=2.58U
* device instance $488 r0 *1 78.97,76.12 nfet
XM$488 SB D1P OUTP vsubs nfet_03v3 L=0.28U W=2U AS=0.58P AD=0.58P PS=2.58U PD=2.58U
* device instance $489 r0 *1 79.83,76.12 nfet
XM$489 OUTP D1P SB vsubs nfet_03v3 L=0.28U W=2U AS=0.58P AD=0.58P PS=2.58U PD=2.58U
* device instance $490 r0 *1 80.69,76.12 nfet
XM$490 SB D1P OUTP vsubs nfet_03v3 L=0.28U W=2U AS=0.58P AD=0.58P PS=2.58U PD=2.58U
* device instance $491 r0 *1 81.55,76.12 nfet
XM$491 OUTP D1P SB vsubs nfet_03v3 L=0.28U W=2U AS=0.58P AD=0.58P PS=2.58U PD=2.58U
* device instance $492 r0 *1 82.41,76.12 nfet
XM$492 SB D1P OUTP vsubs nfet_03v3 L=0.28U W=2U AS=0.58P AD=0.58P PS=2.58U PD=2.58U
* device instance $493 r0 *1 83.27,76.12 nfet
XM$493 OUTP D1P SB vsubs nfet_03v3 L=0.28U W=2U AS=0.58P AD=0.58P PS=2.58U PD=2.58U
* device instance $494 r0 *1 84.13,76.12 nfet
XM$494 SB D1P OUTP vsubs nfet_03v3 L=0.28U W=2U AS=0.58P AD=0.58P PS=2.58U PD=2.58U
* device instance $495 r0 *1 84.99,76.12 nfet
XM$495 OUTP D1P SB vsubs nfet_03v3 L=0.28U W=2U AS=0.58P AD=0.58P PS=2.58U PD=2.58U
* device instance $496 r0 *1 85.85,76.12 nfet
XM$496 SB D1P OUTP vsubs nfet_03v3 L=0.28U W=2U AS=0.58P AD=0.58P PS=2.58U PD=2.58U
* device instance $497 r0 *1 86.71,76.12 nfet
XM$497 OUTP D1P SB vsubs nfet_03v3 L=0.28U W=2U AS=0.58P AD=0.58P PS=2.58U PD=2.58U
* device instance $498 r0 *1 87.57,76.12 nfet
XM$498 SB D1P OUTP vsubs nfet_03v3 L=0.28U W=2U AS=0.58P AD=1P PS=2.58U PD=5U
* device instance $499 r0 *1 109.89,61.66 nfet
XM$499 SB CLKN TAIL vsubs nfet_03v3 L=0.28U W=2U AS=1P AD=0.58P PS=5U PD=2.58U
* device instance $500 r0 *1 110.75,61.66 nfet
XM$500 TAIL CLKN SB vsubs nfet_03v3 L=0.28U W=2U AS=0.58P AD=0.58P PS=2.58U PD=2.58U
* device instance $501 r0 *1 111.61,61.66 nfet
XM$501 SB CLKN TAIL vsubs nfet_03v3 L=0.28U W=2U AS=0.58P AD=0.58P PS=2.58U PD=2.58U
* device instance $502 r0 *1 112.47,61.66 nfet
XM$502 TAIL CLKN SB vsubs nfet_03v3 L=0.28U W=2U AS=0.58P AD=0.58P PS=2.58U PD=2.58U
* device instance $503 r0 *1 113.33,61.66 nfet
XM$503 SB CLKN TAIL vsubs nfet_03v3 L=0.28U W=2U AS=0.58P AD=0.58P PS=2.58U PD=2.58U
* device instance $504 r0 *1 114.19,61.66 nfet
XM$504 TAIL CLKN SB vsubs nfet_03v3 L=0.28U W=2U AS=0.58P AD=0.58P PS=2.58U PD=2.58U
* device instance $505 r0 *1 115.05,61.66 nfet
XM$505 SB CLKN TAIL vsubs nfet_03v3 L=0.28U W=2U AS=0.58P AD=0.58P PS=2.58U PD=2.58U
* device instance $506 r0 *1 115.91,61.66 nfet
XM$506 TAIL CLKN SB vsubs nfet_03v3 L=0.28U W=2U AS=0.58P AD=0.58P PS=2.58U PD=2.58U
* device instance $507 r0 *1 116.77,61.66 nfet
XM$507 SB CLKN TAIL vsubs nfet_03v3 L=0.28U W=2U AS=0.58P AD=0.58P PS=2.58U PD=2.58U
* device instance $508 r0 *1 117.63,61.66 nfet
XM$508 TAIL CLKN SB vsubs nfet_03v3 L=0.28U W=2U AS=0.58P AD=0.58P PS=2.58U PD=2.58U
* device instance $509 r0 *1 118.49,61.66 nfet
XM$509 SB CLKN TAIL vsubs nfet_03v3 L=0.28U W=2U AS=0.58P AD=0.58P PS=2.58U PD=2.58U
* device instance $510 r0 *1 119.35,61.66 nfet
XM$510 TAIL CLKN SB vsubs nfet_03v3 L=0.28U W=2U AS=0.58P AD=0.58P PS=2.58U PD=2.58U
* device instance $511 r0 *1 120.21,61.66 nfet
XM$511 SB CLKN TAIL vsubs nfet_03v3 L=0.28U W=2U AS=0.58P AD=0.58P PS=2.58U PD=2.58U
* device instance $512 r0 *1 121.07,61.66 nfet
XM$512 TAIL CLKN SB vsubs nfet_03v3 L=0.28U W=2U AS=0.58P AD=0.58P PS=2.58U PD=2.58U
* device instance $513 r0 *1 121.93,61.66 nfet
XM$513 SB CLKN TAIL vsubs nfet_03v3 L=0.28U W=2U AS=0.58P AD=0.58P PS=2.58U PD=2.58U
* device instance $514 r0 *1 122.79,61.66 nfet
XM$514 TAIL CLKN SB vsubs nfet_03v3 L=0.28U W=2U AS=0.58P AD=0.58P PS=2.58U PD=2.58U
* device instance $515 r0 *1 123.65,61.66 nfet
XM$515 SB CLKN TAIL vsubs nfet_03v3 L=0.28U W=2U AS=0.58P AD=0.58P PS=2.58U PD=2.58U
* device instance $516 r0 *1 124.51,61.66 nfet
XM$516 TAIL CLKN SB vsubs nfet_03v3 L=0.28U W=2U AS=0.58P AD=0.58P PS=2.58U PD=2.58U
* device instance $517 r0 *1 125.37,61.66 nfet
XM$517 SB CLKN TAIL vsubs nfet_03v3 L=0.28U W=2U AS=0.58P AD=0.58P PS=2.58U PD=2.58U
* device instance $518 r0 *1 126.23,61.66 nfet
XM$518 TAIL CLKN SB vsubs nfet_03v3 L=0.28U W=2U AS=0.58P AD=0.58P PS=2.58U PD=2.58U
* device instance $519 r0 *1 127.09,61.66 nfet
XM$519 SB CLKN TAIL vsubs nfet_03v3 L=0.28U W=2U AS=0.58P AD=0.58P PS=2.58U PD=2.58U
* device instance $520 r0 *1 127.95,61.66 nfet
XM$520 TAIL CLKN SB vsubs nfet_03v3 L=0.28U W=2U AS=0.58P AD=0.58P PS=2.58U PD=2.58U
* device instance $521 r0 *1 128.81,61.66 nfet
XM$521 SB CLKN TAIL vsubs nfet_03v3 L=0.28U W=2U AS=0.58P AD=0.58P PS=2.58U PD=2.58U
* device instance $522 r0 *1 129.67,61.66 nfet
XM$522 TAIL CLKN SB vsubs nfet_03v3 L=0.28U W=2U AS=0.58P AD=0.58P PS=2.58U PD=2.58U
* device instance $523 r0 *1 130.53,61.66 nfet
XM$523 SB CLKN TAIL vsubs nfet_03v3 L=0.28U W=2U AS=0.58P AD=0.58P PS=2.58U PD=2.58U
* device instance $524 r0 *1 131.39,61.66 nfet
XM$524 TAIL CLKN SB vsubs nfet_03v3 L=0.28U W=2U AS=0.58P AD=0.58P PS=2.58U PD=2.58U
* device instance $525 r0 *1 132.25,61.66 nfet
XM$525 SB CLKN TAIL vsubs nfet_03v3 L=0.28U W=2U AS=0.58P AD=0.58P PS=2.58U PD=2.58U
* device instance $526 r0 *1 133.11,61.66 nfet
XM$526 TAIL CLKN SB vsubs nfet_03v3 L=0.28U W=2U AS=0.58P AD=0.58P PS=2.58U PD=2.58U
* device instance $527 r0 *1 133.97,61.66 nfet
XM$527 SB CLKN TAIL vsubs nfet_03v3 L=0.28U W=2U AS=0.58P AD=0.58P PS=2.58U PD=2.58U
* device instance $528 r0 *1 134.83,61.66 nfet
XM$528 TAIL CLKN SB vsubs nfet_03v3 L=0.28U W=2U AS=0.58P AD=0.58P PS=2.58U PD=2.58U
* device instance $529 r0 *1 135.69,61.66 nfet
XM$529 SB CLKN TAIL vsubs nfet_03v3 L=0.28U W=2U AS=0.58P AD=0.58P PS=2.58U PD=2.58U
* device instance $530 r0 *1 136.55,61.66 nfet
XM$530 TAIL CLKN SB vsubs nfet_03v3 L=0.28U W=2U AS=0.58P AD=0.58P PS=2.58U PD=2.58U
* device instance $531 r0 *1 137.41,61.66 nfet
XM$531 SB CLKN TAIL vsubs nfet_03v3 L=0.28U W=2U AS=0.58P AD=0.58P PS=2.58U PD=2.58U
* device instance $532 r0 *1 138.27,61.66 nfet
XM$532 TAIL CLKN SB vsubs nfet_03v3 L=0.28U W=2U AS=0.58P AD=0.58P PS=2.58U PD=2.58U
* device instance $533 r0 *1 139.13,61.66 nfet
XM$533 SB CLKN TAIL vsubs nfet_03v3 L=0.28U W=2U AS=0.58P AD=0.58P PS=2.58U PD=2.58U
* device instance $534 r0 *1 139.99,61.66 nfet
XM$534 TAIL CLKN SB vsubs nfet_03v3 L=0.28U W=2U AS=0.58P AD=0.58P PS=2.58U PD=2.58U
* device instance $535 r0 *1 140.85,61.66 nfet
XM$535 SB CLKN TAIL vsubs nfet_03v3 L=0.28U W=2U AS=0.58P AD=0.58P PS=2.58U PD=2.58U
* device instance $536 r0 *1 141.71,61.66 nfet
XM$536 TAIL CLKN SB vsubs nfet_03v3 L=0.28U W=2U AS=0.58P AD=0.58P PS=2.58U PD=2.58U
* device instance $537 r0 *1 142.57,61.66 nfet
XM$537 SB CLKN TAIL vsubs nfet_03v3 L=0.28U W=2U AS=0.58P AD=0.58P PS=2.58U PD=2.58U
* device instance $538 r0 *1 143.43,61.66 nfet
XM$538 TAIL CLKN SB vsubs nfet_03v3 L=0.28U W=2U AS=0.58P AD=0.58P PS=2.58U PD=2.58U
* device instance $539 r0 *1 144.29,61.66 nfet
XM$539 SB CLKN TAIL vsubs nfet_03v3 L=0.28U W=2U AS=0.58P AD=0.58P PS=2.58U PD=2.58U
* device instance $540 r0 *1 145.15,61.66 nfet
XM$540 TAIL CLKN SB vsubs nfet_03v3 L=0.28U W=2U AS=0.58P AD=0.58P PS=2.58U PD=2.58U
* device instance $541 r0 *1 146.01,61.66 nfet
XM$541 SB CLKN TAIL vsubs nfet_03v3 L=0.28U W=2U AS=0.58P AD=0.58P PS=2.58U PD=2.58U
* device instance $542 r0 *1 146.87,61.66 nfet
XM$542 TAIL CLKN SB vsubs nfet_03v3 L=0.28U W=2U AS=0.58P AD=0.58P PS=2.58U PD=2.58U
* device instance $543 r0 *1 147.73,61.66 nfet
XM$543 SB CLKN TAIL vsubs nfet_03v3 L=0.28U W=2U AS=0.58P AD=0.58P PS=2.58U PD=2.58U
* device instance $544 r0 *1 148.59,61.66 nfet
XM$544 TAIL CLKN SB vsubs nfet_03v3 L=0.28U W=2U AS=0.58P AD=0.58P PS=2.58U PD=2.58U
* device instance $545 r0 *1 149.45,61.66 nfet
XM$545 SB CLKN TAIL vsubs nfet_03v3 L=0.28U W=2U AS=0.58P AD=0.58P PS=2.58U PD=2.58U
* device instance $546 r0 *1 150.31,61.66 nfet
XM$546 TAIL CLKN SB vsubs nfet_03v3 L=0.28U W=2U AS=0.58P AD=0.58P PS=2.58U PD=2.58U
* device instance $547 r0 *1 151.17,61.66 nfet
XM$547 SB CLKN TAIL vsubs nfet_03v3 L=0.28U W=2U AS=0.58P AD=0.58P PS=2.58U PD=2.58U
* device instance $548 r0 *1 152.03,61.66 nfet
XM$548 TAIL CLKN SB vsubs nfet_03v3 L=0.28U W=2U AS=0.58P AD=0.58P PS=2.58U PD=2.58U
* device instance $549 r0 *1 152.89,61.66 nfet
XM$549 SB CLKN TAIL vsubs nfet_03v3 L=0.28U W=2U AS=0.58P AD=0.58P PS=2.58U PD=2.58U
* device instance $550 r0 *1 153.75,61.66 nfet
XM$550 TAIL CLKN SB vsubs nfet_03v3 L=0.28U W=2U AS=0.58P AD=0.58P PS=2.58U PD=2.58U
* device instance $551 r0 *1 154.61,61.66 nfet
XM$551 SB CLKN TAIL vsubs nfet_03v3 L=0.28U W=2U AS=0.58P AD=0.58P PS=2.58U PD=2.58U
* device instance $552 r0 *1 155.47,61.66 nfet
XM$552 TAIL CLKN SB vsubs nfet_03v3 L=0.28U W=2U AS=0.58P AD=0.58P PS=2.58U PD=2.58U
* device instance $553 r0 *1 156.33,61.66 nfet
XM$553 SB CLKN TAIL vsubs nfet_03v3 L=0.28U W=2U AS=0.58P AD=0.58P PS=2.58U PD=2.58U
* device instance $554 r0 *1 157.19,61.66 nfet
XM$554 TAIL CLKN SB vsubs nfet_03v3 L=0.28U W=2U AS=0.58P AD=0.58P PS=2.58U PD=2.58U
* device instance $555 r0 *1 158.05,61.66 nfet
XM$555 SB CLKN TAIL vsubs nfet_03v3 L=0.28U W=2U AS=0.58P AD=0.58P PS=2.58U PD=2.58U
* device instance $556 r0 *1 158.91,61.66 nfet
XM$556 TAIL CLKN SB vsubs nfet_03v3 L=0.28U W=2U AS=0.58P AD=0.58P PS=2.58U PD=2.58U
* device instance $557 r0 *1 159.77,61.66 nfet
XM$557 SB CLKN TAIL vsubs nfet_03v3 L=0.28U W=2U AS=0.58P AD=0.58P PS=2.58U PD=2.58U
* device instance $558 r0 *1 160.63,61.66 nfet
XM$558 TAIL CLKN SB vsubs nfet_03v3 L=0.28U W=2U AS=0.58P AD=0.58P PS=2.58U PD=2.58U
* device instance $559 r0 *1 161.49,61.66 nfet
XM$559 SB CLKN TAIL vsubs nfet_03v3 L=0.28U W=2U AS=0.58P AD=0.58P PS=2.58U PD=2.58U
* device instance $560 r0 *1 162.35,61.66 nfet
XM$560 TAIL CLKN SB vsubs nfet_03v3 L=0.28U W=2U AS=0.58P AD=0.58P PS=2.58U PD=2.58U
* device instance $561 r0 *1 163.21,61.66 nfet
XM$561 SB CLKN TAIL vsubs nfet_03v3 L=0.28U W=2U AS=0.58P AD=0.58P PS=2.58U PD=2.58U
* device instance $562 r0 *1 164.07,61.66 nfet
XM$562 TAIL CLKN SB vsubs nfet_03v3 L=0.28U W=2U AS=0.58P AD=0.58P PS=2.58U PD=2.58U
* device instance $563 r0 *1 164.93,61.66 nfet
XM$563 SB CLKN TAIL vsubs nfet_03v3 L=0.28U W=2U AS=0.58P AD=0.58P PS=2.58U PD=2.58U
* device instance $564 r0 *1 165.79,61.66 nfet
XM$564 TAIL CLKN SB vsubs nfet_03v3 L=0.28U W=2U AS=0.58P AD=0.58P PS=2.58U PD=2.58U
* device instance $565 r0 *1 166.65,61.66 nfet
XM$565 SB CLKN TAIL vsubs nfet_03v3 L=0.28U W=2U AS=0.58P AD=0.58P PS=2.58U PD=2.58U
* device instance $566 r0 *1 167.51,61.66 nfet
XM$566 TAIL CLKN SB vsubs nfet_03v3 L=0.28U W=2U AS=0.58P AD=0.58P PS=2.58U PD=2.58U
* device instance $567 r0 *1 168.37,61.66 nfet
XM$567 SB CLKN TAIL vsubs nfet_03v3 L=0.28U W=2U AS=0.58P AD=0.58P PS=2.58U PD=2.58U
* device instance $568 r0 *1 169.23,61.66 nfet
XM$568 TAIL CLKN SB vsubs nfet_03v3 L=0.28U W=2U AS=0.58P AD=0.58P PS=2.58U PD=2.58U
* device instance $569 r0 *1 170.09,61.66 nfet
XM$569 SB CLKN TAIL vsubs nfet_03v3 L=0.28U W=2U AS=0.58P AD=0.58P PS=2.58U PD=2.58U
* device instance $570 r0 *1 170.95,61.66 nfet
XM$570 TAIL CLKN SB vsubs nfet_03v3 L=0.28U W=2U AS=0.58P AD=0.58P PS=2.58U PD=2.58U
* device instance $571 r0 *1 171.81,61.66 nfet
XM$571 SB CLKN TAIL vsubs nfet_03v3 L=0.28U W=2U AS=0.58P AD=0.58P PS=2.58U PD=2.58U
* device instance $572 r0 *1 172.67,61.66 nfet
XM$572 TAIL CLKN SB vsubs nfet_03v3 L=0.28U W=2U AS=0.58P AD=0.58P PS=2.58U PD=2.58U
* device instance $573 r0 *1 173.53,61.66 nfet
XM$573 SB CLKN TAIL vsubs nfet_03v3 L=0.28U W=2U AS=0.58P AD=0.58P PS=2.58U PD=2.58U
* device instance $574 r0 *1 174.39,61.66 nfet
XM$574 TAIL CLKN SB vsubs nfet_03v3 L=0.28U W=2U AS=0.58P AD=0.58P PS=2.58U PD=2.58U
* device instance $575 r0 *1 175.25,61.66 nfet
XM$575 SB CLKN TAIL vsubs nfet_03v3 L=0.28U W=2U AS=0.58P AD=0.58P PS=2.58U PD=2.58U
* device instance $576 r0 *1 176.11,61.66 nfet
XM$576 TAIL CLKN SB vsubs nfet_03v3 L=0.28U W=2U AS=0.58P AD=0.58P PS=2.58U PD=2.58U
* device instance $577 r0 *1 176.97,61.66 nfet
XM$577 SB CLKN TAIL vsubs nfet_03v3 L=0.28U W=2U AS=0.58P AD=0.58P PS=2.58U PD=2.58U
* device instance $578 r0 *1 177.83,61.66 nfet
XM$578 TAIL CLKN SB vsubs nfet_03v3 L=0.28U W=2U AS=0.58P AD=0.58P PS=2.58U PD=2.58U
* device instance $579 r0 *1 178.69,61.66 nfet
XM$579 SB CLKN TAIL vsubs nfet_03v3 L=0.28U W=2U AS=0.58P AD=0.58P PS=2.58U PD=2.58U
* device instance $580 r0 *1 179.55,61.66 nfet
XM$580 TAIL CLKN SB vsubs nfet_03v3 L=0.28U W=2U AS=0.58P AD=0.58P PS=2.58U PD=2.58U
* device instance $581 r0 *1 180.41,61.66 nfet
XM$581 SB CLKN TAIL vsubs nfet_03v3 L=0.28U W=2U AS=0.58P AD=0.58P PS=2.58U PD=2.58U
* device instance $582 r0 *1 181.27,61.66 nfet
XM$582 TAIL CLKN SB vsubs nfet_03v3 L=0.28U W=2U AS=0.58P AD=0.58P PS=2.58U PD=2.58U
* device instance $583 r0 *1 182.13,61.66 nfet
XM$583 SB CLKN TAIL vsubs nfet_03v3 L=0.28U W=2U AS=0.58P AD=0.58P PS=2.58U PD=2.58U
* device instance $584 r0 *1 182.99,61.66 nfet
XM$584 TAIL CLKN SB vsubs nfet_03v3 L=0.28U W=2U AS=0.58P AD=0.58P PS=2.58U PD=2.58U
* device instance $585 r0 *1 183.85,61.66 nfet
XM$585 SB CLKN TAIL vsubs nfet_03v3 L=0.28U W=2U AS=0.58P AD=0.58P PS=2.58U PD=2.58U
* device instance $586 r0 *1 184.71,61.66 nfet
XM$586 TAIL CLKN SB vsubs nfet_03v3 L=0.28U W=2U AS=0.58P AD=0.58P PS=2.58U PD=2.58U
* device instance $587 r0 *1 185.57,61.66 nfet
XM$587 SB CLKN TAIL vsubs nfet_03v3 L=0.28U W=2U AS=0.58P AD=0.58P PS=2.58U PD=2.58U
* device instance $588 r0 *1 186.43,61.66 nfet
XM$588 TAIL CLKN SB vsubs nfet_03v3 L=0.28U W=2U AS=0.58P AD=0.58P PS=2.58U PD=2.58U
* device instance $589 r0 *1 187.29,61.66 nfet
XM$589 SB CLKN TAIL vsubs nfet_03v3 L=0.28U W=2U AS=0.58P AD=0.58P PS=2.58U PD=2.58U
* device instance $590 r0 *1 188.15,61.66 nfet
XM$590 TAIL CLKN SB vsubs nfet_03v3 L=0.28U W=2U AS=0.58P AD=0.58P PS=2.58U PD=2.58U
* device instance $591 r0 *1 189.01,61.66 nfet
XM$591 SB CLKN TAIL vsubs nfet_03v3 L=0.28U W=2U AS=0.58P AD=0.58P PS=2.58U PD=2.58U
* device instance $592 r0 *1 189.87,61.66 nfet
XM$592 TAIL CLKN SB vsubs nfet_03v3 L=0.28U W=2U AS=0.58P AD=0.58P PS=2.58U PD=2.58U
* device instance $593 r0 *1 190.73,61.66 nfet
XM$593 SB CLKN TAIL vsubs nfet_03v3 L=0.28U W=2U AS=0.58P AD=0.58P PS=2.58U PD=2.58U
* device instance $594 r0 *1 191.59,61.66 nfet
XM$594 TAIL CLKN SB vsubs nfet_03v3 L=0.28U W=2U AS=0.58P AD=1P PS=2.58U PD=5U
* device instance $595 r0 *1 129.35,76.12 nfet
XM$595 OUTN D1N SB vsubs nfet_03v3 L=0.28U W=2U AS=1P AD=0.58P PS=5U PD=2.58U
* device instance $596 r0 *1 130.21,76.12 nfet
XM$596 SB D1N OUTN vsubs nfet_03v3 L=0.28U W=2U AS=0.58P AD=0.58P PS=2.58U PD=2.58U
* device instance $597 r0 *1 131.07,76.12 nfet
XM$597 OUTN D1N SB vsubs nfet_03v3 L=0.28U W=2U AS=0.58P AD=0.58P PS=2.58U PD=2.58U
* device instance $598 r0 *1 131.93,76.12 nfet
XM$598 SB D1N OUTN vsubs nfet_03v3 L=0.28U W=2U AS=0.58P AD=0.58P PS=2.58U PD=2.58U
* device instance $599 r0 *1 132.79,76.12 nfet
XM$599 OUTN D1N SB vsubs nfet_03v3 L=0.28U W=2U AS=0.58P AD=0.58P PS=2.58U PD=2.58U
* device instance $600 r0 *1 133.65,76.12 nfet
XM$600 SB D1N OUTN vsubs nfet_03v3 L=0.28U W=2U AS=0.58P AD=0.58P PS=2.58U PD=2.58U
* device instance $601 r0 *1 134.51,76.12 nfet
XM$601 OUTN D1N SB vsubs nfet_03v3 L=0.28U W=2U AS=0.58P AD=0.58P PS=2.58U PD=2.58U
* device instance $602 r0 *1 135.37,76.12 nfet
XM$602 SB D1N OUTN vsubs nfet_03v3 L=0.28U W=2U AS=0.58P AD=0.58P PS=2.58U PD=2.58U
* device instance $603 r0 *1 136.23,76.12 nfet
XM$603 OUTN D1N SB vsubs nfet_03v3 L=0.28U W=2U AS=0.58P AD=0.58P PS=2.58U PD=2.58U
* device instance $604 r0 *1 137.09,76.12 nfet
XM$604 SB D1N OUTN vsubs nfet_03v3 L=0.28U W=2U AS=0.58P AD=0.58P PS=2.58U PD=2.58U
* device instance $605 r0 *1 137.95,76.12 nfet
XM$605 OUTN D1N SB vsubs nfet_03v3 L=0.28U W=2U AS=0.58P AD=0.58P PS=2.58U PD=2.58U
* device instance $606 r0 *1 138.81,76.12 nfet
XM$606 SB D1N OUTN vsubs nfet_03v3 L=0.28U W=2U AS=0.58P AD=0.58P PS=2.58U PD=2.58U
* device instance $607 r0 *1 139.67,76.12 nfet
XM$607 OUTN D1N SB vsubs nfet_03v3 L=0.28U W=2U AS=0.58P AD=0.58P PS=2.58U PD=2.58U
* device instance $608 r0 *1 140.53,76.12 nfet
XM$608 SB D1N OUTN vsubs nfet_03v3 L=0.28U W=2U AS=0.58P AD=0.58P PS=2.58U PD=2.58U
* device instance $609 r0 *1 141.39,76.12 nfet
XM$609 OUTN D1N SB vsubs nfet_03v3 L=0.28U W=2U AS=0.58P AD=0.58P PS=2.58U PD=2.58U
* device instance $610 r0 *1 142.25,76.12 nfet
XM$610 SB D1N OUTN vsubs nfet_03v3 L=0.28U W=2U AS=0.58P AD=0.58P PS=2.58U PD=2.58U
* device instance $611 r0 *1 143.11,76.12 nfet
XM$611 OUTN D1N SB vsubs nfet_03v3 L=0.28U W=2U AS=0.58P AD=0.58P PS=2.58U PD=2.58U
* device instance $612 r0 *1 143.97,76.12 nfet
XM$612 SB D1N OUTN vsubs nfet_03v3 L=0.28U W=2U AS=0.58P AD=0.58P PS=2.58U PD=2.58U
* device instance $613 r0 *1 144.83,76.12 nfet
XM$613 OUTN D1N SB vsubs nfet_03v3 L=0.28U W=2U AS=0.58P AD=0.58P PS=2.58U PD=2.58U
* device instance $614 r0 *1 145.69,76.12 nfet
XM$614 SB D1N OUTN vsubs nfet_03v3 L=0.28U W=2U AS=0.58P AD=0.58P PS=2.58U PD=2.58U
* device instance $615 r0 *1 146.55,76.12 nfet
XM$615 OUTN D1N SB vsubs nfet_03v3 L=0.28U W=2U AS=0.58P AD=0.58P PS=2.58U PD=2.58U
* device instance $616 r0 *1 147.41,76.12 nfet
XM$616 SB D1N OUTN vsubs nfet_03v3 L=0.28U W=2U AS=0.58P AD=0.58P PS=2.58U PD=2.58U
* device instance $617 r0 *1 148.27,76.12 nfet
XM$617 OUTN D1N SB vsubs nfet_03v3 L=0.28U W=2U AS=0.58P AD=0.58P PS=2.58U PD=2.58U
* device instance $618 r0 *1 149.13,76.12 nfet
XM$618 SB D1N OUTN vsubs nfet_03v3 L=0.28U W=2U AS=0.58P AD=0.58P PS=2.58U PD=2.58U
* device instance $619 r0 *1 149.99,76.12 nfet
XM$619 OUTN D1N SB vsubs nfet_03v3 L=0.28U W=2U AS=0.58P AD=0.58P PS=2.58U PD=2.58U
* device instance $620 r0 *1 150.85,76.12 nfet
XM$620 SB D1N OUTN vsubs nfet_03v3 L=0.28U W=2U AS=0.58P AD=0.58P PS=2.58U PD=2.58U
* device instance $621 r0 *1 151.71,76.12 nfet
XM$621 OUTN D1N SB vsubs nfet_03v3 L=0.28U W=2U AS=0.58P AD=0.58P PS=2.58U PD=2.58U
* device instance $622 r0 *1 152.57,76.12 nfet
XM$622 SB D1N OUTN vsubs nfet_03v3 L=0.28U W=2U AS=0.58P AD=0.58P PS=2.58U PD=2.58U
* device instance $623 r0 *1 153.43,76.12 nfet
XM$623 OUTN D1N SB vsubs nfet_03v3 L=0.28U W=2U AS=0.58P AD=0.58P PS=2.58U PD=2.58U
* device instance $624 r0 *1 154.29,76.12 nfet
XM$624 SB D1N OUTN vsubs nfet_03v3 L=0.28U W=2U AS=0.58P AD=0.58P PS=2.58U PD=2.58U
* device instance $625 r0 *1 155.15,76.12 nfet
XM$625 OUTN D1N SB vsubs nfet_03v3 L=0.28U W=2U AS=0.58P AD=0.58P PS=2.58U PD=2.58U
* device instance $626 r0 *1 156.01,76.12 nfet
XM$626 SB D1N OUTN vsubs nfet_03v3 L=0.28U W=2U AS=0.58P AD=0.58P PS=2.58U PD=2.58U
* device instance $627 r0 *1 156.87,76.12 nfet
XM$627 OUTN D1N SB vsubs nfet_03v3 L=0.28U W=2U AS=0.58P AD=0.58P PS=2.58U PD=2.58U
* device instance $628 r0 *1 157.73,76.12 nfet
XM$628 SB D1N OUTN vsubs nfet_03v3 L=0.28U W=2U AS=0.58P AD=0.58P PS=2.58U PD=2.58U
* device instance $629 r0 *1 158.59,76.12 nfet
XM$629 OUTN D1N SB vsubs nfet_03v3 L=0.28U W=2U AS=0.58P AD=0.58P PS=2.58U PD=2.58U
* device instance $630 r0 *1 159.45,76.12 nfet
XM$630 SB D1N OUTN vsubs nfet_03v3 L=0.28U W=2U AS=0.58P AD=0.58P PS=2.58U PD=2.58U
* device instance $631 r0 *1 160.31,76.12 nfet
XM$631 OUTN D1N SB vsubs nfet_03v3 L=0.28U W=2U AS=0.58P AD=0.58P PS=2.58U PD=2.58U
* device instance $632 r0 *1 161.17,76.12 nfet
XM$632 SB D1N OUTN vsubs nfet_03v3 L=0.28U W=2U AS=0.58P AD=0.58P PS=2.58U PD=2.58U
* device instance $633 r0 *1 162.03,76.12 nfet
XM$633 OUTN D1N SB vsubs nfet_03v3 L=0.28U W=2U AS=0.58P AD=0.58P PS=2.58U PD=2.58U
* device instance $634 r0 *1 162.89,76.12 nfet
XM$634 SB D1N OUTN vsubs nfet_03v3 L=0.28U W=2U AS=0.58P AD=0.58P PS=2.58U PD=2.58U
* device instance $635 r0 *1 163.75,76.12 nfet
XM$635 OUTN D1N SB vsubs nfet_03v3 L=0.28U W=2U AS=0.58P AD=0.58P PS=2.58U PD=2.58U
* device instance $636 r0 *1 164.61,76.12 nfet
XM$636 SB D1N OUTN vsubs nfet_03v3 L=0.28U W=2U AS=0.58P AD=0.58P PS=2.58U PD=2.58U
* device instance $637 r0 *1 165.47,76.12 nfet
XM$637 OUTN D1N SB vsubs nfet_03v3 L=0.28U W=2U AS=0.58P AD=0.58P PS=2.58U PD=2.58U
* device instance $638 r0 *1 166.33,76.12 nfet
XM$638 SB D1N OUTN vsubs nfet_03v3 L=0.28U W=2U AS=0.58P AD=0.58P PS=2.58U PD=2.58U
* device instance $639 r0 *1 167.19,76.12 nfet
XM$639 OUTN D1N SB vsubs nfet_03v3 L=0.28U W=2U AS=0.58P AD=0.58P PS=2.58U PD=2.58U
* device instance $640 r0 *1 168.05,76.12 nfet
XM$640 SB D1N OUTN vsubs nfet_03v3 L=0.28U W=2U AS=0.58P AD=0.58P PS=2.58U PD=2.58U
* device instance $641 r0 *1 168.91,76.12 nfet
XM$641 OUTN D1N SB vsubs nfet_03v3 L=0.28U W=2U AS=0.58P AD=0.58P PS=2.58U PD=2.58U
* device instance $642 r0 *1 169.77,76.12 nfet
XM$642 SB D1N OUTN vsubs nfet_03v3 L=0.28U W=2U AS=0.58P AD=0.58P PS=2.58U PD=2.58U
* device instance $643 r0 *1 170.63,76.12 nfet
XM$643 OUTN D1N SB vsubs nfet_03v3 L=0.28U W=2U AS=0.58P AD=0.58P PS=2.58U PD=2.58U
* device instance $644 r0 *1 171.49,76.12 nfet
XM$644 SB D1N OUTN vsubs nfet_03v3 L=0.28U W=2U AS=0.58P AD=0.58P PS=2.58U PD=2.58U
* device instance $645 r0 *1 172.35,76.12 nfet
XM$645 OUTN D1N SB vsubs nfet_03v3 L=0.28U W=2U AS=0.58P AD=0.58P PS=2.58U PD=2.58U
* device instance $646 r0 *1 173.21,76.12 nfet
XM$646 SB D1N OUTN vsubs nfet_03v3 L=0.28U W=2U AS=0.58P AD=0.58P PS=2.58U PD=2.58U
* device instance $647 r0 *1 174.07,76.12 nfet
XM$647 OUTN D1N SB vsubs nfet_03v3 L=0.28U W=2U AS=0.58P AD=0.58P PS=2.58U PD=2.58U
* device instance $648 r0 *1 174.93,76.12 nfet
XM$648 SB D1N OUTN vsubs nfet_03v3 L=0.28U W=2U AS=0.58P AD=0.58P PS=2.58U PD=2.58U
* device instance $649 r0 *1 175.79,76.12 nfet
XM$649 OUTN D1N SB vsubs nfet_03v3 L=0.28U W=2U AS=0.58P AD=0.58P PS=2.58U PD=2.58U
* device instance $650 r0 *1 176.65,76.12 nfet
XM$650 SB D1N OUTN vsubs nfet_03v3 L=0.28U W=2U AS=0.58P AD=0.58P PS=2.58U PD=2.58U
* device instance $651 r0 *1 177.51,76.12 nfet
XM$651 OUTN D1N SB vsubs nfet_03v3 L=0.28U W=2U AS=0.58P AD=0.58P PS=2.58U PD=2.58U
* device instance $652 r0 *1 178.37,76.12 nfet
XM$652 SB D1N OUTN vsubs nfet_03v3 L=0.28U W=2U AS=0.58P AD=0.58P PS=2.58U PD=2.58U
* device instance $653 r0 *1 179.23,76.12 nfet
XM$653 OUTN D1N SB vsubs nfet_03v3 L=0.28U W=2U AS=0.58P AD=0.58P PS=2.58U PD=2.58U
* device instance $654 r0 *1 180.09,76.12 nfet
XM$654 SB D1N OUTN vsubs nfet_03v3 L=0.28U W=2U AS=0.58P AD=0.58P PS=2.58U PD=2.58U
* device instance $655 r0 *1 180.95,76.12 nfet
XM$655 OUTN D1N SB vsubs nfet_03v3 L=0.28U W=2U AS=0.58P AD=0.58P PS=2.58U PD=2.58U
* device instance $656 r0 *1 181.81,76.12 nfet
XM$656 SB D1N OUTN vsubs nfet_03v3 L=0.28U W=2U AS=0.58P AD=0.58P PS=2.58U PD=2.58U
* device instance $657 r0 *1 182.67,76.12 nfet
XM$657 OUTN D1N SB vsubs nfet_03v3 L=0.28U W=2U AS=0.58P AD=0.58P PS=2.58U PD=2.58U
* device instance $658 r0 *1 183.53,76.12 nfet
XM$658 SB D1N OUTN vsubs nfet_03v3 L=0.28U W=2U AS=0.58P AD=1P PS=2.58U PD=5U
* device instance $659 r0 *1 35.87,98.76 ppolyf_u
R$659 OUTP TOP 103.25
* device instance $660 r0 *1 106.745,128.76 ppolyf_u
R$660 TOP VDD 46.375
* device instance $661 r0 *1 127.82,128.76 ppolyf_u
R$661 VDD IBIAS 4340
* device instance $662 r0 *1 181.05,98.76 ppolyf_u
R$662 TOP OUTN 103.25
.ENDS tmds_final_mux_extracted
